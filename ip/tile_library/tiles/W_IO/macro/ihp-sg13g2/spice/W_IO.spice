* NGSPICE file created from W_IO.ext - technology: ihp-sg13g2

* Black-box entry subcircuit for sg13g2_fill_1 abstract view
.subckt sg13g2_fill_1 VDD VSS
.ends

* Black-box entry subcircuit for sg13g2_decap_8 abstract view
.subckt sg13g2_decap_8 VDD VSS
.ends

* Black-box entry subcircuit for sg13g2_buf_1 abstract view
.subckt sg13g2_buf_1 A X VDD VSS
.ends

* Black-box entry subcircuit for sg13g2_decap_4 abstract view
.subckt sg13g2_decap_4 VDD VSS
.ends

* Black-box entry subcircuit for sg13g2_fill_2 abstract view
.subckt sg13g2_fill_2 VDD VSS
.ends

* Black-box entry subcircuit for sg13g2_dlhq_1 abstract view
.subckt sg13g2_dlhq_1 D GATE Q VDD VSS
.ends

* Black-box entry subcircuit for sg13g2_o21ai_1 abstract view
.subckt sg13g2_o21ai_1 B1 VDD Y VSS A1 A2
.ends

* Black-box entry subcircuit for sg13g2_mux2_1 abstract view
.subckt sg13g2_mux2_1 A0 A1 S X VDD VSS
.ends

* Black-box entry subcircuit for sg13g2_mux4_1 abstract view
.subckt sg13g2_mux4_1 S0 A0 A1 A2 A3 S1 X VDD VSS
.ends

* Black-box entry subcircuit for sg13g2_buf_2 abstract view
.subckt sg13g2_buf_2 A X VDD VSS
.ends

* Black-box entry subcircuit for sg13g2_a21o_1 abstract view
.subckt sg13g2_a21o_1 A2 A1 B1 X VDD VSS
.ends

* Black-box entry subcircuit for sg13g2_dfrbpq_2 abstract view
.subckt sg13g2_dfrbpq_2 RESET_B VSS VDD D Q CLK
.ends

* Black-box entry subcircuit for sg13g2_buf_8 abstract view
.subckt sg13g2_buf_8 A X VDD VSS
.ends

* Black-box entry subcircuit for sg13g2_a22oi_1 abstract view
.subckt sg13g2_a22oi_1 Y B1 B2 A2 A1 VDD VSS
.ends

* Black-box entry subcircuit for sg13g2_nor2b_1 abstract view
.subckt sg13g2_nor2b_1 A B_N Y VDD VSS
.ends

* Black-box entry subcircuit for sg13g2_a221oi_1 abstract view
.subckt sg13g2_a221oi_1 VDD VSS B2 C1 B1 A1 Y A2
.ends

* Black-box entry subcircuit for sg13g2_tiehi abstract view
.subckt sg13g2_tiehi VDD VSS L_HI
.ends

* Black-box entry subcircuit for sg13g2_nor2_1 abstract view
.subckt sg13g2_nor2_1 A B Y VDD VSS
.ends

* Black-box entry subcircuit for sg13g2_nor3_1 abstract view
.subckt sg13g2_nor3_1 A B C Y VDD VSS
.ends

* Black-box entry subcircuit for sg13g2_a21oi_1 abstract view
.subckt sg13g2_a21oi_1 VSS VDD A1 A2 Y B1
.ends

* Black-box entry subcircuit for sg13g2_nand3_1 abstract view
.subckt sg13g2_nand3_1 B C A Y VDD VSS
.ends

* Black-box entry subcircuit for sg13g2_nand2_1 abstract view
.subckt sg13g2_nand2_1 Y A B VDD VSS
.ends

* Black-box entry subcircuit for sg13g2_inv_1 abstract view
.subckt sg13g2_inv_1 VDD Y A VSS
.ends

* Black-box entry subcircuit for sg13g2_nand2b_1 abstract view
.subckt sg13g2_nand2b_1 Y B A_N VDD VSS
.ends

.subckt W_IO A_I_top A_O_top A_T_top B_I_top B_O_top B_T_top E1BEG[0] E1BEG[1] E1BEG[2]
+ E1BEG[3] E2BEG[0] E2BEG[1] E2BEG[2] E2BEG[3] E2BEG[4] E2BEG[5] E2BEG[6] E2BEG[7]
+ E2BEGb[0] E2BEGb[1] E2BEGb[2] E2BEGb[3] E2BEGb[4] E2BEGb[5] E2BEGb[6] E2BEGb[7]
+ E6BEG[0] E6BEG[10] E6BEG[11] E6BEG[1] E6BEG[2] E6BEG[3] E6BEG[4] E6BEG[5] E6BEG[6]
+ E6BEG[7] E6BEG[8] E6BEG[9] EE4BEG[0] EE4BEG[10] EE4BEG[11] EE4BEG[12] EE4BEG[13]
+ EE4BEG[14] EE4BEG[15] EE4BEG[1] EE4BEG[2] EE4BEG[3] EE4BEG[4] EE4BEG[5] EE4BEG[6]
+ EE4BEG[7] EE4BEG[8] EE4BEG[9] FrameData[0] FrameData[10] FrameData[11] FrameData[12]
+ FrameData[13] FrameData[14] FrameData[15] FrameData[16] FrameData[17] FrameData[18]
+ FrameData[19] FrameData[1] FrameData[20] FrameData[21] FrameData[22] FrameData[23]
+ FrameData[24] FrameData[25] FrameData[26] FrameData[27] FrameData[28] FrameData[29]
+ FrameData[2] FrameData[30] FrameData[31] FrameData[3] FrameData[4] FrameData[5]
+ FrameData[6] FrameData[7] FrameData[8] FrameData[9] FrameData_O[0] FrameData_O[10]
+ FrameData_O[11] FrameData_O[12] FrameData_O[13] FrameData_O[14] FrameData_O[15]
+ FrameData_O[16] FrameData_O[17] FrameData_O[18] FrameData_O[19] FrameData_O[1] FrameData_O[20]
+ FrameData_O[21] FrameData_O[22] FrameData_O[23] FrameData_O[24] FrameData_O[25]
+ FrameData_O[26] FrameData_O[27] FrameData_O[28] FrameData_O[29] FrameData_O[2] FrameData_O[30]
+ FrameData_O[31] FrameData_O[3] FrameData_O[4] FrameData_O[5] FrameData_O[6] FrameData_O[7]
+ FrameData_O[8] FrameData_O[9] FrameStrobe[0] FrameStrobe[10] FrameStrobe[11] FrameStrobe[12]
+ FrameStrobe[13] FrameStrobe[14] FrameStrobe[15] FrameStrobe[16] FrameStrobe[17]
+ FrameStrobe[18] FrameStrobe[19] FrameStrobe[1] FrameStrobe[2] FrameStrobe[3] FrameStrobe[4]
+ FrameStrobe[5] FrameStrobe[6] FrameStrobe[7] FrameStrobe[8] FrameStrobe[9] FrameStrobe_O[0]
+ FrameStrobe_O[10] FrameStrobe_O[11] FrameStrobe_O[12] FrameStrobe_O[13] FrameStrobe_O[14]
+ FrameStrobe_O[15] FrameStrobe_O[16] FrameStrobe_O[17] FrameStrobe_O[18] FrameStrobe_O[19]
+ FrameStrobe_O[1] FrameStrobe_O[2] FrameStrobe_O[3] FrameStrobe_O[4] FrameStrobe_O[5]
+ FrameStrobe_O[6] FrameStrobe_O[7] FrameStrobe_O[8] FrameStrobe_O[9] UserCLK UserCLKo
+ VGND VPWR W1END[0] W1END[1] W1END[2] W1END[3] W2END[0] W2END[1] W2END[2] W2END[3]
+ W2END[4] W2END[5] W2END[6] W2END[7] W2MID[0] W2MID[1] W2MID[2] W2MID[3] W2MID[4]
+ W2MID[5] W2MID[6] W2MID[7] W6END[0] W6END[10] W6END[11] W6END[1] W6END[2] W6END[3]
+ W6END[4] W6END[5] W6END[6] W6END[7] W6END[8] W6END[9] WW4END[0] WW4END[10] WW4END[11]
+ WW4END[12] WW4END[13] WW4END[14] WW4END[15] WW4END[1] WW4END[2] WW4END[3] WW4END[4]
+ WW4END[5] WW4END[6] WW4END[7] WW4END[8] WW4END[9]
XFILLER_45_203 VPWR VGND sg13g2_fill_1
XFILLER_9_126 VPWR VGND sg13g2_decap_8
XFILLER_13_144 VPWR VGND sg13g2_decap_8
X_294_ net31 net182 VPWR VGND sg13g2_buf_1
XFILLER_42_84 VPWR VGND sg13g2_decap_8
XFILLER_54_9 VPWR VGND sg13g2_decap_4
XFILLER_3_12 VPWR VGND sg13g2_decap_8
XFILLER_3_89 VPWR VGND sg13g2_fill_2
XFILLER_8_192 VPWR VGND sg13g2_fill_1
XFILLER_10_147 VPWR VGND sg13g2_decap_8
XFILLER_10_114 VPWR VGND sg13g2_fill_2
XFILLER_12_32 VPWR VGND sg13g2_fill_1
XFILLER_12_54 VPWR VGND sg13g2_fill_1
XFILLER_5_4 VPWR VGND sg13g2_decap_8
XFILLER_37_40 VPWR VGND sg13g2_fill_1
X_346_ Inst_W_IO_switch_matrix.E2BEG1 net111 VPWR VGND sg13g2_buf_1
X_277_ Inst_W_IO_switch_matrix.EE4BEG5 net149 VPWR VGND sg13g2_buf_1
XFILLER_5_151 VPWR VGND sg13g2_decap_8
XFILLER_45_5 VPWR VGND sg13g2_decap_8
X_200_ net31 net46 Inst_W_IO_ConfigMem.Inst_frame1_bit6.Q VPWR VGND sg13g2_dlhq_1
X_062_ Inst_W_IO_ConfigMem.Inst_frame0_bit28.Q VPWR _011_ VGND _008_ _010_ sg13g2_o21ai_1
X_131_ net56 Inst_A_IO_1_bidirectional_frame_config_pass.Q Inst_W_IO_ConfigMem.Inst_frame3_bit23.Q
+ Inst_W_IO_switch_matrix.E1BEG1 VPWR VGND sg13g2_mux2_1
XFILLER_2_154 VPWR VGND sg13g2_decap_8
XFILLER_48_61 VPWR VGND sg13g2_decap_8
XFILLER_0_35 VPWR VGND sg13g2_decap_8
XFILLER_0_57 VPWR VGND sg13g2_decap_8
X_329_ FrameStrobe[9] net205 VPWR VGND sg13g2_buf_1
XFILLER_9_88 VPWR VGND sg13g2_fill_1
XFILLER_49_180 VPWR VGND sg13g2_decap_8
XFILLER_44_19 VPWR VGND sg13g2_decap_8
XFILLER_18_53 VPWR VGND sg13g2_decap_8
XFILLER_47_117 VPWR VGND sg13g2_decap_8
XFILLER_34_85 VPWR VGND sg13g2_fill_2
XFILLER_50_84 VPWR VGND sg13g2_decap_8
X_114_ Inst_W_IO_ConfigMem.Inst_frame2_bit22.Q net59 net93 net101 net77 Inst_W_IO_ConfigMem.Inst_frame2_bit23.Q
+ Inst_W_IO_switch_matrix.E2BEGb6 VPWR VGND sg13g2_mux4_1
XFILLER_46_161 VPWR VGND sg13g2_decap_8
XFILLER_52_131 VPWR VGND sg13g2_decap_8
XFILLER_37_194 VPWR VGND sg13g2_decap_8
XFILLER_20_21 VPWR VGND sg13g2_decap_4
XFILLER_29_96 VPWR VGND sg13g2_decap_4
XFILLER_28_172 VPWR VGND sg13g2_decap_8
XFILLER_43_131 VPWR VGND sg13g2_decap_8
XFILLER_45_40 VPWR VGND sg13g2_decap_8
XFILLER_34_142 VPWR VGND sg13g2_decap_8
XFILLER_25_197 VPWR VGND sg13g2_decap_8
XFILLER_40_112 VPWR VGND sg13g2_decap_8
XFILLER_40_189 VPWR VGND sg13g2_decap_8
Xoutput86 net104 B_I_top VPWR VGND sg13g2_buf_1
Xoutput97 net115 E2BEG[5] VPWR VGND sg13g2_buf_1
XFILLER_16_175 VPWR VGND sg13g2_decap_8
XFILLER_31_156 VPWR VGND sg13g2_decap_8
XFILLER_52_19 VPWR VGND sg13g2_decap_8
XFILLER_22_112 VPWR VGND sg13g2_fill_2
XFILLER_22_156 VPWR VGND sg13g2_fill_1
XFILLER_22_189 VPWR VGND sg13g2_decap_8
XFILLER_26_53 VPWR VGND sg13g2_decap_4
X_362_ Inst_W_IO_switch_matrix.E6BEG1 net129 VPWR VGND sg13g2_buf_1
XFILLER_26_75 VPWR VGND sg13g2_fill_2
X_293_ net30 net181 VPWR VGND sg13g2_buf_2
XFILLER_42_63 VPWR VGND sg13g2_decap_8
XFILLER_3_68 VPWR VGND sg13g2_decap_8
XFILLER_8_171 VPWR VGND sg13g2_decap_8
XFILLER_47_19 VPWR VGND sg13g2_decap_8
XFILLER_6_119 VPWR VGND sg13g2_decap_8
XFILLER_37_52 VPWR VGND sg13g2_fill_2
XFILLER_37_96 VPWR VGND sg13g2_decap_4
XFILLER_53_95 VPWR VGND sg13g2_fill_2
XFILLER_53_84 VPWR VGND sg13g2_decap_8
X_276_ Inst_W_IO_switch_matrix.EE4BEG4 net148 VPWR VGND sg13g2_buf_1
X_345_ Inst_W_IO_switch_matrix.E2BEG0 net110 VPWR VGND sg13g2_buf_1
XFILLER_5_130 VPWR VGND sg13g2_decap_8
XFILLER_23_21 VPWR VGND sg13g2_fill_2
X_130_ net37 net2 Inst_W_IO_ConfigMem.Inst_frame3_bit24.Q Inst_W_IO_switch_matrix.E1BEG2
+ VPWR VGND sg13g2_mux2_1
X_061_ _009_ Inst_W_IO_ConfigMem.Inst_frame0_bit26.Q _000_ _010_ VPWR VGND sg13g2_a21o_1
XFILLER_2_133 VPWR VGND sg13g2_decap_8
XFILLER_48_40 VPWR VGND sg13g2_decap_8
XFILLER_0_14 VPWR VGND sg13g2_decap_8
X_328_ FrameStrobe[8] net204 VPWR VGND sg13g2_buf_2
X_259_ net208 VGND VPWR net2 Inst_B_IO_1_bidirectional_frame_config_pass.Q clknet_1_1__leaf_UserCLK_regs
+ sg13g2_dfrbpq_2
X_113_ Inst_W_IO_ConfigMem.Inst_frame2_bit24.Q net58 net86 net100 net74 Inst_W_IO_ConfigMem.Inst_frame2_bit25.Q
+ Inst_W_IO_switch_matrix.E2BEGb7 VPWR VGND sg13g2_mux4_1
XFILLER_50_63 VPWR VGND sg13g2_decap_8
XFILLER_46_140 VPWR VGND sg13g2_decap_8
XFILLER_52_110 VPWR VGND sg13g2_decap_8
XFILLER_37_173 VPWR VGND sg13g2_decap_8
XFILLER_52_187 VPWR VGND sg13g2_decap_8
XFILLER_29_75 VPWR VGND sg13g2_decap_4
XFILLER_43_110 VPWR VGND sg13g2_decap_8
XFILLER_43_187 VPWR VGND sg13g2_decap_8
XFILLER_45_96 VPWR VGND sg13g2_decap_8
XFILLER_6_57 VPWR VGND sg13g2_fill_2
XFILLER_34_198 VPWR VGND sg13g2_decap_4
XFILLER_25_176 VPWR VGND sg13g2_decap_8
XFILLER_31_43 VPWR VGND sg13g2_fill_2
XFILLER_40_168 VPWR VGND sg13g2_decap_8
Xoutput87 net105 B_T_top VPWR VGND sg13g2_buf_1
Xoutput98 net116 E2BEG[6] VPWR VGND sg13g2_buf_1
XFILLER_16_154 VPWR VGND sg13g2_decap_8
XFILLER_31_135 VPWR VGND sg13g2_decap_8
XFILLER_39_202 VPWR VGND sg13g2_fill_2
XFILLER_22_168 VPWR VGND sg13g2_decap_8
X_292_ net29 net180 VPWR VGND sg13g2_buf_2
XFILLER_13_179 VPWR VGND sg13g2_decap_8
XFILLER_26_98 VPWR VGND sg13g2_decap_8
X_361_ Inst_W_IO_switch_matrix.E6BEG0 net126 VPWR VGND sg13g2_buf_1
XFILLER_42_42 VPWR VGND sg13g2_decap_8
XFILLER_3_47 VPWR VGND sg13g2_decap_8
XFILLER_8_150 VPWR VGND sg13g2_decap_8
XFILLER_12_12 VPWR VGND sg13g2_fill_1
XFILLER_12_78 VPWR VGND sg13g2_fill_2
XFILLER_53_63 VPWR VGND sg13g2_decap_8
X_344_ Inst_W_IO_switch_matrix.E1BEG3 net109 VPWR VGND sg13g2_buf_1
X_275_ Inst_W_IO_switch_matrix.EE4BEG3 net147 VPWR VGND sg13g2_buf_1
XFILLER_5_186 VPWR VGND sg13g2_decap_8
XFILLER_2_112 VPWR VGND sg13g2_decap_8
X_060_ net64 net65 Inst_W_IO_ConfigMem.Inst_frame0_bit25.Q _009_ VPWR VGND sg13g2_mux2_1
XFILLER_2_189 VPWR VGND sg13g2_decap_8
XFILLER_48_96 VPWR VGND sg13g2_decap_8
X_327_ FrameStrobe[7] net203 VPWR VGND sg13g2_buf_1
X_189_ net22 net42 Inst_W_IO_ConfigMem.Inst_frame2_bit27.Q VPWR VGND sg13g2_dlhq_1
X_258_ net207 VGND VPWR net1 Inst_A_IO_1_bidirectional_frame_config_pass.Q clknet_1_0__leaf_UserCLK_regs
+ sg13g2_dfrbpq_2
XFILLER_50_42 VPWR VGND sg13g2_decap_8
XFILLER_34_65 VPWR VGND sg13g2_fill_2
X_112_ Inst_W_IO_ConfigMem.Inst_frame2_bit27.Q net74 net80 net78 net1 Inst_W_IO_ConfigMem.Inst_frame2_bit26.Q
+ Inst_W_IO_switch_matrix.EE4BEG0 VPWR VGND sg13g2_mux4_1
XFILLER_1_0 VPWR VGND sg13g2_decap_8
XFILLER_46_196 VPWR VGND sg13g2_decap_8
XFILLER_34_0 VPWR VGND sg13g2_fill_1
XFILLER_52_166 VPWR VGND sg13g2_decap_8
XFILLER_1_91 VPWR VGND sg13g2_decap_8
XFILLER_37_152 VPWR VGND sg13g2_decap_8
XFILLER_20_56 VPWR VGND sg13g2_decap_8
XFILLER_43_166 VPWR VGND sg13g2_decap_8
XFILLER_45_75 VPWR VGND sg13g2_decap_8
XFILLER_6_14 VPWR VGND sg13g2_decap_4
XFILLER_19_185 VPWR VGND sg13g2_decap_8
XFILLER_34_122 VPWR VGND sg13g2_fill_2
XFILLER_34_177 VPWR VGND sg13g2_decap_8
XFILLER_25_155 VPWR VGND sg13g2_decap_8
XFILLER_40_147 VPWR VGND sg13g2_decap_8
Xoutput88 net106 E1BEG[0] VPWR VGND sg13g2_buf_1
Xoutput99 net117 E2BEG[7] VPWR VGND sg13g2_buf_1
XFILLER_22_147 VPWR VGND sg13g2_decap_8
XFILLER_26_33 VPWR VGND sg13g2_fill_2
XFILLER_13_158 VPWR VGND sg13g2_decap_8
X_360_ Inst_W_IO_switch_matrix.E2BEGb7 net125 VPWR VGND sg13g2_buf_1
XFILLER_21_180 VPWR VGND sg13g2_decap_8
X_291_ net28 net179 VPWR VGND sg13g2_buf_1
XFILLER_42_21 VPWR VGND sg13g2_decap_8
XFILLER_42_98 VPWR VGND sg13g2_decap_8
XFILLER_3_26 VPWR VGND sg13g2_decap_8
XFILLER_53_42 VPWR VGND sg13g2_decap_8
X_343_ Inst_W_IO_switch_matrix.E1BEG2 net108 VPWR VGND sg13g2_buf_1
X_274_ Inst_W_IO_switch_matrix.EE4BEG2 net146 VPWR VGND sg13g2_buf_1
XFILLER_5_165 VPWR VGND sg13g2_decap_8
XFILLER_38_7 VPWR VGND sg13g2_decap_8
XFILLER_4_91 VPWR VGND sg13g2_decap_8
XFILLER_23_23 VPWR VGND sg13g2_fill_1
XFILLER_2_168 VPWR VGND sg13g2_decap_8
XFILLER_48_75 VPWR VGND sg13g2_decap_8
X_326_ FrameStrobe[6] net202 VPWR VGND sg13g2_buf_1
X_257_ net27 net51 Inst_W_IO_ConfigMem.Inst_frame0_bit31.Q VPWR VGND sg13g2_dlhq_1
X_188_ net21 net42 Inst_W_IO_ConfigMem.Inst_frame2_bit26.Q VPWR VGND sg13g2_dlhq_1
XFILLER_36_4 VPWR VGND sg13g2_decap_4
XFILLER_43_5 VPWR VGND sg13g2_decap_8
XFILLER_49_194 VPWR VGND sg13g2_decap_8
XFILLER_18_23 VPWR VGND sg13g2_decap_8
XFILLER_50_98 VPWR VGND sg13g2_decap_8
XFILLER_50_21 VPWR VGND sg13g2_decap_8
X_111_ Inst_W_IO_ConfigMem.Inst_frame2_bit29.Q net82 net75 net84 net2 Inst_W_IO_ConfigMem.Inst_frame2_bit28.Q
+ Inst_W_IO_switch_matrix.EE4BEG1 VPWR VGND sg13g2_mux4_1
XFILLER_38_109 VPWR VGND sg13g2_fill_1
XFILLER_46_175 VPWR VGND sg13g2_decap_8
X_309_ net16 net167 VPWR VGND sg13g2_buf_1
XFILLER_27_0 VPWR VGND sg13g2_fill_1
XFILLER_52_145 VPWR VGND sg13g2_decap_8
XFILLER_1_70 VPWR VGND sg13g2_decap_8
XFILLER_29_11 VPWR VGND sg13g2_fill_2
XFILLER_28_120 VPWR VGND sg13g2_decap_8
XFILLER_28_186 VPWR VGND sg13g2_decap_8
XFILLER_45_54 VPWR VGND sg13g2_decap_8
XFILLER_43_145 VPWR VGND sg13g2_decap_8
XFILLER_19_164 VPWR VGND sg13g2_decap_8
XFILLER_34_156 VPWR VGND sg13g2_decap_8
XFILLER_40_126 VPWR VGND sg13g2_decap_8
Xoutput89 net107 E1BEG[1] VPWR VGND sg13g2_buf_1
XFILLER_16_189 VPWR VGND sg13g2_decap_8
XFILLER_30_181 VPWR VGND sg13g2_decap_8
XFILLER_9_119 VPWR VGND sg13g2_decap_8
XFILLER_13_137 VPWR VGND sg13g2_decap_8
X_290_ net25 net176 VPWR VGND sg13g2_buf_1
XFILLER_42_77 VPWR VGND sg13g2_decap_8
XFILLER_8_185 VPWR VGND sg13g2_decap_8
XFILLER_8_130 VPWR VGND sg13g2_fill_2
XFILLER_12_181 VPWR VGND sg13g2_decap_8
XFILLER_37_11 VPWR VGND sg13g2_decap_8
XFILLER_53_21 VPWR VGND sg13g2_decap_8
X_342_ Inst_W_IO_switch_matrix.E1BEG1 net107 VPWR VGND sg13g2_buf_1
XFILLER_5_144 VPWR VGND sg13g2_decap_8
XFILLER_5_111 VPWR VGND sg13g2_fill_1
X_273_ Inst_W_IO_switch_matrix.EE4BEG1 net145 VPWR VGND sg13g2_buf_1
XFILLER_4_70 VPWR VGND sg13g2_decap_8
XFILLER_3_5 VPWR VGND sg13g2_decap_8
XFILLER_2_147 VPWR VGND sg13g2_decap_8
XFILLER_0_28 VPWR VGND sg13g2_decap_8
XFILLER_48_54 VPWR VGND sg13g2_decap_8
X_325_ FrameStrobe[5] net201 VPWR VGND sg13g2_buf_8
XFILLER_50_7 VPWR VGND sg13g2_decap_8
X_256_ net26 net51 Inst_W_IO_ConfigMem.Inst_frame0_bit30.Q VPWR VGND sg13g2_dlhq_1
X_187_ net20 net39 Inst_W_IO_ConfigMem.Inst_frame2_bit25.Q VPWR VGND sg13g2_dlhq_1
XFILLER_29_4 VPWR VGND sg13g2_fill_2
XFILLER_49_173 VPWR VGND sg13g2_decap_8
X_110_ Inst_W_IO_ConfigMem.Inst_frame2_bit31.Q net77 net81 net79 Inst_A_IO_1_bidirectional_frame_config_pass.Q
+ Inst_W_IO_ConfigMem.Inst_frame2_bit30.Q Inst_W_IO_switch_matrix.EE4BEG2 VPWR VGND
+ sg13g2_mux4_1
XFILLER_34_67 VPWR VGND sg13g2_fill_1
XFILLER_50_77 VPWR VGND sg13g2_decap_8
XFILLER_46_154 VPWR VGND sg13g2_decap_8
X_239_ net7 net53 Inst_W_IO_ConfigMem.Inst_frame0_bit13.Q VPWR VGND sg13g2_dlhq_1
X_308_ net15 net166 VPWR VGND sg13g2_buf_1
XFILLER_52_124 VPWR VGND sg13g2_decap_8
XFILLER_37_187 VPWR VGND sg13g2_decap_8
XFILLER_29_34 VPWR VGND sg13g2_decap_8
XFILLER_28_165 VPWR VGND sg13g2_decap_8
XFILLER_43_124 VPWR VGND sg13g2_decap_8
XFILLER_45_33 VPWR VGND sg13g2_decap_8
XFILLER_34_135 VPWR VGND sg13g2_decap_8
XFILLER_25_113 VPWR VGND sg13g2_decap_4
XFILLER_40_105 VPWR VGND sg13g2_decap_8
XFILLER_16_168 VPWR VGND sg13g2_decap_8
XFILLER_24_190 VPWR VGND sg13g2_decap_8
XFILLER_31_149 VPWR VGND sg13g2_decap_8
XFILLER_11_4 VPWR VGND sg13g2_fill_1
XFILLER_30_160 VPWR VGND sg13g2_decap_8
XFILLER_26_35 VPWR VGND sg13g2_fill_1
XFILLER_26_46 VPWR VGND sg13g2_decap_8
XFILLER_26_57 VPWR VGND sg13g2_fill_1
XFILLER_42_56 VPWR VGND sg13g2_decap_8
XFILLER_12_160 VPWR VGND sg13g2_decap_8
XFILLER_8_164 VPWR VGND sg13g2_decap_8
XFILLER_37_45 VPWR VGND sg13g2_decap_8
XFILLER_53_77 VPWR VGND sg13g2_decap_8
X_341_ Inst_W_IO_switch_matrix.E1BEG0 net106 VPWR VGND sg13g2_buf_1
X_272_ Inst_W_IO_switch_matrix.EE4BEG0 net138 VPWR VGND sg13g2_buf_1
XFILLER_41_200 VPWR VGND sg13g2_decap_4
XFILLER_5_123 VPWR VGND sg13g2_decap_8
XFILLER_23_58 VPWR VGND sg13g2_fill_2
XFILLER_2_126 VPWR VGND sg13g2_decap_8
XFILLER_48_33 VPWR VGND sg13g2_decap_8
X_324_ FrameStrobe[4] net200 VPWR VGND sg13g2_buf_1
X_255_ net24 net51 Inst_W_IO_ConfigMem.Inst_frame0_bit29.Q VPWR VGND sg13g2_dlhq_1
X_186_ net19 net39 Inst_W_IO_ConfigMem.Inst_frame2_bit24.Q VPWR VGND sg13g2_dlhq_1
XFILLER_49_152 VPWR VGND sg13g2_decap_8
XFILLER_50_56 VPWR VGND sg13g2_decap_8
XFILLER_46_133 VPWR VGND sg13g2_decap_8
X_169_ net32 net39 Inst_W_IO_ConfigMem.Inst_frame2_bit7.Q VPWR VGND sg13g2_dlhq_1
X_238_ net6 net53 Inst_W_IO_ConfigMem.Inst_frame0_bit12.Q VPWR VGND sg13g2_dlhq_1
X_307_ net13 net164 VPWR VGND sg13g2_buf_1
XFILLER_52_103 VPWR VGND sg13g2_decap_8
XFILLER_37_166 VPWR VGND sg13g2_decap_8
XFILLER_43_103 VPWR VGND sg13g2_decap_8
XFILLER_45_12 VPWR VGND sg13g2_decap_8
XFILLER_45_89 VPWR VGND sg13g2_decap_8
XFILLER_51_180 VPWR VGND sg13g2_decap_8
XFILLER_19_100 VPWR VGND sg13g2_decap_4
XFILLER_19_199 VPWR VGND sg13g2_fill_1
XFILLER_32_0 VPWR VGND sg13g2_fill_1
XFILLER_25_169 VPWR VGND sg13g2_decap_8
XFILLER_31_36 VPWR VGND sg13g2_decap_8
XFILLER_16_147 VPWR VGND sg13g2_decap_8
XFILLER_15_191 VPWR VGND sg13g2_decap_8
XFILLER_7_93 VPWR VGND sg13g2_fill_2
XFILLER_7_82 VPWR VGND sg13g2_decap_8
XFILLER_7_60 VPWR VGND sg13g2_fill_1
XFILLER_13_106 VPWR VGND sg13g2_fill_1
XFILLER_42_35 VPWR VGND sg13g2_decap_8
XFILLER_21_194 VPWR VGND sg13g2_decap_8
XFILLER_8_143 VPWR VGND sg13g2_decap_8
XFILLER_53_56 VPWR VGND sg13g2_decap_8
X_271_ Inst_W_IO_switch_matrix.E6BEG11 net128 VPWR VGND sg13g2_buf_1
X_340_ clknet_1_0__leaf_UserCLK net206 VPWR VGND sg13g2_buf_1
XFILLER_5_179 VPWR VGND sg13g2_decap_8
XFILLER_5_102 VPWR VGND sg13g2_decap_8
XFILLER_2_105 VPWR VGND sg13g2_decap_8
XFILLER_48_12 VPWR VGND sg13g2_decap_8
XFILLER_48_89 VPWR VGND sg13g2_decap_8
X_254_ net23 net50 Inst_W_IO_ConfigMem.Inst_frame0_bit28.Q VPWR VGND sg13g2_dlhq_1
XFILLER_13_92 VPWR VGND sg13g2_fill_1
X_323_ net38 net199 VPWR VGND sg13g2_buf_1
X_185_ net18 net42 Inst_W_IO_ConfigMem.Inst_frame2_bit23.Q VPWR VGND sg13g2_dlhq_1
XFILLER_1_182 VPWR VGND sg13g2_decap_8
XFILLER_1_193 VPWR VGND sg13g2_fill_2
XFILLER_29_6 VPWR VGND sg13g2_fill_1
XFILLER_49_131 VPWR VGND sg13g2_decap_8
XFILLER_50_35 VPWR VGND sg13g2_decap_8
XFILLER_46_112 VPWR VGND sg13g2_decap_8
X_306_ net12 net163 VPWR VGND sg13g2_buf_1
XFILLER_46_189 VPWR VGND sg13g2_decap_8
X_168_ net31 net40 Inst_W_IO_ConfigMem.Inst_frame2_bit6.Q VPWR VGND sg13g2_dlhq_1
X_237_ net5 net54 Inst_W_IO_ConfigMem.Inst_frame0_bit11.Q VPWR VGND sg13g2_dlhq_1
X_099_ Inst_W_IO_ConfigMem.Inst_frame1_bit21.Q net83 net76 net85 Inst_B_IO_1_bidirectional_frame_config_pass.Q
+ Inst_W_IO_ConfigMem.Inst_frame1_bit20.Q Inst_W_IO_switch_matrix.EE4BEG13 VPWR VGND
+ sg13g2_mux4_1
XFILLER_41_5 VPWR VGND sg13g2_decap_8
XFILLER_52_159 VPWR VGND sg13g2_decap_8
XFILLER_1_84 VPWR VGND sg13g2_decap_8
XFILLER_37_145 VPWR VGND sg13g2_decap_8
XFILLER_20_38 VPWR VGND sg13g2_fill_1
XFILLER_29_69 VPWR VGND sg13g2_fill_2
XFILLER_28_101 VPWR VGND sg13g2_decap_8
XFILLER_43_159 VPWR VGND sg13g2_decap_8
XFILLER_45_68 VPWR VGND sg13g2_decap_8
XFILLER_6_18 VPWR VGND sg13g2_fill_2
XFILLER_3_200 VPWR VGND sg13g2_fill_2
XFILLER_10_82 VPWR VGND sg13g2_fill_2
XFILLER_19_178 VPWR VGND sg13g2_decap_8
XFILLER_25_148 VPWR VGND sg13g2_decap_8
XFILLER_31_118 VPWR VGND sg13g2_decap_8
XFILLER_15_170 VPWR VGND sg13g2_decap_8
XFILLER_30_195 VPWR VGND sg13g2_decap_8
XFILLER_26_15 VPWR VGND sg13g2_fill_1
XFILLER_42_14 VPWR VGND sg13g2_decap_8
XFILLER_21_173 VPWR VGND sg13g2_decap_8
XFILLER_3_19 VPWR VGND sg13g2_decap_8
XFILLER_12_195 VPWR VGND sg13g2_decap_4
XFILLER_53_35 VPWR VGND sg13g2_decap_8
X_270_ Inst_W_IO_switch_matrix.E6BEG10 net127 VPWR VGND sg13g2_buf_1
XFILLER_5_158 VPWR VGND sg13g2_decap_8
XFILLER_32_202 VPWR VGND sg13g2_fill_2
XFILLER_4_84 VPWR VGND sg13g2_decap_8
XFILLER_4_51 VPWR VGND sg13g2_fill_1
XFILLER_4_40 VPWR VGND sg13g2_decap_8
XFILLER_23_202 VPWR VGND sg13g2_fill_2
XFILLER_48_68 VPWR VGND sg13g2_decap_8
X_322_ net44 net198 VPWR VGND sg13g2_buf_1
X_253_ net22 net50 Inst_W_IO_ConfigMem.Inst_frame0_bit27.Q VPWR VGND sg13g2_dlhq_1
Xfanout50 net52 net50 VPWR VGND sg13g2_buf_8
X_184_ net17 net42 Inst_W_IO_ConfigMem.Inst_frame2_bit22.Q VPWR VGND sg13g2_dlhq_1
XFILLER_1_161 VPWR VGND sg13g2_decap_8
XFILLER_49_110 VPWR VGND sg13g2_decap_8
XFILLER_49_187 VPWR VGND sg13g2_decap_8
XFILLER_50_14 VPWR VGND sg13g2_decap_8
XFILLER_46_168 VPWR VGND sg13g2_decap_8
X_305_ net11 net162 VPWR VGND sg13g2_buf_1
X_167_ net30 net39 Inst_W_IO_ConfigMem.Inst_frame2_bit5.Q VPWR VGND sg13g2_dlhq_1
X_098_ Inst_W_IO_ConfigMem.Inst_frame1_bit23.Q net66 net70 net68 net72 Inst_W_IO_ConfigMem.Inst_frame1_bit22.Q
+ Inst_W_IO_switch_matrix.EE4BEG14 VPWR VGND sg13g2_mux4_1
X_236_ net4 net54 Inst_W_IO_ConfigMem.Inst_frame0_bit10.Q VPWR VGND sg13g2_dlhq_1
XFILLER_40_91 VPWR VGND sg13g2_decap_8
XFILLER_52_138 VPWR VGND sg13g2_decap_8
XFILLER_1_63 VPWR VGND sg13g2_decap_8
XFILLER_28_113 VPWR VGND sg13g2_decap_8
XFILLER_28_179 VPWR VGND sg13g2_decap_8
XFILLER_45_47 VPWR VGND sg13g2_decap_8
XFILLER_43_138 VPWR VGND sg13g2_decap_8
XFILLER_19_157 VPWR VGND sg13g2_decap_8
XFILLER_34_149 VPWR VGND sg13g2_decap_8
X_219_ net20 net45 Inst_W_IO_ConfigMem.Inst_frame1_bit25.Q VPWR VGND sg13g2_dlhq_1
XFILLER_42_182 VPWR VGND sg13g2_decap_8
XFILLER_33_182 VPWR VGND sg13g2_decap_8
XFILLER_40_119 VPWR VGND sg13g2_decap_8
XFILLER_21_93 VPWR VGND sg13g2_decap_8
XFILLER_22_108 VPWR VGND sg13g2_decap_4
XFILLER_30_174 VPWR VGND sg13g2_decap_8
XFILLER_21_152 VPWR VGND sg13g2_decap_8
XFILLER_8_178 VPWR VGND sg13g2_decap_8
XFILLER_8_123 VPWR VGND sg13g2_decap_8
XFILLER_12_174 VPWR VGND sg13g2_decap_8
XFILLER_50_203 VPWR VGND sg13g2_fill_1
XFILLER_53_14 VPWR VGND sg13g2_decap_8
XFILLER_5_137 VPWR VGND sg13g2_decap_8
XFILLER_17_200 VPWR VGND sg13g2_fill_2
XFILLER_4_63 VPWR VGND sg13g2_decap_8
XFILLER_48_47 VPWR VGND sg13g2_decap_8
X_252_ net21 net50 Inst_W_IO_ConfigMem.Inst_frame0_bit26.Q VPWR VGND sg13g2_dlhq_1
Xfanout51 net52 net51 VPWR VGND sg13g2_buf_1
XFILLER_14_203 VPWR VGND sg13g2_fill_1
Xfanout40 net41 net40 VPWR VGND sg13g2_buf_8
X_321_ net49 net197 VPWR VGND sg13g2_buf_1
X_183_ net16 net40 Inst_W_IO_ConfigMem.Inst_frame2_bit21.Q VPWR VGND sg13g2_dlhq_1
XFILLER_1_140 VPWR VGND sg13g2_decap_8
XFILLER_49_166 VPWR VGND sg13g2_decap_8
XFILLER_46_147 VPWR VGND sg13g2_decap_8
X_235_ net34 net53 Inst_W_IO_ConfigMem.Inst_frame0_bit9.Q VPWR VGND sg13g2_dlhq_1
X_304_ net10 net161 VPWR VGND sg13g2_buf_1
X_097_ Inst_W_IO_ConfigMem.Inst_frame1_bit25.Q net67 net71 net69 net73 Inst_W_IO_ConfigMem.Inst_frame1_bit24.Q
+ Inst_W_IO_switch_matrix.EE4BEG15 VPWR VGND sg13g2_mux4_1
X_166_ net29 net39 Inst_W_IO_ConfigMem.Inst_frame2_bit4.Q VPWR VGND sg13g2_dlhq_1
XFILLER_1_42 VPWR VGND sg13g2_decap_8
XFILLER_52_117 VPWR VGND sg13g2_decap_8
XFILLER_45_180 VPWR VGND sg13g2_decap_8
XFILLER_28_158 VPWR VGND sg13g2_decap_8
XFILLER_43_117 VPWR VGND sg13g2_decap_8
XFILLER_45_26 VPWR VGND sg13g2_decap_8
XFILLER_51_194 VPWR VGND sg13g2_decap_8
XFILLER_19_93 VPWR VGND sg13g2_decap_8
XFILLER_34_128 VPWR VGND sg13g2_decap_8
XFILLER_42_161 VPWR VGND sg13g2_decap_8
X_149_ Inst_W_IO_ConfigMem.Inst_frame0_bit31.Q VPWR _047_ VGND net64 Inst_W_IO_ConfigMem.Inst_frame0_bit30.Q
+ sg13g2_o21ai_1
X_218_ net19 net45 Inst_W_IO_ConfigMem.Inst_frame1_bit24.Q VPWR VGND sg13g2_dlhq_1
XFILLER_25_117 VPWR VGND sg13g2_fill_1
XFILLER_33_161 VPWR VGND sg13g2_decap_8
XFILLER_24_183 VPWR VGND sg13g2_decap_8
XFILLER_21_72 VPWR VGND sg13g2_decap_8
XFILLER_30_153 VPWR VGND sg13g2_decap_8
XFILLER_46_91 VPWR VGND sg13g2_decap_8
XFILLER_7_30 VPWR VGND sg13g2_fill_2
XFILLER_30_0 VPWR VGND sg13g2_decap_4
XFILLER_42_49 VPWR VGND sg13g2_decap_8
XFILLER_12_153 VPWR VGND sg13g2_decap_8
XFILLER_8_157 VPWR VGND sg13g2_decap_8
XFILLER_26_201 VPWR VGND sg13g2_fill_2
XFILLER_5_116 VPWR VGND sg13g2_decap_8
XFILLER_4_182 VPWR VGND sg13g2_decap_8
XFILLER_2_119 VPWR VGND sg13g2_decap_8
XFILLER_48_26 VPWR VGND sg13g2_decap_8
X_251_ net20 net50 Inst_W_IO_ConfigMem.Inst_frame0_bit25.Q VPWR VGND sg13g2_dlhq_1
X_320_ net55 net186 VPWR VGND sg13g2_buf_1
Xfanout52 net55 net52 VPWR VGND sg13g2_buf_8
X_182_ net15 net40 Inst_W_IO_ConfigMem.Inst_frame2_bit20.Q VPWR VGND sg13g2_dlhq_1
Xfanout41 net44 net41 VPWR VGND sg13g2_buf_8
XFILLER_49_145 VPWR VGND sg13g2_decap_8
XFILLER_50_49 VPWR VGND sg13g2_decap_8
XFILLER_1_7 VPWR VGND sg13g2_decap_8
XFILLER_46_126 VPWR VGND sg13g2_decap_8
XFILLER_6_200 VPWR VGND sg13g2_fill_2
X_234_ net33 net53 Inst_W_IO_ConfigMem.Inst_frame0_bit8.Q VPWR VGND sg13g2_dlhq_1
XFILLER_24_61 VPWR VGND sg13g2_fill_2
X_165_ net28 net41 Inst_W_IO_ConfigMem.Inst_frame2_bit3.Q VPWR VGND sg13g2_dlhq_1
X_303_ net9 net160 VPWR VGND sg13g2_buf_1
X_096_ Inst_W_IO_ConfigMem.Inst_frame1_bit26.Q net56 net88 net76 net1 Inst_W_IO_ConfigMem.Inst_frame1_bit27.Q
+ Inst_W_IO_switch_matrix.E6BEG0 VPWR VGND sg13g2_mux4_1
XFILLER_40_71 VPWR VGND sg13g2_fill_2
XFILLER_1_21 VPWR VGND sg13g2_decap_8
XFILLER_1_98 VPWR VGND sg13g2_decap_8
XFILLER_37_159 VPWR VGND sg13g2_decap_8
XFILLER_51_173 VPWR VGND sg13g2_decap_8
XFILLER_19_61 VPWR VGND sg13g2_decap_4
XFILLER_19_104 VPWR VGND sg13g2_fill_2
XFILLER_27_181 VPWR VGND sg13g2_decap_8
XFILLER_42_140 VPWR VGND sg13g2_decap_8
X_148_ _046_ _003_ _045_ Inst_W_IO_ConfigMem.Inst_frame0_bit30.Q net62 VPWR VGND sg13g2_a22oi_1
X_217_ net18 net45 Inst_W_IO_ConfigMem.Inst_frame1_bit23.Q VPWR VGND sg13g2_dlhq_1
X_079_ net66 net67 Inst_W_IO_ConfigMem.Inst_frame0_bit18.Q _027_ VPWR VGND sg13g2_mux2_1
XFILLER_33_140 VPWR VGND sg13g2_decap_8
XFILLER_24_162 VPWR VGND sg13g2_decap_8
XFILLER_21_40 VPWR VGND sg13g2_fill_1
XFILLER_46_70 VPWR VGND sg13g2_decap_8
XFILLER_15_184 VPWR VGND sg13g2_decap_8
XFILLER_21_187 VPWR VGND sg13g2_decap_8
XFILLER_42_28 VPWR VGND sg13g2_decap_8
XFILLER_8_136 VPWR VGND sg13g2_decap_8
XFILLER_12_132 VPWR VGND sg13g2_decap_8
XFILLER_16_84 VPWR VGND sg13g2_fill_1
XFILLER_53_49 VPWR VGND sg13g2_decap_8
XFILLER_43_82 VPWR VGND sg13g2_decap_8
XFILLER_4_161 VPWR VGND sg13g2_decap_8
XFILLER_4_32 VPWR VGND sg13g2_decap_4
XFILLER_4_98 VPWR VGND sg13g2_decap_8
X_250_ net19 net50 Inst_W_IO_ConfigMem.Inst_frame0_bit24.Q VPWR VGND sg13g2_dlhq_1
X_181_ net13 net40 Inst_W_IO_ConfigMem.Inst_frame2_bit19.Q VPWR VGND sg13g2_dlhq_1
Xfanout53 net55 net53 VPWR VGND sg13g2_buf_8
Xfanout42 net44 net42 VPWR VGND sg13g2_buf_8
XFILLER_1_175 VPWR VGND sg13g2_decap_8
XFILLER_49_124 VPWR VGND sg13g2_decap_8
XFILLER_34_18 VPWR VGND sg13g2_fill_1
XFILLER_50_28 VPWR VGND sg13g2_decap_8
XFILLER_46_105 VPWR VGND sg13g2_decap_8
X_302_ net8 net159 VPWR VGND sg13g2_buf_1
X_164_ net25 net39 Inst_W_IO_ConfigMem.Inst_frame2_bit2.Q VPWR VGND sg13g2_dlhq_1
X_095_ Inst_W_IO_ConfigMem.Inst_frame1_bit28.Q net57 net87 net75 net2 Inst_W_IO_ConfigMem.Inst_frame1_bit29.Q
+ Inst_W_IO_switch_matrix.E6BEG1 VPWR VGND sg13g2_mux4_1
X_233_ net32 net54 Inst_W_IO_ConfigMem.Inst_frame0_bit7.Q VPWR VGND sg13g2_dlhq_1
XFILLER_1_77 VPWR VGND sg13g2_decap_8
XFILLER_53_0 VPWR VGND sg13g2_decap_8
XFILLER_51_152 VPWR VGND sg13g2_decap_8
XFILLER_36_193 VPWR VGND sg13g2_decap_8
XFILLER_27_160 VPWR VGND sg13g2_decap_8
XFILLER_34_108 VPWR VGND sg13g2_decap_4
XFILLER_42_196 VPWR VGND sg13g2_decap_8
XFILLER_51_82 VPWR VGND sg13g2_decap_8
X_147_ Inst_W_IO_ConfigMem.Inst_frame0_bit30.Q net73 _045_ VPWR VGND sg13g2_nor2b_1
X_216_ net17 net45 Inst_W_IO_ConfigMem.Inst_frame1_bit22.Q VPWR VGND sg13g2_dlhq_1
X_078_ net68 net69 Inst_W_IO_ConfigMem.Inst_frame0_bit18.Q _026_ VPWR VGND sg13g2_mux2_1
XFILLER_25_4 VPWR VGND sg13g2_fill_2
XFILLER_18_182 VPWR VGND sg13g2_decap_8
XFILLER_33_196 VPWR VGND sg13g2_decap_8
XFILLER_15_163 VPWR VGND sg13g2_decap_8
XFILLER_30_188 VPWR VGND sg13g2_decap_8
XFILLER_16_0 VPWR VGND sg13g2_fill_1
XFILLER_38_200 VPWR VGND sg13g2_decap_4
XFILLER_21_100 VPWR VGND sg13g2_decap_8
Xclkbuf_1_0__f_UserCLK_regs clknet_0_UserCLK_regs clknet_1_0__leaf_UserCLK_regs VPWR
+ VGND sg13g2_buf_8
XFILLER_21_166 VPWR VGND sg13g2_decap_8
XFILLER_12_188 VPWR VGND sg13g2_decap_8
XFILLER_12_199 VPWR VGND sg13g2_fill_1
XFILLER_26_203 VPWR VGND sg13g2_fill_1
XFILLER_37_18 VPWR VGND sg13g2_fill_1
XFILLER_53_28 VPWR VGND sg13g2_decap_8
XFILLER_43_61 VPWR VGND sg13g2_decap_8
XFILLER_4_140 VPWR VGND sg13g2_decap_8
XFILLER_4_77 VPWR VGND sg13g2_decap_8
XFILLER_4_11 VPWR VGND sg13g2_decap_8
X_180_ net12 net40 Inst_W_IO_ConfigMem.Inst_frame2_bit18.Q VPWR VGND sg13g2_dlhq_1
Xfanout54 net55 net54 VPWR VGND sg13g2_buf_2
Xfanout43 net44 net43 VPWR VGND sg13g2_buf_1
XFILLER_1_154 VPWR VGND sg13g2_decap_8
XFILLER_49_103 VPWR VGND sg13g2_decap_8
XFILLER_54_93 VPWR VGND sg13g2_fill_2
XFILLER_48_180 VPWR VGND sg13g2_decap_8
XFILLER_24_63 VPWR VGND sg13g2_fill_1
X_301_ net7 net158 VPWR VGND sg13g2_buf_1
X_232_ net31 net54 Inst_W_IO_ConfigMem.Inst_frame0_bit6.Q VPWR VGND sg13g2_dlhq_1
X_094_ Inst_W_IO_ConfigMem.Inst_frame1_bit30.Q net99 net92 net83 net1 Inst_W_IO_ConfigMem.Inst_frame1_bit31.Q
+ Inst_W_IO_switch_matrix.E6BEG2 VPWR VGND sg13g2_mux4_1
X_163_ net14 net41 Inst_W_IO_ConfigMem.Inst_frame2_bit1.Q VPWR VGND sg13g2_dlhq_1
XFILLER_40_40 VPWR VGND sg13g2_decap_8
XFILLER_40_51 VPWR VGND sg13g2_fill_2
XFILLER_40_84 VPWR VGND sg13g2_decap_8
XFILLER_49_82 VPWR VGND sg13g2_decap_8
XFILLER_1_56 VPWR VGND sg13g2_decap_8
XFILLER_45_194 VPWR VGND sg13g2_decap_8
XFILLER_46_0 VPWR VGND sg13g2_decap_8
XFILLER_51_131 VPWR VGND sg13g2_decap_8
XFILLER_36_172 VPWR VGND sg13g2_decap_8
XFILLER_51_61 VPWR VGND sg13g2_decap_8
X_215_ net16 net47 Inst_W_IO_ConfigMem.Inst_frame1_bit21.Q VPWR VGND sg13g2_dlhq_1
XFILLER_42_175 VPWR VGND sg13g2_decap_8
X_146_ VPWR VGND net63 Inst_W_IO_ConfigMem.Inst_frame0_bit29.Q _043_ _003_ _044_ _042_
+ sg13g2_a221oi_1
X_077_ Inst_W_IO_ConfigMem.Inst_frame0_bit21.Q VPWR _025_ VGND _022_ _024_ sg13g2_o21ai_1
XFILLER_18_4 VPWR VGND sg13g2_fill_2
XFILLER_18_161 VPWR VGND sg13g2_decap_8
XFILLER_33_175 VPWR VGND sg13g2_decap_8
XFILLER_24_197 VPWR VGND sg13g2_fill_2
XFILLER_21_86 VPWR VGND sg13g2_decap_8
XFILLER_47_201 VPWR VGND sg13g2_fill_2
XFILLER_30_134 VPWR VGND sg13g2_fill_1
XFILLER_30_167 VPWR VGND sg13g2_decap_8
X_129_ net36 Inst_B_IO_1_bidirectional_frame_config_pass.Q Inst_W_IO_ConfigMem.Inst_frame3_bit25.Q
+ Inst_W_IO_switch_matrix.E1BEG3 VPWR VGND sg13g2_mux2_1
X_259__190 VPWR VGND net208 sg13g2_tiehi
Xinput80 WW4END[6] net98 VPWR VGND sg13g2_buf_1
XFILLER_16_42 VPWR VGND sg13g2_fill_1
XFILLER_8_116 VPWR VGND sg13g2_decap_8
XFILLER_12_167 VPWR VGND sg13g2_decap_8
XFILLER_7_182 VPWR VGND sg13g2_decap_8
XFILLER_43_40 VPWR VGND sg13g2_decap_8
XFILLER_4_196 VPWR VGND sg13g2_decap_4
XFILLER_4_56 VPWR VGND sg13g2_decap_8
Xfanout55 FrameStrobe[0] net55 VPWR VGND sg13g2_buf_2
Xfanout44 FrameStrobe[2] net44 VPWR VGND sg13g2_buf_1
XFILLER_1_133 VPWR VGND sg13g2_decap_8
XFILLER_38_73 VPWR VGND sg13g2_fill_2
XFILLER_49_159 VPWR VGND sg13g2_decap_8
XFILLER_54_83 VPWR VGND sg13g2_fill_2
XFILLER_39_181 VPWR VGND sg13g2_decap_8
XFILLER_54_173 VPWR VGND sg13g2_fill_2
X_231_ net30 net52 Inst_W_IO_ConfigMem.Inst_frame0_bit5.Q VPWR VGND sg13g2_dlhq_1
X_162_ net3 net40 Inst_W_IO_ConfigMem.Inst_frame2_bit0.Q VPWR VGND sg13g2_dlhq_1
X_300_ net6 net157 VPWR VGND sg13g2_buf_1
XFILLER_6_0 VPWR VGND sg13g2_decap_8
X_093_ Inst_W_IO_ConfigMem.Inst_frame0_bit0.Q net98 net91 net82 net2 Inst_W_IO_ConfigMem.Inst_frame0_bit1.Q
+ Inst_W_IO_switch_matrix.E6BEG3 VPWR VGND sg13g2_mux4_1
XFILLER_1_35 VPWR VGND sg13g2_decap_8
XFILLER_49_61 VPWR VGND sg13g2_decap_8
XFILLER_45_173 VPWR VGND sg13g2_decap_8
Xinput1 A_O_top net1 VPWR VGND sg13g2_buf_2
XFILLER_36_151 VPWR VGND sg13g2_decap_8
XFILLER_45_19 VPWR VGND sg13g2_decap_8
XFILLER_51_187 VPWR VGND sg13g2_decap_8
XFILLER_51_110 VPWR VGND sg13g2_decap_8
XFILLER_27_195 VPWR VGND sg13g2_decap_8
XFILLER_42_154 VPWR VGND sg13g2_decap_8
XFILLER_51_40 VPWR VGND sg13g2_decap_8
X_145_ Inst_W_IO_ConfigMem.Inst_frame0_bit30.Q _003_ _043_ VPWR VGND sg13g2_nor2_1
X_214_ net15 net47 Inst_W_IO_ConfigMem.Inst_frame1_bit20.Q VPWR VGND sg13g2_dlhq_1
X_076_ _023_ Inst_W_IO_ConfigMem.Inst_frame0_bit19.Q _002_ _024_ VPWR VGND sg13g2_a21o_1
XFILLER_25_6 VPWR VGND sg13g2_fill_1
XFILLER_33_154 VPWR VGND sg13g2_decap_8
XFILLER_24_176 VPWR VGND sg13g2_decap_8
XFILLER_21_65 VPWR VGND sg13g2_decap_8
XFILLER_15_198 VPWR VGND sg13g2_decap_4
XFILLER_30_146 VPWR VGND sg13g2_decap_8
Xclkbuf_1_0__f_UserCLK clknet_0_UserCLK clknet_1_0__leaf_UserCLK VPWR VGND sg13g2_buf_8
XFILLER_46_84 VPWR VGND sg13g2_decap_8
X_128_ Inst_W_IO_ConfigMem.Inst_frame3_bit26.Q net73 net99 net92 net83 Inst_W_IO_ConfigMem.Inst_frame3_bit27.Q
+ Inst_W_IO_switch_matrix.E2BEG0 VPWR VGND sg13g2_mux4_1
XFILLER_7_89 VPWR VGND sg13g2_decap_4
XFILLER_7_56 VPWR VGND sg13g2_decap_4
XFILLER_7_12 VPWR VGND sg13g2_decap_8
X_059_ Inst_W_IO_ConfigMem.Inst_frame0_bit26.Q _006_ _007_ _008_ VPWR VGND sg13g2_nor3_1
XFILLER_30_4 VPWR VGND sg13g2_fill_2
Xinput81 WW4END[7] net99 VPWR VGND sg13g2_buf_1
Xinput70 WW4END[11] net88 VPWR VGND sg13g2_buf_1
XFILLER_29_202 VPWR VGND sg13g2_fill_2
XFILLER_12_146 VPWR VGND sg13g2_decap_8
XFILLER_7_161 VPWR VGND sg13g2_decap_8
XFILLER_5_109 VPWR VGND sg13g2_fill_2
XFILLER_43_96 VPWR VGND sg13g2_decap_8
XFILLER_4_175 VPWR VGND sg13g2_decap_8
XFILLER_48_19 VPWR VGND sg13g2_decap_8
Xfanout45 net46 net45 VPWR VGND sg13g2_buf_2
XFILLER_8_4 VPWR VGND sg13g2_decap_4
XFILLER_1_112 VPWR VGND sg13g2_decap_8
XFILLER_1_189 VPWR VGND sg13g2_decap_4
XFILLER_49_138 VPWR VGND sg13g2_decap_8
XFILLER_54_73 VPWR VGND sg13g2_fill_2
XFILLER_48_5 VPWR VGND sg13g2_decap_8
XFILLER_54_163 VPWR VGND sg13g2_fill_2
XFILLER_39_160 VPWR VGND sg13g2_decap_8
XFILLER_46_119 VPWR VGND sg13g2_decap_8
X_230_ net29 net52 Inst_W_IO_ConfigMem.Inst_frame0_bit4.Q VPWR VGND sg13g2_dlhq_1
X_161_ net27 net38 Inst_W_IO_ConfigMem.Inst_frame3_bit31.Q VPWR VGND sg13g2_dlhq_1
X_092_ Inst_W_IO_ConfigMem.Inst_frame0_bit2.Q net56 net95 net79 net1 Inst_W_IO_ConfigMem.Inst_frame0_bit3.Q
+ Inst_W_IO_switch_matrix.E6BEG4 VPWR VGND sg13g2_mux4_1
XFILLER_40_64 VPWR VGND sg13g2_decap_8
XFILLER_1_14 VPWR VGND sg13g2_decap_8
XFILLER_49_40 VPWR VGND sg13g2_decap_8
XFILLER_45_152 VPWR VGND sg13g2_decap_8
X_359_ Inst_W_IO_switch_matrix.E2BEGb6 net124 VPWR VGND sg13g2_buf_1
Xinput2 B_O_top net2 VPWR VGND sg13g2_buf_2
XFILLER_28_108 VPWR VGND sg13g2_fill_1
XFILLER_36_130 VPWR VGND sg13g2_decap_8
XFILLER_51_166 VPWR VGND sg13g2_decap_8
XFILLER_19_54 VPWR VGND sg13g2_decap_8
XFILLER_19_65 VPWR VGND sg13g2_fill_1
XFILLER_19_87 VPWR VGND sg13g2_fill_2
XFILLER_27_174 VPWR VGND sg13g2_decap_8
XFILLER_42_133 VPWR VGND sg13g2_decap_8
XFILLER_51_96 VPWR VGND sg13g2_decap_8
X_075_ net64 net65 Inst_W_IO_ConfigMem.Inst_frame0_bit18.Q _023_ VPWR VGND sg13g2_mux2_1
X_144_ VGND VPWR _001_ Inst_W_IO_ConfigMem.Inst_frame0_bit30.Q _042_ _041_ sg13g2_a21oi_1
X_213_ net13 net47 Inst_W_IO_ConfigMem.Inst_frame1_bit19.Q VPWR VGND sg13g2_dlhq_1
XFILLER_18_152 VPWR VGND sg13g2_decap_4
XFILLER_18_196 VPWR VGND sg13g2_decap_4
XFILLER_33_133 VPWR VGND sg13g2_decap_8
XFILLER_24_122 VPWR VGND sg13g2_decap_4
XFILLER_24_155 VPWR VGND sg13g2_decap_8
XFILLER_21_11 VPWR VGND sg13g2_decap_4
XFILLER_24_199 VPWR VGND sg13g2_fill_1
Xoutput180 net198 FrameStrobe_O[2] VPWR VGND sg13g2_buf_1
XFILLER_46_63 VPWR VGND sg13g2_decap_8
XFILLER_47_203 VPWR VGND sg13g2_fill_1
XFILLER_15_177 VPWR VGND sg13g2_decap_8
X_058_ net63 Inst_W_IO_ConfigMem.Inst_frame0_bit25.Q _007_ VPWR VGND sg13g2_nor2b_1
X_127_ Inst_W_IO_ConfigMem.Inst_frame3_bit28.Q net72 net98 net91 net82 Inst_W_IO_ConfigMem.Inst_frame3_bit29.Q
+ Inst_W_IO_switch_matrix.E2BEG1 VPWR VGND sg13g2_mux4_1
Xinput82 WW4END[8] net100 VPWR VGND sg13g2_buf_1
Xinput71 WW4END[12] net89 VPWR VGND sg13g2_buf_1
Xinput60 W6END[2] net78 VPWR VGND sg13g2_buf_2
XFILLER_12_125 VPWR VGND sg13g2_decap_8
XFILLER_7_140 VPWR VGND sg13g2_decap_8
XFILLER_11_180 VPWR VGND sg13g2_decap_8
XFILLER_14_0 VPWR VGND sg13g2_fill_2
XFILLER_43_75 VPWR VGND sg13g2_decap_8
XFILLER_4_154 VPWR VGND sg13g2_decap_8
XFILLER_4_47 VPWR VGND sg13g2_decap_4
XFILLER_4_25 VPWR VGND sg13g2_decap_8
Xfanout46 FrameStrobe[1] net46 VPWR VGND sg13g2_buf_8
XFILLER_1_168 VPWR VGND sg13g2_decap_8
XFILLER_38_42 VPWR VGND sg13g2_fill_1
XFILLER_49_117 VPWR VGND sg13g2_decap_8
XFILLER_54_63 VPWR VGND sg13g2_fill_2
XFILLER_48_194 VPWR VGND sg13g2_decap_4
XFILLER_54_153 VPWR VGND sg13g2_fill_2
X_091_ Inst_W_IO_ConfigMem.Inst_frame0_bit4.Q net57 net94 net78 net2 Inst_W_IO_ConfigMem.Inst_frame0_bit5.Q
+ Inst_W_IO_switch_matrix.E6BEG5 VPWR VGND sg13g2_mux4_1
X_160_ net26 net38 Inst_W_IO_ConfigMem.Inst_frame3_bit30.Q VPWR VGND sg13g2_dlhq_1
XFILLER_40_98 VPWR VGND sg13g2_decap_8
Xclkbuf_regs_0_UserCLK UserCLK UserCLK_regs VPWR VGND sg13g2_buf_8
XFILLER_45_131 VPWR VGND sg13g2_decap_8
XFILLER_49_96 VPWR VGND sg13g2_decap_8
X_358_ Inst_W_IO_switch_matrix.E2BEGb5 net123 VPWR VGND sg13g2_buf_1
X_289_ net14 net165 VPWR VGND sg13g2_buf_1
XFILLER_51_145 VPWR VGND sg13g2_decap_8
Xinput3 FrameData[0] net3 VPWR VGND sg13g2_buf_1
XFILLER_36_186 VPWR VGND sg13g2_decap_8
XFILLER_19_11 VPWR VGND sg13g2_decap_4
XFILLER_27_153 VPWR VGND sg13g2_decap_8
X_212_ net12 net47 Inst_W_IO_ConfigMem.Inst_frame1_bit18.Q VPWR VGND sg13g2_dlhq_1
XFILLER_42_112 VPWR VGND sg13g2_decap_8
XFILLER_42_189 VPWR VGND sg13g2_decap_8
XFILLER_51_75 VPWR VGND sg13g2_decap_8
X_074_ Inst_W_IO_ConfigMem.Inst_frame0_bit19.Q _020_ _021_ _022_ VPWR VGND sg13g2_nor3_1
X_143_ net72 Inst_W_IO_ConfigMem.Inst_frame0_bit30.Q _041_ VPWR VGND sg13g2_nor2_1
XFILLER_18_175 VPWR VGND sg13g2_decap_8
XFILLER_33_189 VPWR VGND sg13g2_decap_8
XFILLER_2_91 VPWR VGND sg13g2_decap_8
Xoutput170 net188 FrameStrobe_O[11] VPWR VGND sg13g2_buf_1
Xoutput181 net199 FrameStrobe_O[3] VPWR VGND sg13g2_buf_1
XFILLER_46_42 VPWR VGND sg13g2_decap_8
XFILLER_15_156 VPWR VGND sg13g2_decap_8
X_057_ Inst_W_IO_ConfigMem.Inst_frame0_bit25.Q net62 _006_ VPWR VGND sg13g2_nor2_1
X_126_ Inst_W_IO_ConfigMem.Inst_frame3_bit30.Q net71 net97 net90 net81 Inst_W_IO_ConfigMem.Inst_frame3_bit31.Q
+ Inst_W_IO_switch_matrix.E2BEG2 VPWR VGND sg13g2_mux4_1
XFILLER_53_207 VPWR VGND sg13g2_fill_1
Xinput50 W2MID[2] net68 VPWR VGND sg13g2_buf_2
Xinput72 WW4END[13] net90 VPWR VGND sg13g2_buf_1
Xinput61 W6END[3] net79 VPWR VGND sg13g2_buf_2
XFILLER_21_159 VPWR VGND sg13g2_decap_8
Xinput83 WW4END[9] net101 VPWR VGND sg13g2_buf_1
XFILLER_32_22 VPWR VGND sg13g2_fill_1
XFILLER_32_44 VPWR VGND sg13g2_fill_2
XFILLER_7_196 VPWR VGND sg13g2_decap_4
X_109_ Inst_W_IO_ConfigMem.Inst_frame1_bit1.Q net83 net76 net85 Inst_B_IO_1_bidirectional_frame_config_pass.Q
+ Inst_W_IO_ConfigMem.Inst_frame1_bit0.Q Inst_W_IO_switch_matrix.EE4BEG3 VPWR VGND
+ sg13g2_mux4_1
XFILLER_43_54 VPWR VGND sg13g2_decap_8
XFILLER_4_133 VPWR VGND sg13g2_decap_8
Xfanout47 net49 net47 VPWR VGND sg13g2_buf_8
XFILLER_1_147 VPWR VGND sg13g2_decap_8
XFILLER_38_21 VPWR VGND sg13g2_decap_8
XFILLER_54_53 VPWR VGND sg13g2_fill_2
XFILLER_9_203 VPWR VGND sg13g2_fill_1
XFILLER_48_173 VPWR VGND sg13g2_decap_8
XFILLER_39_195 VPWR VGND sg13g2_decap_8
XFILLER_54_143 VPWR VGND sg13g2_fill_2
X_090_ Inst_W_IO_ConfigMem.Inst_frame0_bit6.Q net37 net101 net85 Inst_A_IO_1_bidirectional_frame_config_pass.Q
+ Inst_W_IO_ConfigMem.Inst_frame0_bit7.Q Inst_W_IO_switch_matrix.E6BEG6 VPWR VGND
+ sg13g2_mux4_1
Xclkbuf_0_UserCLK_regs UserCLK_regs clknet_0_UserCLK_regs VPWR VGND sg13g2_buf_8
XFILLER_40_33 VPWR VGND sg13g2_decap_8
XFILLER_40_77 VPWR VGND sg13g2_decap_8
XFILLER_49_75 VPWR VGND sg13g2_decap_8
XFILLER_1_49 VPWR VGND sg13g2_decap_8
XFILLER_45_110 VPWR VGND sg13g2_decap_8
XFILLER_45_187 VPWR VGND sg13g2_decap_8
X_357_ Inst_W_IO_switch_matrix.E2BEGb4 net122 VPWR VGND sg13g2_buf_1
X_288_ net3 net154 VPWR VGND sg13g2_buf_1
Xinput4 FrameData[10] net4 VPWR VGND sg13g2_buf_1
XFILLER_51_124 VPWR VGND sg13g2_decap_8
XFILLER_36_165 VPWR VGND sg13g2_decap_8
XFILLER_51_54 VPWR VGND sg13g2_decap_8
X_142_ _036_ VPWR net103 VGND _037_ _040_ sg13g2_o21ai_1
X_211_ net11 net48 Inst_W_IO_ConfigMem.Inst_frame1_bit17.Q VPWR VGND sg13g2_dlhq_1
XFILLER_42_168 VPWR VGND sg13g2_decap_8
X_073_ net63 Inst_W_IO_ConfigMem.Inst_frame0_bit18.Q _021_ VPWR VGND sg13g2_nor2b_1
XFILLER_33_168 VPWR VGND sg13g2_decap_8
XFILLER_2_70 VPWR VGND sg13g2_decap_8
XFILLER_21_79 VPWR VGND sg13g2_decap_8
Xoutput171 net189 FrameStrobe_O[12] VPWR VGND sg13g2_buf_1
Xoutput182 net200 FrameStrobe_O[4] VPWR VGND sg13g2_buf_1
Xoutput160 net178 FrameData_O[31] VPWR VGND sg13g2_buf_1
XFILLER_46_21 VPWR VGND sg13g2_decap_8
XFILLER_46_98 VPWR VGND sg13g2_decap_8
XFILLER_7_26 VPWR VGND sg13g2_decap_4
X_125_ Inst_W_IO_ConfigMem.Inst_frame2_bit0.Q net70 net96 net89 net80 Inst_W_IO_ConfigMem.Inst_frame2_bit1.Q
+ Inst_W_IO_switch_matrix.E2BEG3 VPWR VGND sg13g2_mux4_1
X_056_ Inst_W_IO_ConfigMem.Inst_frame0_bit27.Q _004_ _005_ VPWR VGND sg13g2_nor2_1
Xinput40 W2END[0] net58 VPWR VGND sg13g2_buf_2
Xinput51 W2MID[3] net69 VPWR VGND sg13g2_buf_2
Xinput73 WW4END[14] net91 VPWR VGND sg13g2_buf_1
Xinput62 W6END[4] net80 VPWR VGND sg13g2_buf_2
XFILLER_16_35 VPWR VGND sg13g2_fill_2
XFILLER_8_109 VPWR VGND sg13g2_decap_8
XFILLER_20_182 VPWR VGND sg13g2_decap_8
X_108_ Inst_W_IO_ConfigMem.Inst_frame1_bit2.Q net58 net60 net62 net64 Inst_W_IO_ConfigMem.Inst_frame1_bit3.Q
+ Inst_W_IO_switch_matrix.EE4BEG4 VPWR VGND sg13g2_mux4_1
XFILLER_7_175 VPWR VGND sg13g2_decap_8
XFILLER_14_2 VPWR VGND sg13g2_fill_1
XFILLER_43_33 VPWR VGND sg13g2_decap_8
XFILLER_4_112 VPWR VGND sg13g2_decap_8
XFILLER_4_189 VPWR VGND sg13g2_decap_8
Xfanout48 net49 net48 VPWR VGND sg13g2_buf_2
XFILLER_1_126 VPWR VGND sg13g2_decap_8
XFILLER_54_43 VPWR VGND sg13g2_fill_2
XFILLER_13_200 VPWR VGND sg13g2_decap_4
XFILLER_48_152 VPWR VGND sg13g2_decap_8
XFILLER_5_81 VPWR VGND sg13g2_decap_8
XFILLER_54_133 VPWR VGND sg13g2_fill_2
XFILLER_39_174 VPWR VGND sg13g2_decap_8
XFILLER_54_199 VPWR VGND sg13g2_fill_1
XFILLER_40_12 VPWR VGND sg13g2_decap_8
XFILLER_1_28 VPWR VGND sg13g2_decap_8
XFILLER_49_54 VPWR VGND sg13g2_decap_8
XFILLER_45_166 VPWR VGND sg13g2_decap_8
X_287_ Inst_W_IO_switch_matrix.EE4BEG15 net144 VPWR VGND sg13g2_buf_1
X_356_ Inst_W_IO_switch_matrix.E2BEGb3 net121 VPWR VGND sg13g2_buf_1
XFILLER_39_4 VPWR VGND sg13g2_decap_8
Xinput5 FrameData[11] net5 VPWR VGND sg13g2_buf_1
XFILLER_36_144 VPWR VGND sg13g2_decap_8
XFILLER_51_103 VPWR VGND sg13g2_decap_8
XFILLER_27_188 VPWR VGND sg13g2_decap_8
XFILLER_51_33 VPWR VGND sg13g2_decap_8
X_141_ _038_ _039_ Inst_W_IO_ConfigMem.Inst_frame0_bit22.Q _040_ VPWR VGND sg13g2_nand3_1
X_210_ net10 net48 Inst_W_IO_ConfigMem.Inst_frame1_bit16.Q VPWR VGND sg13g2_dlhq_1
XFILLER_42_147 VPWR VGND sg13g2_decap_8
X_072_ net62 Inst_W_IO_ConfigMem.Inst_frame0_bit18.Q _020_ VPWR VGND sg13g2_nor2_1
XFILLER_18_122 VPWR VGND sg13g2_fill_1
XFILLER_18_144 VPWR VGND sg13g2_decap_4
XFILLER_33_147 VPWR VGND sg13g2_decap_8
X_339_ FrameStrobe[19] net196 VPWR VGND sg13g2_buf_1
XFILLER_24_169 VPWR VGND sg13g2_decap_8
Xoutput150 net168 FrameData_O[22] VPWR VGND sg13g2_buf_1
XFILLER_21_58 VPWR VGND sg13g2_decap_8
Xoutput161 net179 FrameData_O[3] VPWR VGND sg13g2_buf_1
Xoutput172 net190 FrameStrobe_O[13] VPWR VGND sg13g2_buf_1
Xoutput183 net201 FrameStrobe_O[5] VPWR VGND sg13g2_buf_1
XFILLER_46_77 VPWR VGND sg13g2_decap_8
XFILLER_7_49 VPWR VGND sg13g2_decap_8
X_055_ Inst_W_IO_ConfigMem.Inst_frame0_bit25.Q net58 net59 net60 net61 Inst_W_IO_ConfigMem.Inst_frame0_bit26.Q
+ _004_ VPWR VGND sg13g2_mux4_1
X_124_ Inst_W_IO_ConfigMem.Inst_frame2_bit2.Q net69 net95 net88 net79 Inst_W_IO_ConfigMem.Inst_frame2_bit3.Q
+ Inst_W_IO_switch_matrix.E2BEG4 VPWR VGND sg13g2_mux4_1
XFILLER_23_191 VPWR VGND sg13g2_decap_8
XFILLER_30_139 VPWR VGND sg13g2_decap_8
Xinput41 W2END[1] net59 VPWR VGND sg13g2_buf_2
Xinput52 W2MID[4] net70 VPWR VGND sg13g2_buf_2
Xinput74 WW4END[15] net92 VPWR VGND sg13g2_buf_1
Xinput30 FrameData[5] net30 VPWR VGND sg13g2_buf_1
Xinput63 W6END[5] net81 VPWR VGND sg13g2_buf_2
XFILLER_12_139 VPWR VGND sg13g2_decap_8
XFILLER_20_161 VPWR VGND sg13g2_decap_8
X_107_ Inst_W_IO_ConfigMem.Inst_frame1_bit4.Q net59 net61 net63 net65 Inst_W_IO_ConfigMem.Inst_frame1_bit5.Q
+ Inst_W_IO_switch_matrix.EE4BEG5 VPWR VGND sg13g2_mux4_1
XFILLER_7_154 VPWR VGND sg13g2_decap_8
XFILLER_7_121 VPWR VGND sg13g2_fill_1
XFILLER_11_194 VPWR VGND sg13g2_decap_4
XFILLER_21_4 VPWR VGND sg13g2_decap_8
XFILLER_27_57 VPWR VGND sg13g2_fill_2
XFILLER_43_12 VPWR VGND sg13g2_decap_8
XFILLER_43_89 VPWR VGND sg13g2_decap_8
XFILLER_4_168 VPWR VGND sg13g2_decap_8
Xfanout49 FrameStrobe[1] net49 VPWR VGND sg13g2_buf_2
Xfanout38 net35 net38 VPWR VGND sg13g2_buf_8
XFILLER_1_105 VPWR VGND sg13g2_decap_8
XFILLER_54_33 VPWR VGND sg13g2_fill_2
XFILLER_54_99 VPWR VGND sg13g2_decap_4
XFILLER_48_131 VPWR VGND sg13g2_decap_8
XFILLER_5_60 VPWR VGND sg13g2_decap_8
XFILLER_54_123 VPWR VGND sg13g2_fill_2
XFILLER_39_153 VPWR VGND sg13g2_decap_8
XFILLER_54_189 VPWR VGND sg13g2_fill_2
XFILLER_40_57 VPWR VGND sg13g2_decap_8
XFILLER_49_33 VPWR VGND sg13g2_decap_8
XFILLER_45_145 VPWR VGND sg13g2_decap_8
X_286_ Inst_W_IO_switch_matrix.EE4BEG14 net143 VPWR VGND sg13g2_buf_1
X_355_ Inst_W_IO_switch_matrix.E2BEGb2 net120 VPWR VGND sg13g2_buf_1
XFILLER_53_7 VPWR VGND sg13g2_decap_8
Xinput6 FrameData[12] net6 VPWR VGND sg13g2_buf_1
XFILLER_36_101 VPWR VGND sg13g2_fill_1
XFILLER_51_159 VPWR VGND sg13g2_decap_8
XFILLER_27_167 VPWR VGND sg13g2_decap_8
XFILLER_35_46 VPWR VGND sg13g2_fill_2
XFILLER_42_126 VPWR VGND sg13g2_decap_8
XFILLER_51_89 VPWR VGND sg13g2_decap_8
XFILLER_51_12 VPWR VGND sg13g2_decap_8
X_140_ _039_ net62 Inst_W_IO_ConfigMem.Inst_frame0_bit24.Q VPWR VGND sg13g2_nand2_1
X_071_ Inst_W_IO_ConfigMem.Inst_frame0_bit20.Q _018_ _019_ VPWR VGND sg13g2_nor2_1
XFILLER_18_156 VPWR VGND sg13g2_fill_1
X_338_ FrameStrobe[18] net195 VPWR VGND sg13g2_buf_1
XFILLER_18_189 VPWR VGND sg13g2_decap_8
X_269_ Inst_W_IO_switch_matrix.E6BEG9 net137 VPWR VGND sg13g2_buf_1
XFILLER_24_115 VPWR VGND sg13g2_decap_8
Xclkbuf_1_1__f_UserCLK_regs clknet_0_UserCLK_regs clknet_1_1__leaf_UserCLK_regs VPWR
+ VGND sg13g2_buf_8
XFILLER_32_181 VPWR VGND sg13g2_decap_8
Xoutput173 net191 FrameStrobe_O[14] VPWR VGND sg13g2_buf_1
Xoutput184 net202 FrameStrobe_O[6] VPWR VGND sg13g2_buf_1
Xoutput151 net169 FrameData_O[23] VPWR VGND sg13g2_buf_1
Xoutput162 net180 FrameData_O[4] VPWR VGND sg13g2_buf_1
Xoutput140 net158 FrameData_O[13] VPWR VGND sg13g2_buf_1
XFILLER_46_56 VPWR VGND sg13g2_decap_8
XFILLER_23_170 VPWR VGND sg13g2_decap_8
X_054_ VPWR _003_ Inst_W_IO_ConfigMem.Inst_frame0_bit31.Q VGND sg13g2_inv_1
X_123_ Inst_W_IO_ConfigMem.Inst_frame2_bit4.Q net68 net94 net87 net78 Inst_W_IO_ConfigMem.Inst_frame2_bit5.Q
+ Inst_W_IO_switch_matrix.E2BEG5 VPWR VGND sg13g2_mux4_1
XFILLER_14_192 VPWR VGND sg13g2_decap_8
Xinput31 FrameData[6] net31 VPWR VGND sg13g2_buf_1
XFILLER_21_107 VPWR VGND sg13g2_fill_2
Xinput20 FrameData[25] net20 VPWR VGND sg13g2_buf_2
Xinput75 WW4END[1] net93 VPWR VGND sg13g2_buf_2
Xinput42 W2END[2] net60 VPWR VGND sg13g2_buf_2
Xinput53 W2MID[5] net71 VPWR VGND sg13g2_buf_2
Xinput64 W6END[6] net82 VPWR VGND sg13g2_buf_2
XFILLER_42_0 VPWR VGND sg13g2_decap_8
XFILLER_12_118 VPWR VGND sg13g2_decap_8
XFILLER_16_37 VPWR VGND sg13g2_fill_1
XFILLER_11_173 VPWR VGND sg13g2_decap_8
XFILLER_7_133 VPWR VGND sg13g2_decap_8
X_106_ Inst_W_IO_ConfigMem.Inst_frame1_bit7.Q net66 net70 net68 net72 Inst_W_IO_ConfigMem.Inst_frame1_bit6.Q
+ Inst_W_IO_switch_matrix.EE4BEG6 VPWR VGND sg13g2_mux4_1
XFILLER_43_68 VPWR VGND sg13g2_decap_8
XFILLER_4_147 VPWR VGND sg13g2_decap_8
XFILLER_4_18 VPWR VGND sg13g2_decap_8
XFILLER_31_202 VPWR VGND sg13g2_fill_2
Xfanout39 net40 net39 VPWR VGND sg13g2_buf_8
XFILLER_38_35 VPWR VGND sg13g2_decap_8
XFILLER_54_89 VPWR VGND sg13g2_decap_4
XFILLER_54_23 VPWR VGND sg13g2_fill_2
XFILLER_0_183 VPWR VGND sg13g2_decap_4
XFILLER_48_110 VPWR VGND sg13g2_decap_8
XFILLER_48_187 VPWR VGND sg13g2_decap_8
XFILLER_48_198 VPWR VGND sg13g2_fill_2
XFILLER_39_132 VPWR VGND sg13g2_decap_8
XFILLER_54_179 VPWR VGND sg13g2_fill_2
XFILLER_54_113 VPWR VGND sg13g2_fill_2
XFILLER_40_47 VPWR VGND sg13g2_decap_4
XFILLER_49_12 VPWR VGND sg13g2_decap_8
XFILLER_45_124 VPWR VGND sg13g2_decap_8
XFILLER_49_89 VPWR VGND sg13g2_decap_8
X_354_ Inst_W_IO_switch_matrix.E2BEGb1 net119 VPWR VGND sg13g2_buf_1
X_285_ Inst_W_IO_switch_matrix.EE4BEG13 net142 VPWR VGND sg13g2_buf_1
XFILLER_46_7 VPWR VGND sg13g2_decap_8
Xinput7 FrameData[13] net7 VPWR VGND sg13g2_buf_1
XFILLER_36_179 VPWR VGND sg13g2_decap_8
XFILLER_51_138 VPWR VGND sg13g2_decap_8
XFILLER_19_15 VPWR VGND sg13g2_fill_1
XFILLER_35_190 VPWR VGND sg13g2_decap_8
XFILLER_42_105 VPWR VGND sg13g2_decap_8
XFILLER_51_68 VPWR VGND sg13g2_decap_8
XFILLER_50_182 VPWR VGND sg13g2_decap_8
X_070_ Inst_W_IO_ConfigMem.Inst_frame0_bit18.Q net58 net59 net60 net61 Inst_W_IO_ConfigMem.Inst_frame0_bit19.Q
+ _018_ VPWR VGND sg13g2_mux4_1
XFILLER_18_168 VPWR VGND sg13g2_decap_8
X_337_ FrameStrobe[17] net194 VPWR VGND sg13g2_buf_1
XFILLER_41_193 VPWR VGND sg13g2_decap_8
XFILLER_51_5 VPWR VGND sg13g2_decap_8
X_199_ net30 net46 Inst_W_IO_ConfigMem.Inst_frame1_bit5.Q VPWR VGND sg13g2_dlhq_1
X_268_ Inst_W_IO_switch_matrix.E6BEG8 net136 VPWR VGND sg13g2_buf_1
XFILLER_2_84 VPWR VGND sg13g2_decap_8
XFILLER_32_160 VPWR VGND sg13g2_decap_8
Xoutput174 net192 FrameStrobe_O[15] VPWR VGND sg13g2_buf_1
Xoutput185 net203 FrameStrobe_O[7] VPWR VGND sg13g2_buf_1
Xoutput152 net170 FrameData_O[24] VPWR VGND sg13g2_buf_1
Xoutput141 net159 FrameData_O[14] VPWR VGND sg13g2_buf_1
Xoutput130 net148 EE4BEG[4] VPWR VGND sg13g2_buf_1
Xoutput163 net181 FrameData_O[5] VPWR VGND sg13g2_buf_1
XFILLER_46_35 VPWR VGND sg13g2_decap_8
XFILLER_15_149 VPWR VGND sg13g2_decap_8
XFILLER_2_0 VPWR VGND sg13g2_decap_8
X_053_ VPWR _002_ Inst_W_IO_ConfigMem.Inst_frame0_bit20.Q VGND sg13g2_inv_1
X_122_ Inst_W_IO_ConfigMem.Inst_frame2_bit6.Q net67 net93 net101 net77 Inst_W_IO_ConfigMem.Inst_frame2_bit7.Q
+ Inst_W_IO_switch_matrix.E2BEG6 VPWR VGND sg13g2_mux4_1
Xinput43 W2END[3] net61 VPWR VGND sg13g2_buf_2
Xinput54 W2MID[6] net72 VPWR VGND sg13g2_buf_2
XFILLER_14_171 VPWR VGND sg13g2_decap_8
Xinput32 FrameData[7] net32 VPWR VGND sg13g2_buf_1
Xinput10 FrameData[16] net10 VPWR VGND sg13g2_buf_1
Xinput21 FrameData[26] net21 VPWR VGND sg13g2_buf_2
Xinput76 WW4END[2] net94 VPWR VGND sg13g2_buf_1
Xinput65 W6END[7] net83 VPWR VGND sg13g2_buf_2
XFILLER_20_196 VPWR VGND sg13g2_decap_4
XFILLER_11_152 VPWR VGND sg13g2_decap_8
XFILLER_7_112 VPWR VGND sg13g2_decap_8
X_105_ Inst_W_IO_ConfigMem.Inst_frame1_bit9.Q net67 net71 net69 net73 Inst_W_IO_ConfigMem.Inst_frame1_bit8.Q
+ Inst_W_IO_switch_matrix.EE4BEG7 VPWR VGND sg13g2_mux4_1
XFILLER_7_189 VPWR VGND sg13g2_decap_8
XFILLER_27_59 VPWR VGND sg13g2_fill_1
XFILLER_43_47 VPWR VGND sg13g2_decap_8
XFILLER_4_126 VPWR VGND sg13g2_decap_8
XFILLER_16_200 VPWR VGND sg13g2_fill_2
XFILLER_22_203 VPWR VGND sg13g2_fill_1
XFILLER_38_14 VPWR VGND sg13g2_decap_8
XFILLER_54_79 VPWR VGND sg13g2_decap_4
XFILLER_54_13 VPWR VGND sg13g2_fill_2
XFILLER_0_162 VPWR VGND sg13g2_decap_8
XFILLER_48_166 VPWR VGND sg13g2_decap_8
XFILLER_5_95 VPWR VGND sg13g2_decap_8
XFILLER_54_169 VPWR VGND sg13g2_decap_4
XFILLER_54_103 VPWR VGND sg13g2_fill_2
XFILLER_39_188 VPWR VGND sg13g2_decap_8
XFILLER_40_26 VPWR VGND sg13g2_decap_8
XFILLER_6_7 VPWR VGND sg13g2_decap_8
XFILLER_49_68 VPWR VGND sg13g2_decap_8
XFILLER_45_103 VPWR VGND sg13g2_decap_8
X_353_ Inst_W_IO_switch_matrix.E2BEGb0 net118 VPWR VGND sg13g2_buf_1
X_284_ Inst_W_IO_switch_matrix.EE4BEG12 net141 VPWR VGND sg13g2_buf_1
Xinput8 FrameData[14] net8 VPWR VGND sg13g2_buf_1
XFILLER_51_117 VPWR VGND sg13g2_decap_8
XFILLER_36_158 VPWR VGND sg13g2_decap_8
XFILLER_44_180 VPWR VGND sg13g2_decap_8
XFILLER_50_161 VPWR VGND sg13g2_decap_8
XFILLER_35_48 VPWR VGND sg13g2_fill_1
XFILLER_51_47 VPWR VGND sg13g2_decap_8
XFILLER_4_4 VPWR VGND sg13g2_decap_8
XFILLER_18_114 VPWR VGND sg13g2_decap_4
XFILLER_26_180 VPWR VGND sg13g2_decap_8
X_336_ FrameStrobe[16] net193 VPWR VGND sg13g2_buf_1
X_267_ Inst_W_IO_switch_matrix.E6BEG7 net135 VPWR VGND sg13g2_buf_1
XFILLER_41_172 VPWR VGND sg13g2_decap_8
X_198_ net29 net46 Inst_W_IO_ConfigMem.Inst_frame1_bit4.Q VPWR VGND sg13g2_dlhq_1
XFILLER_37_4 VPWR VGND sg13g2_decap_8
XFILLER_44_5 VPWR VGND sg13g2_decap_8
XFILLER_2_63 VPWR VGND sg13g2_decap_8
Xoutput153 net171 FrameData_O[25] VPWR VGND sg13g2_buf_1
Xoutput175 net193 FrameStrobe_O[16] VPWR VGND sg13g2_buf_1
Xoutput186 net204 FrameStrobe_O[8] VPWR VGND sg13g2_buf_1
Xoutput120 net138 EE4BEG[0] VPWR VGND sg13g2_buf_1
Xoutput131 net149 EE4BEG[5] VPWR VGND sg13g2_buf_1
Xoutput164 net182 FrameData_O[6] VPWR VGND sg13g2_buf_1
Xoutput142 net160 FrameData_O[15] VPWR VGND sg13g2_buf_1
XFILLER_15_106 VPWR VGND sg13g2_fill_1
XFILLER_46_14 VPWR VGND sg13g2_decap_8
XFILLER_7_19 VPWR VGND sg13g2_decap_8
X_121_ Inst_W_IO_ConfigMem.Inst_frame2_bit8.Q net66 net86 net100 net74 Inst_W_IO_ConfigMem.Inst_frame2_bit9.Q
+ Inst_W_IO_switch_matrix.E2BEG7 VPWR VGND sg13g2_mux4_1
X_052_ VPWR _001_ net58 VGND sg13g2_inv_1
XFILLER_14_150 VPWR VGND sg13g2_decap_8
XFILLER_21_109 VPWR VGND sg13g2_fill_1
Xinput77 WW4END[3] net95 VPWR VGND sg13g2_buf_1
Xinput44 W2END[4] net62 VPWR VGND sg13g2_buf_2
Xinput55 W2MID[7] net73 VPWR VGND sg13g2_buf_2
Xinput66 W6END[8] net84 VPWR VGND sg13g2_buf_1
Xinput33 FrameData[8] net33 VPWR VGND sg13g2_buf_1
Xinput11 FrameData[17] net11 VPWR VGND sg13g2_buf_1
X_319_ net27 net178 VPWR VGND sg13g2_buf_1
Xinput22 FrameData[27] net22 VPWR VGND sg13g2_buf_2
XFILLER_20_175 VPWR VGND sg13g2_decap_8
XFILLER_43_201 VPWR VGND sg13g2_fill_2
XFILLER_11_131 VPWR VGND sg13g2_decap_8
XFILLER_7_168 VPWR VGND sg13g2_decap_8
XFILLER_22_82 VPWR VGND sg13g2_decap_4
X_104_ Inst_W_IO_ConfigMem.Inst_frame1_bit11.Q net80 net84 net82 net75 Inst_W_IO_ConfigMem.Inst_frame1_bit10.Q
+ Inst_W_IO_switch_matrix.EE4BEG8 VPWR VGND sg13g2_mux4_1
XFILLER_43_26 VPWR VGND sg13g2_decap_8
XFILLER_4_105 VPWR VGND sg13g2_decap_8
XFILLER_3_193 VPWR VGND sg13g2_decap_8
XFILLER_1_119 VPWR VGND sg13g2_decap_8
XFILLER_54_69 VPWR VGND sg13g2_decap_4
XFILLER_0_141 VPWR VGND sg13g2_decap_8
XFILLER_48_145 VPWR VGND sg13g2_decap_8
XFILLER_5_74 VPWR VGND sg13g2_decap_8
XFILLER_10_0 VPWR VGND sg13g2_decap_8
XFILLER_39_112 VPWR VGND sg13g2_fill_2
XFILLER_39_167 VPWR VGND sg13g2_decap_8
XFILLER_54_159 VPWR VGND sg13g2_decap_4
XFILLER_24_39 VPWR VGND sg13g2_fill_1
XFILLER_49_47 VPWR VGND sg13g2_decap_8
XFILLER_45_159 VPWR VGND sg13g2_decap_8
X_352_ Inst_W_IO_switch_matrix.E2BEG7 net117 VPWR VGND sg13g2_buf_1
X_283_ Inst_W_IO_switch_matrix.EE4BEG11 net140 VPWR VGND sg13g2_buf_1
XFILLER_5_200 VPWR VGND sg13g2_fill_2
XFILLER_30_71 VPWR VGND sg13g2_decap_8
XFILLER_30_82 VPWR VGND sg13g2_fill_1
Xinput9 FrameData[15] net9 VPWR VGND sg13g2_buf_1
XFILLER_39_91 VPWR VGND sg13g2_decap_8
XFILLER_36_137 VPWR VGND sg13g2_decap_8
XFILLER_51_26 VPWR VGND sg13g2_decap_8
XFILLER_50_140 VPWR VGND sg13g2_decap_8
X_335_ FrameStrobe[15] net192 VPWR VGND sg13g2_buf_1
X_197_ net28 net45 Inst_W_IO_ConfigMem.Inst_frame1_bit3.Q VPWR VGND sg13g2_dlhq_1
X_266_ Inst_W_IO_switch_matrix.E6BEG6 net134 VPWR VGND sg13g2_buf_1
XFILLER_41_151 VPWR VGND sg13g2_decap_8
XFILLER_2_42 VPWR VGND sg13g2_decap_8
XFILLER_32_195 VPWR VGND sg13g2_decap_8
Xoutput143 net161 FrameData_O[16] VPWR VGND sg13g2_buf_1
Xoutput132 net150 EE4BEG[6] VPWR VGND sg13g2_buf_1
Xoutput121 net139 EE4BEG[10] VPWR VGND sg13g2_buf_1
Xoutput110 net128 E6BEG[11] VPWR VGND sg13g2_buf_1
Xoutput154 net172 FrameData_O[26] VPWR VGND sg13g2_buf_1
Xoutput176 net194 FrameStrobe_O[17] VPWR VGND sg13g2_buf_1
Xoutput187 net205 FrameStrobe_O[9] VPWR VGND sg13g2_buf_1
Xoutput165 net183 FrameData_O[7] VPWR VGND sg13g2_buf_1
X_120_ Inst_W_IO_ConfigMem.Inst_frame2_bit10.Q net65 net99 net92 net83 Inst_W_IO_ConfigMem.Inst_frame2_bit11.Q
+ Inst_W_IO_switch_matrix.E2BEGb0 VPWR VGND sg13g2_mux4_1
X_051_ VPWR _000_ Inst_W_IO_ConfigMem.Inst_frame0_bit27.Q VGND sg13g2_inv_1
XFILLER_23_184 VPWR VGND sg13g2_decap_8
X_249_ net18 net50 Inst_W_IO_ConfigMem.Inst_frame0_bit23.Q VPWR VGND sg13g2_dlhq_1
Xinput78 WW4END[4] net96 VPWR VGND sg13g2_buf_1
Xinput45 W2END[5] net63 VPWR VGND sg13g2_buf_2
Xinput56 W6END[0] net74 VPWR VGND sg13g2_buf_2
Xinput67 W6END[9] net85 VPWR VGND sg13g2_buf_1
Xinput34 FrameData[9] net34 VPWR VGND sg13g2_buf_1
X_318_ net26 net177 VPWR VGND sg13g2_buf_1
Xinput12 FrameData[18] net12 VPWR VGND sg13g2_buf_1
Xinput23 FrameData[28] net23 VPWR VGND sg13g2_buf_2
XFILLER_20_154 VPWR VGND sg13g2_decap_8
XFILLER_7_147 VPWR VGND sg13g2_decap_8
XFILLER_11_187 VPWR VGND sg13g2_decap_8
XFILLER_11_198 VPWR VGND sg13g2_fill_2
X_103_ Inst_W_IO_ConfigMem.Inst_frame1_bit13.Q net77 net81 net79 net83 Inst_W_IO_ConfigMem.Inst_frame1_bit12.Q
+ Inst_W_IO_switch_matrix.EE4BEG9 VPWR VGND sg13g2_mux4_1
XFILLER_34_202 VPWR VGND sg13g2_fill_2
XFILLER_27_39 VPWR VGND sg13g2_fill_1
XFILLER_3_172 VPWR VGND sg13g2_decap_8
XFILLER_54_59 VPWR VGND sg13g2_decap_4
XFILLER_0_120 VPWR VGND sg13g2_decap_8
XFILLER_48_124 VPWR VGND sg13g2_decap_8
XFILLER_5_53 VPWR VGND sg13g2_decap_8
XFILLER_54_149 VPWR VGND sg13g2_decap_4
XFILLER_39_146 VPWR VGND sg13g2_decap_8
XFILLER_24_18 VPWR VGND sg13g2_decap_4
XFILLER_49_26 VPWR VGND sg13g2_decap_8
X_351_ Inst_W_IO_switch_matrix.E2BEG6 net116 VPWR VGND sg13g2_buf_1
XFILLER_45_138 VPWR VGND sg13g2_decap_8
X_282_ Inst_W_IO_switch_matrix.EE4BEG10 net139 VPWR VGND sg13g2_buf_1
XFILLER_42_119 VPWR VGND sg13g2_decap_8
XFILLER_50_196 VPWR VGND sg13g2_decap_8
X_334_ FrameStrobe[14] net191 VPWR VGND sg13g2_buf_1
X_265_ Inst_W_IO_switch_matrix.E6BEG5 net133 VPWR VGND sg13g2_buf_1
X_196_ net25 net46 Inst_W_IO_ConfigMem.Inst_frame1_bit2.Q VPWR VGND sg13g2_dlhq_1
XFILLER_41_82 VPWR VGND sg13g2_decap_8
XFILLER_2_21 VPWR VGND sg13g2_decap_8
XFILLER_2_98 VPWR VGND sg13g2_decap_8
XFILLER_17_193 VPWR VGND sg13g2_decap_8
XFILLER_32_174 VPWR VGND sg13g2_decap_8
Xoutput177 net195 FrameStrobe_O[18] VPWR VGND sg13g2_buf_1
Xoutput155 net173 FrameData_O[27] VPWR VGND sg13g2_buf_1
Xoutput144 net162 FrameData_O[17] VPWR VGND sg13g2_buf_1
Xoutput100 net118 E2BEGb[0] VPWR VGND sg13g2_buf_1
Xoutput133 net151 EE4BEG[7] VPWR VGND sg13g2_buf_1
Xoutput122 net140 EE4BEG[11] VPWR VGND sg13g2_buf_1
Xoutput111 net129 E6BEG[1] VPWR VGND sg13g2_buf_1
Xoutput166 net184 FrameData_O[8] VPWR VGND sg13g2_buf_1
Xoutput188 net206 UserCLKo VPWR VGND sg13g2_buf_1
XFILLER_46_49 VPWR VGND sg13g2_decap_8
XFILLER_23_163 VPWR VGND sg13g2_decap_8
XFILLER_11_41 VPWR VGND sg13g2_fill_1
X_317_ net24 net175 VPWR VGND sg13g2_buf_8
XFILLER_14_185 VPWR VGND sg13g2_decap_8
Xinput13 FrameData[19] net13 VPWR VGND sg13g2_buf_1
X_248_ net17 net50 Inst_W_IO_ConfigMem.Inst_frame0_bit22.Q VPWR VGND sg13g2_dlhq_1
Xinput79 WW4END[5] net97 VPWR VGND sg13g2_buf_2
Xinput68 WW4END[0] net86 VPWR VGND sg13g2_buf_1
Xinput46 W2END[6] net64 VPWR VGND sg13g2_buf_2
Xinput35 FrameStrobe[3] net35 VPWR VGND sg13g2_buf_2
Xinput57 W6END[10] net75 VPWR VGND sg13g2_buf_1
X_179_ net11 net42 Inst_W_IO_ConfigMem.Inst_frame2_bit17.Q VPWR VGND sg13g2_dlhq_1
Xinput24 FrameData[29] net24 VPWR VGND sg13g2_buf_2
XFILLER_20_111 VPWR VGND sg13g2_decap_8
XFILLER_32_18 VPWR VGND sg13g2_decap_4
XFILLER_28_200 VPWR VGND sg13g2_decap_4
XFILLER_43_203 VPWR VGND sg13g2_fill_1
XFILLER_11_166 VPWR VGND sg13g2_decap_8
XFILLER_7_126 VPWR VGND sg13g2_decap_8
X_102_ Inst_W_IO_ConfigMem.Inst_frame1_bit15.Q net74 net80 net78 net1 Inst_W_IO_ConfigMem.Inst_frame1_bit14.Q
+ Inst_W_IO_switch_matrix.EE4BEG10 VPWR VGND sg13g2_mux4_1
XFILLER_0_0 VPWR VGND sg13g2_decap_8
XFILLER_8_42 VPWR VGND sg13g2_decap_4
XFILLER_33_94 VPWR VGND sg13g2_fill_1
XFILLER_3_151 VPWR VGND sg13g2_decap_8
XFILLER_38_28 VPWR VGND sg13g2_decap_8
XFILLER_54_49 VPWR VGND sg13g2_decap_4
XFILLER_0_176 VPWR VGND sg13g2_decap_8
XFILLER_48_103 VPWR VGND sg13g2_decap_8
XFILLER_44_82 VPWR VGND sg13g2_decap_8
XFILLER_5_32 VPWR VGND sg13g2_decap_8
XFILLER_39_114 VPWR VGND sg13g2_fill_1
XFILLER_54_139 VPWR VGND sg13g2_decap_4
XFILLER_47_180 VPWR VGND sg13g2_decap_8
XFILLER_45_117 VPWR VGND sg13g2_decap_8
XFILLER_53_161 VPWR VGND sg13g2_decap_4
X_350_ Inst_W_IO_switch_matrix.E2BEG5 net115 VPWR VGND sg13g2_buf_1
X_281_ Inst_W_IO_switch_matrix.EE4BEG9 net153 VPWR VGND sg13g2_buf_1
XFILLER_44_194 VPWR VGND sg13g2_decap_4
XFILLER_35_183 VPWR VGND sg13g2_decap_8
XFILLER_50_175 VPWR VGND sg13g2_decap_8
X_333_ FrameStrobe[13] net190 VPWR VGND sg13g2_buf_1
XFILLER_25_62 VPWR VGND sg13g2_fill_1
X_264_ Inst_W_IO_switch_matrix.E6BEG4 net132 VPWR VGND sg13g2_buf_1
XFILLER_26_194 VPWR VGND sg13g2_decap_8
XFILLER_41_186 VPWR VGND sg13g2_decap_8
X_195_ net14 net47 Inst_W_IO_ConfigMem.Inst_frame1_bit1.Q VPWR VGND sg13g2_dlhq_1
XFILLER_41_61 VPWR VGND sg13g2_decap_8
XFILLER_2_77 VPWR VGND sg13g2_decap_8
XFILLER_17_172 VPWR VGND sg13g2_decap_8
XFILLER_32_153 VPWR VGND sg13g2_decap_8
Xoutput178 net196 FrameStrobe_O[19] VPWR VGND sg13g2_buf_1
Xoutput156 net174 FrameData_O[28] VPWR VGND sg13g2_buf_1
Xoutput145 net163 FrameData_O[18] VPWR VGND sg13g2_buf_1
Xoutput101 net119 E2BEGb[1] VPWR VGND sg13g2_buf_1
Xoutput134 net152 EE4BEG[8] VPWR VGND sg13g2_buf_1
Xoutput123 net141 EE4BEG[12] VPWR VGND sg13g2_buf_1
Xoutput112 net130 E6BEG[2] VPWR VGND sg13g2_buf_1
Xoutput167 net185 FrameData_O[9] VPWR VGND sg13g2_buf_1
XFILLER_46_28 VPWR VGND sg13g2_decap_8
XFILLER_23_142 VPWR VGND sg13g2_decap_8
XFILLER_36_83 VPWR VGND sg13g2_fill_1
XFILLER_52_82 VPWR VGND sg13g2_decap_8
X_247_ net16 net51 Inst_W_IO_ConfigMem.Inst_frame0_bit21.Q VPWR VGND sg13g2_dlhq_1
Xinput36 W1END[0] net36 VPWR VGND sg13g2_buf_1
Xinput14 FrameData[1] net14 VPWR VGND sg13g2_buf_1
Xinput25 FrameData[2] net25 VPWR VGND sg13g2_buf_1
XFILLER_14_164 VPWR VGND sg13g2_decap_8
X_316_ net23 net174 VPWR VGND sg13g2_buf_1
Xinput47 W2END[7] net65 VPWR VGND sg13g2_buf_1
Xinput69 WW4END[10] net87 VPWR VGND sg13g2_buf_1
Xinput58 W6END[11] net76 VPWR VGND sg13g2_buf_1
X_178_ net10 net42 Inst_W_IO_ConfigMem.Inst_frame2_bit16.Q VPWR VGND sg13g2_dlhq_1
XFILLER_37_201 VPWR VGND sg13g2_fill_2
XFILLER_20_189 VPWR VGND sg13g2_decap_8
XFILLER_11_145 VPWR VGND sg13g2_decap_8
X_101_ Inst_W_IO_ConfigMem.Inst_frame1_bit17.Q net82 net75 net84 net2 Inst_W_IO_ConfigMem.Inst_frame1_bit16.Q
+ Inst_W_IO_switch_matrix.EE4BEG11 VPWR VGND sg13g2_mux4_1
XFILLER_47_82 VPWR VGND sg13g2_decap_8
XFILLER_8_65 VPWR VGND sg13g2_fill_2
XFILLER_6_182 VPWR VGND sg13g2_decap_8
XFILLER_4_119 VPWR VGND sg13g2_decap_8
XFILLER_3_130 VPWR VGND sg13g2_decap_8
XFILLER_54_39 VPWR VGND sg13g2_decap_4
XFILLER_0_155 VPWR VGND sg13g2_decap_8
XFILLER_28_51 VPWR VGND sg13g2_fill_1
XFILLER_28_73 VPWR VGND sg13g2_fill_2
XFILLER_48_159 VPWR VGND sg13g2_decap_8
XFILLER_44_61 VPWR VGND sg13g2_decap_8
XFILLER_5_11 VPWR VGND sg13g2_decap_8
XFILLER_5_88 VPWR VGND sg13g2_decap_8
XFILLER_54_129 VPWR VGND sg13g2_decap_4
XFILLER_40_19 VPWR VGND sg13g2_decap_8
XFILLER_14_20 VPWR VGND sg13g2_decap_8
X_280_ Inst_W_IO_switch_matrix.EE4BEG8 net152 VPWR VGND sg13g2_buf_1
XFILLER_14_97 VPWR VGND sg13g2_decap_8
XFILLER_29_181 VPWR VGND sg13g2_decap_8
XFILLER_44_173 VPWR VGND sg13g2_decap_8
XFILLER_50_154 VPWR VGND sg13g2_decap_8
XFILLER_35_162 VPWR VGND sg13g2_decap_8
XFILLER_26_173 VPWR VGND sg13g2_decap_8
X_332_ FrameStrobe[12] net189 VPWR VGND sg13g2_buf_1
X_263_ Inst_W_IO_switch_matrix.E6BEG3 net131 VPWR VGND sg13g2_buf_1
XFILLER_41_40 VPWR VGND sg13g2_decap_8
XFILLER_41_165 VPWR VGND sg13g2_decap_8
X_194_ net3 net47 Inst_W_IO_ConfigMem.Inst_frame1_bit0.Q VPWR VGND sg13g2_dlhq_1
XFILLER_2_56 VPWR VGND sg13g2_decap_8
XFILLER_17_151 VPWR VGND sg13g2_decap_8
XFILLER_32_132 VPWR VGND sg13g2_decap_8
Xoutput157 net175 FrameData_O[29] VPWR VGND sg13g2_buf_1
Xoutput179 net197 FrameStrobe_O[1] VPWR VGND sg13g2_buf_1
Xoutput168 net186 FrameStrobe_O[0] VPWR VGND sg13g2_buf_1
Xoutput146 net164 FrameData_O[19] VPWR VGND sg13g2_buf_1
Xoutput102 net120 E2BEGb[2] VPWR VGND sg13g2_buf_1
Xoutput135 net153 EE4BEG[9] VPWR VGND sg13g2_buf_1
Xoutput124 net142 EE4BEG[13] VPWR VGND sg13g2_buf_1
Xoutput113 net131 E6BEG[3] VPWR VGND sg13g2_buf_1
XFILLER_23_198 VPWR VGND sg13g2_decap_4
XFILLER_11_32 VPWR VGND sg13g2_decap_4
XFILLER_14_143 VPWR VGND sg13g2_decap_8
XFILLER_52_61 VPWR VGND sg13g2_decap_8
Xinput26 FrameData[30] net26 VPWR VGND sg13g2_buf_2
Xinput37 W1END[1] net37 VPWR VGND sg13g2_buf_2
Xinput48 W2MID[0] net66 VPWR VGND sg13g2_buf_2
X_315_ net22 net173 VPWR VGND sg13g2_buf_2
X_246_ net15 net52 Inst_W_IO_ConfigMem.Inst_frame0_bit20.Q VPWR VGND sg13g2_dlhq_1
Xinput59 W6END[1] net77 VPWR VGND sg13g2_buf_2
Xinput15 FrameData[20] net15 VPWR VGND sg13g2_buf_1
X_177_ net9 net43 Inst_W_IO_ConfigMem.Inst_frame2_bit15.Q VPWR VGND sg13g2_dlhq_1
XFILLER_28_4 VPWR VGND sg13g2_fill_1
XFILLER_20_102 VPWR VGND sg13g2_decap_4
XFILLER_20_168 VPWR VGND sg13g2_decap_8
X_100_ Inst_W_IO_ConfigMem.Inst_frame1_bit19.Q net77 net81 net79 Inst_A_IO_1_bidirectional_frame_config_pass.Q
+ Inst_W_IO_ConfigMem.Inst_frame1_bit18.Q Inst_W_IO_switch_matrix.EE4BEG12 VPWR VGND
+ sg13g2_mux4_1
XFILLER_22_86 VPWR VGND sg13g2_fill_1
XFILLER_47_61 VPWR VGND sg13g2_decap_8
XFILLER_6_161 VPWR VGND sg13g2_decap_8
X_229_ net28 net53 Inst_W_IO_ConfigMem.Inst_frame0_bit3.Q VPWR VGND sg13g2_dlhq_1
XFILLER_43_19 VPWR VGND sg13g2_decap_8
XFILLER_3_186 VPWR VGND sg13g2_decap_8
XFILLER_54_29 VPWR VGND sg13g2_decap_4
XFILLER_0_134 VPWR VGND sg13g2_decap_8
XFILLER_48_138 VPWR VGND sg13g2_decap_8
XFILLER_44_40 VPWR VGND sg13g2_decap_8
XFILLER_5_67 VPWR VGND sg13g2_decap_8
XFILLER_39_105 VPWR VGND sg13g2_decap_8
XFILLER_54_119 VPWR VGND sg13g2_decap_4
XFILLER_53_130 VPWR VGND sg13g2_decap_8
XFILLER_38_193 VPWR VGND sg13g2_decap_8
XFILLER_53_174 VPWR VGND sg13g2_fill_1
XFILLER_30_64 VPWR VGND sg13g2_decap_8
XFILLER_39_84 VPWR VGND sg13g2_fill_2
XFILLER_29_160 VPWR VGND sg13g2_decap_8
XFILLER_44_152 VPWR VGND sg13g2_decap_8
XFILLER_51_19 VPWR VGND sg13g2_decap_8
XFILLER_50_133 VPWR VGND sg13g2_decap_8
XFILLER_35_141 VPWR VGND sg13g2_decap_8
X_331_ FrameStrobe[11] net188 VPWR VGND sg13g2_buf_1
XFILLER_26_152 VPWR VGND sg13g2_decap_8
X_262_ Inst_W_IO_switch_matrix.E6BEG2 net130 VPWR VGND sg13g2_buf_1
X_193_ net27 net43 Inst_W_IO_ConfigMem.Inst_frame2_bit31.Q VPWR VGND sg13g2_dlhq_1
XFILLER_41_144 VPWR VGND sg13g2_decap_8
XFILLER_41_96 VPWR VGND sg13g2_fill_2
XFILLER_2_35 VPWR VGND sg13g2_decap_8
XFILLER_32_188 VPWR VGND sg13g2_decap_8
Xoutput103 net121 E2BEGb[3] VPWR VGND sg13g2_buf_1
Xoutput125 net143 EE4BEG[14] VPWR VGND sg13g2_buf_1
Xoutput114 net132 E6BEG[4] VPWR VGND sg13g2_buf_1
Xoutput169 net187 FrameStrobe_O[10] VPWR VGND sg13g2_buf_1
Xoutput136 net154 FrameData_O[0] VPWR VGND sg13g2_buf_1
Xoutput147 net165 FrameData_O[1] VPWR VGND sg13g2_buf_1
Xoutput158 net176 FrameData_O[2] VPWR VGND sg13g2_buf_1
XFILLER_23_177 VPWR VGND sg13g2_decap_8
XFILLER_46_203 VPWR VGND sg13g2_fill_1
XFILLER_52_40 VPWR VGND sg13g2_decap_8
X_314_ net21 net172 VPWR VGND sg13g2_buf_1
Xinput27 FrameData[31] net27 VPWR VGND sg13g2_buf_2
Xinput38 W1END[2] net56 VPWR VGND sg13g2_buf_2
Xinput49 W2MID[1] net67 VPWR VGND sg13g2_buf_2
XFILLER_14_199 VPWR VGND sg13g2_decap_4
X_245_ net13 net52 Inst_W_IO_ConfigMem.Inst_frame0_bit19.Q VPWR VGND sg13g2_dlhq_1
Xinput16 FrameData[21] net16 VPWR VGND sg13g2_buf_1
X_176_ net8 net43 Inst_W_IO_ConfigMem.Inst_frame2_bit14.Q VPWR VGND sg13g2_dlhq_1
XFILLER_42_7 VPWR VGND sg13g2_decap_8
XFILLER_37_203 VPWR VGND sg13g2_fill_1
XFILLER_20_125 VPWR VGND sg13g2_decap_4
XFILLER_20_147 VPWR VGND sg13g2_decap_8
XFILLER_47_40 VPWR VGND sg13g2_decap_8
XFILLER_6_140 VPWR VGND sg13g2_decap_8
X_159_ net24 net38 Inst_W_IO_ConfigMem.Inst_frame3_bit29.Q VPWR VGND sg13g2_dlhq_1
X_228_ net25 net53 Inst_W_IO_ConfigMem.Inst_frame0_bit2.Q VPWR VGND sg13g2_dlhq_1
XFILLER_3_165 VPWR VGND sg13g2_decap_8
XFILLER_12_8 VPWR VGND sg13g2_decap_4
XFILLER_54_19 VPWR VGND sg13g2_decap_4
XFILLER_0_113 VPWR VGND sg13g2_decap_8
XFILLER_48_117 VPWR VGND sg13g2_decap_8
XFILLER_28_75 VPWR VGND sg13g2_fill_1
XFILLER_44_96 VPWR VGND sg13g2_decap_8
XFILLER_5_46 VPWR VGND sg13g2_decap_8
XFILLER_54_109 VPWR VGND sg13g2_decap_4
XFILLER_39_139 VPWR VGND sg13g2_decap_8
XFILLER_47_194 VPWR VGND sg13g2_decap_8
XFILLER_49_19 VPWR VGND sg13g2_decap_8
XFILLER_38_172 VPWR VGND sg13g2_decap_8
XFILLER_53_186 VPWR VGND sg13g2_fill_1
XFILLER_44_131 VPWR VGND sg13g2_decap_8
XFILLER_35_120 VPWR VGND sg13g2_decap_8
XFILLER_50_189 VPWR VGND sg13g2_decap_8
XFILLER_50_112 VPWR VGND sg13g2_decap_8
XFILLER_35_197 VPWR VGND sg13g2_decap_8
X_330_ FrameStrobe[10] net187 VPWR VGND sg13g2_buf_1
XFILLER_41_112 VPWR VGND sg13g2_decap_8
XFILLER_41_123 VPWR VGND sg13g2_fill_1
X_192_ net26 net43 Inst_W_IO_ConfigMem.Inst_frame2_bit30.Q VPWR VGND sg13g2_dlhq_1
XFILLER_41_75 VPWR VGND sg13g2_decap_8
XFILLER_49_201 VPWR VGND sg13g2_fill_2
XFILLER_2_14 VPWR VGND sg13g2_decap_8
XFILLER_17_186 VPWR VGND sg13g2_decap_8
XFILLER_32_101 VPWR VGND sg13g2_fill_2
XFILLER_32_167 VPWR VGND sg13g2_decap_8
Xoutput159 net177 FrameData_O[30] VPWR VGND sg13g2_buf_1
Xoutput148 net166 FrameData_O[20] VPWR VGND sg13g2_buf_1
Xoutput104 net122 E2BEGb[4] VPWR VGND sg13g2_buf_1
Xoutput126 net144 EE4BEG[15] VPWR VGND sg13g2_buf_1
Xoutput115 net133 E6BEG[5] VPWR VGND sg13g2_buf_1
Xoutput137 net155 FrameData_O[10] VPWR VGND sg13g2_buf_1
XFILLER_23_156 VPWR VGND sg13g2_decap_8
XFILLER_2_7 VPWR VGND sg13g2_decap_8
X_244_ net12 net50 Inst_W_IO_ConfigMem.Inst_frame0_bit18.Q VPWR VGND sg13g2_dlhq_1
XFILLER_14_178 VPWR VGND sg13g2_decap_8
X_313_ net20 net171 VPWR VGND sg13g2_buf_1
XFILLER_52_96 VPWR VGND sg13g2_decap_8
Xinput39 W1END[3] net57 VPWR VGND sg13g2_buf_2
Xinput28 FrameData[3] net28 VPWR VGND sg13g2_buf_1
X_175_ net7 net40 Inst_W_IO_ConfigMem.Inst_frame2_bit13.Q VPWR VGND sg13g2_dlhq_1
Xinput17 FrameData[22] net17 VPWR VGND sg13g2_buf_2
XFILLER_9_182 VPWR VGND sg13g2_decap_8
XFILLER_11_159 VPWR VGND sg13g2_decap_8
XFILLER_7_119 VPWR VGND sg13g2_fill_2
XFILLER_47_96 VPWR VGND sg13g2_decap_8
XFILLER_8_46 VPWR VGND sg13g2_fill_1
X_227_ net14 net52 Inst_W_IO_ConfigMem.Inst_frame0_bit1.Q VPWR VGND sg13g2_dlhq_1
XFILLER_6_196 VPWR VGND sg13g2_decap_4
X_158_ net23 net38 Inst_W_IO_ConfigMem.Inst_frame3_bit28.Q VPWR VGND sg13g2_dlhq_1
X_089_ Inst_W_IO_ConfigMem.Inst_frame0_bit8.Q net36 net100 net84 Inst_B_IO_1_bidirectional_frame_config_pass.Q
+ Inst_W_IO_ConfigMem.Inst_frame0_bit9.Q Inst_W_IO_switch_matrix.E6BEG7 VPWR VGND
+ sg13g2_mux4_1
XFILLER_40_5 VPWR VGND sg13g2_decap_8
XFILLER_33_10 VPWR VGND sg13g2_fill_1
XFILLER_33_32 VPWR VGND sg13g2_fill_2
XFILLER_33_87 VPWR VGND sg13g2_decap_8
XFILLER_3_144 VPWR VGND sg13g2_decap_8
XFILLER_24_0 VPWR VGND sg13g2_fill_1
XFILLER_0_169 VPWR VGND sg13g2_decap_8
XFILLER_44_75 VPWR VGND sg13g2_decap_8
XFILLER_5_25 VPWR VGND sg13g2_decap_8
XFILLER_47_173 VPWR VGND sg13g2_decap_8
XFILLER_53_165 VPWR VGND sg13g2_fill_1
XFILLER_53_143 VPWR VGND sg13g2_fill_2
XFILLER_38_151 VPWR VGND sg13g2_decap_8
XFILLER_29_195 VPWR VGND sg13g2_decap_8
XFILLER_39_64 VPWR VGND sg13g2_fill_2
XFILLER_39_86 VPWR VGND sg13g2_fill_1
XFILLER_44_110 VPWR VGND sg13g2_decap_8
XFILLER_44_187 VPWR VGND sg13g2_decap_8
XFILLER_44_198 VPWR VGND sg13g2_fill_2
XFILLER_35_176 VPWR VGND sg13g2_decap_8
XFILLER_50_168 VPWR VGND sg13g2_decap_8
XFILLER_25_11 VPWR VGND sg13g2_decap_4
XFILLER_26_187 VPWR VGND sg13g2_decap_8
XFILLER_41_179 VPWR VGND sg13g2_decap_8
X_191_ net24 net42 Inst_W_IO_ConfigMem.Inst_frame2_bit29.Q VPWR VGND sg13g2_dlhq_1
XFILLER_41_54 VPWR VGND sg13g2_decap_8
XFILLER_41_98 VPWR VGND sg13g2_fill_1
XFILLER_17_165 VPWR VGND sg13g2_decap_8
XFILLER_32_146 VPWR VGND sg13g2_decap_8
Xoutput149 net167 FrameData_O[21] VPWR VGND sg13g2_buf_1
Xoutput105 net123 E2BEGb[5] VPWR VGND sg13g2_buf_1
Xoutput127 net145 EE4BEG[1] VPWR VGND sg13g2_buf_1
Xoutput116 net134 E6BEG[6] VPWR VGND sg13g2_buf_1
Xoutput138 net156 FrameData_O[11] VPWR VGND sg13g2_buf_1
XFILLER_23_113 VPWR VGND sg13g2_decap_4
XFILLER_11_79 VPWR VGND sg13g2_fill_1
XFILLER_36_76 VPWR VGND sg13g2_fill_2
XFILLER_52_75 VPWR VGND sg13g2_decap_8
XFILLER_14_157 VPWR VGND sg13g2_decap_8
X_312_ net19 net170 VPWR VGND sg13g2_buf_1
X_243_ net11 net53 Inst_W_IO_ConfigMem.Inst_frame0_bit17.Q VPWR VGND sg13g2_dlhq_1
Xinput18 FrameData[23] net18 VPWR VGND sg13g2_buf_2
Xinput29 FrameData[4] net29 VPWR VGND sg13g2_buf_1
X_174_ net6 net41 Inst_W_IO_ConfigMem.Inst_frame2_bit12.Q VPWR VGND sg13g2_dlhq_1
XFILLER_9_161 VPWR VGND sg13g2_decap_8
XFILLER_54_0 VPWR VGND sg13g2_decap_4
XFILLER_11_138 VPWR VGND sg13g2_decap_8
XFILLER_47_75 VPWR VGND sg13g2_decap_8
XFILLER_10_182 VPWR VGND sg13g2_decap_8
X_157_ net22 net38 Inst_W_IO_ConfigMem.Inst_frame3_bit27.Q VPWR VGND sg13g2_dlhq_1
X_226_ net3 net52 Inst_W_IO_ConfigMem.Inst_frame0_bit0.Q VPWR VGND sg13g2_dlhq_1
XFILLER_6_175 VPWR VGND sg13g2_decap_8
X_088_ Inst_W_IO_ConfigMem.Inst_frame0_bit10.Q net97 net90 net81 Inst_A_IO_1_bidirectional_frame_config_pass.Q
+ Inst_W_IO_ConfigMem.Inst_frame0_bit11.Q Inst_W_IO_switch_matrix.E6BEG8 VPWR VGND
+ sg13g2_mux4_1
XFILLER_26_4 VPWR VGND sg13g2_fill_2
XFILLER_3_123 VPWR VGND sg13g2_decap_8
X_209_ net9 net49 Inst_W_IO_ConfigMem.Inst_frame1_bit15.Q VPWR VGND sg13g2_dlhq_1
XFILLER_0_92 VPWR VGND sg13g2_decap_8
XFILLER_0_148 VPWR VGND sg13g2_decap_8
XFILLER_44_54 VPWR VGND sg13g2_decap_8
XFILLER_47_152 VPWR VGND sg13g2_decap_8
XFILLER_38_130 VPWR VGND sg13g2_decap_8
XFILLER_53_155 VPWR VGND sg13g2_fill_2
XFILLER_30_23 VPWR VGND sg13g2_fill_2
XFILLER_30_78 VPWR VGND sg13g2_decap_4
XFILLER_39_32 VPWR VGND sg13g2_decap_8
XFILLER_29_174 VPWR VGND sg13g2_decap_8
XFILLER_39_98 VPWR VGND sg13g2_decap_8
XFILLER_44_166 VPWR VGND sg13g2_decap_8
XFILLER_50_147 VPWR VGND sg13g2_decap_8
XFILLER_35_155 VPWR VGND sg13g2_decap_8
XFILLER_6_91 VPWR VGND sg13g2_decap_8
XFILLER_26_166 VPWR VGND sg13g2_decap_8
X_190_ net23 net42 Inst_W_IO_ConfigMem.Inst_frame2_bit28.Q VPWR VGND sg13g2_dlhq_1
XFILLER_41_158 VPWR VGND sg13g2_decap_8
XFILLER_41_33 VPWR VGND sg13g2_decap_8
XFILLER_49_203 VPWR VGND sg13g2_fill_1
XFILLER_2_49 VPWR VGND sg13g2_decap_8
XFILLER_17_144 VPWR VGND sg13g2_decap_8
XFILLER_32_103 VPWR VGND sg13g2_fill_1
XFILLER_32_125 VPWR VGND sg13g2_decap_8
Xoutput106 net124 E2BEGb[6] VPWR VGND sg13g2_buf_1
Xoutput128 net146 EE4BEG[2] VPWR VGND sg13g2_buf_1
Xoutput117 net135 E6BEG[7] VPWR VGND sg13g2_buf_1
Xoutput139 net157 FrameData_O[12] VPWR VGND sg13g2_buf_1
XFILLER_11_36 VPWR VGND sg13g2_fill_1
XFILLER_31_191 VPWR VGND sg13g2_decap_8
XFILLER_52_54 VPWR VGND sg13g2_decap_8
X_311_ net18 net169 VPWR VGND sg13g2_buf_1
X_173_ net5 net41 Inst_W_IO_ConfigMem.Inst_frame2_bit11.Q VPWR VGND sg13g2_dlhq_1
X_242_ net10 net54 Inst_W_IO_ConfigMem.Inst_frame0_bit16.Q VPWR VGND sg13g2_dlhq_1
Xinput19 FrameData[24] net19 VPWR VGND sg13g2_buf_2
XFILLER_20_106 VPWR VGND sg13g2_fill_1
XFILLER_9_140 VPWR VGND sg13g2_decap_8
XFILLER_22_24 VPWR VGND sg13g2_decap_8
XFILLER_47_54 VPWR VGND sg13g2_decap_8
XFILLER_10_161 VPWR VGND sg13g2_decap_8
X_156_ net21 net38 Inst_W_IO_ConfigMem.Inst_frame3_bit26.Q VPWR VGND sg13g2_dlhq_1
XFILLER_6_154 VPWR VGND sg13g2_decap_8
X_225_ net27 net46 Inst_W_IO_ConfigMem.Inst_frame1_bit31.Q VPWR VGND sg13g2_dlhq_1
X_087_ Inst_W_IO_ConfigMem.Inst_frame0_bit12.Q net96 net89 net80 Inst_B_IO_1_bidirectional_frame_config_pass.Q
+ Inst_W_IO_ConfigMem.Inst_frame0_bit13.Q Inst_W_IO_switch_matrix.E6BEG9 VPWR VGND
+ sg13g2_mux4_1
XFILLER_19_4 VPWR VGND sg13g2_decap_8
XFILLER_33_34 VPWR VGND sg13g2_fill_1
XFILLER_3_102 VPWR VGND sg13g2_decap_8
XFILLER_3_179 VPWR VGND sg13g2_decap_8
X_139_ Inst_W_IO_ConfigMem.Inst_frame0_bit23.Q VPWR _038_ VGND net60 Inst_W_IO_ConfigMem.Inst_frame0_bit24.Q
+ sg13g2_o21ai_1
X_208_ net8 net47 Inst_W_IO_ConfigMem.Inst_frame1_bit14.Q VPWR VGND sg13g2_dlhq_1
XFILLER_0_71 VPWR VGND sg13g2_decap_8
XFILLER_21_201 VPWR VGND sg13g2_fill_2
XFILLER_0_127 VPWR VGND sg13g2_decap_8
XFILLER_44_33 VPWR VGND sg13g2_decap_8
XFILLER_47_131 VPWR VGND sg13g2_decap_8
XFILLER_53_123 VPWR VGND sg13g2_decap_8
XFILLER_53_101 VPWR VGND sg13g2_decap_8
XFILLER_38_186 VPWR VGND sg13g2_decap_8
XFILLER_39_11 VPWR VGND sg13g2_decap_8
XFILLER_39_66 VPWR VGND sg13g2_fill_1
XFILLER_29_153 VPWR VGND sg13g2_decap_8
XFILLER_44_145 VPWR VGND sg13g2_decap_8
XFILLER_50_126 VPWR VGND sg13g2_decap_8
XFILLER_35_134 VPWR VGND sg13g2_decap_8
XFILLER_26_145 VPWR VGND sg13g2_decap_8
XFILLER_41_12 VPWR VGND sg13g2_decap_8
XFILLER_41_137 VPWR VGND sg13g2_decap_8
XFILLER_41_89 VPWR VGND sg13g2_decap_8
XFILLER_2_28 VPWR VGND sg13g2_decap_8
Xoutput107 net125 E2BEGb[7] VPWR VGND sg13g2_buf_1
Xoutput129 net147 EE4BEG[3] VPWR VGND sg13g2_buf_1
Xoutput118 net136 E6BEG[8] VPWR VGND sg13g2_buf_1
XFILLER_31_170 VPWR VGND sg13g2_decap_8
XFILLER_52_33 VPWR VGND sg13g2_decap_8
X_310_ net17 net168 VPWR VGND sg13g2_buf_2
XFILLER_36_78 VPWR VGND sg13g2_fill_1
X_172_ net4 net41 Inst_W_IO_ConfigMem.Inst_frame2_bit10.Q VPWR VGND sg13g2_dlhq_1
X_241_ net9 net53 Inst_W_IO_ConfigMem.Inst_frame0_bit15.Q VPWR VGND sg13g2_dlhq_1
XFILLER_20_118 VPWR VGND sg13g2_decap_8
XFILLER_20_129 VPWR VGND sg13g2_fill_1
XFILLER_9_196 VPWR VGND sg13g2_decap_8
XFILLER_3_82 VPWR VGND sg13g2_decap_8
XFILLER_0_7 VPWR VGND sg13g2_decap_8
XFILLER_47_33 VPWR VGND sg13g2_decap_8
X_224_ net26 net46 Inst_W_IO_ConfigMem.Inst_frame1_bit30.Q VPWR VGND sg13g2_dlhq_1
XFILLER_10_140 VPWR VGND sg13g2_decap_8
XFILLER_6_133 VPWR VGND sg13g2_decap_8
X_155_ net20 net35 Inst_W_IO_ConfigMem.Inst_frame3_bit25.Q VPWR VGND sg13g2_dlhq_1
X_086_ Inst_W_IO_ConfigMem.Inst_frame0_bit14.Q net37 net93 net77 Inst_A_IO_1_bidirectional_frame_config_pass.Q
+ Inst_W_IO_ConfigMem.Inst_frame0_bit15.Q Inst_W_IO_switch_matrix.E6BEG10 VPWR VGND
+ sg13g2_mux4_1
XFILLER_26_6 VPWR VGND sg13g2_fill_1
XFILLER_17_47 VPWR VGND sg13g2_fill_2
XFILLER_3_158 VPWR VGND sg13g2_decap_8
XFILLER_30_202 VPWR VGND sg13g2_fill_2
X_207_ net7 net47 Inst_W_IO_ConfigMem.Inst_frame1_bit13.Q VPWR VGND sg13g2_dlhq_1
X_138_ _001_ Inst_W_IO_ConfigMem.Inst_frame0_bit23.Q Inst_W_IO_ConfigMem.Inst_frame0_bit24.Q
+ _037_ VPWR VGND sg13g2_nor3_1
X_069_ _017_ VPWR net104 VGND _005_ _011_ sg13g2_o21ai_1
XFILLER_31_4 VPWR VGND sg13g2_fill_2
XFILLER_0_50 VPWR VGND sg13g2_decap_8
XFILLER_0_106 VPWR VGND sg13g2_decap_8
XFILLER_44_12 VPWR VGND sg13g2_decap_8
XFILLER_8_206 VPWR VGND sg13g2_fill_1
XFILLER_44_89 VPWR VGND sg13g2_decap_8
XFILLER_5_39 VPWR VGND sg13g2_decap_8
XFILLER_47_110 VPWR VGND sg13g2_decap_8
XFILLER_47_187 VPWR VGND sg13g2_decap_8
XFILLER_38_165 VPWR VGND sg13g2_decap_8
XFILLER_53_179 VPWR VGND sg13g2_decap_8
XFILLER_44_124 VPWR VGND sg13g2_decap_8
XFILLER_50_105 VPWR VGND sg13g2_decap_8
XFILLER_41_68 VPWR VGND sg13g2_decap_8
XFILLER_9_4 VPWR VGND sg13g2_fill_2
XFILLER_17_124 VPWR VGND sg13g2_fill_2
XFILLER_17_179 VPWR VGND sg13g2_decap_8
XFILLER_25_190 VPWR VGND sg13g2_decap_8
Xoutput108 net126 E6BEG[0] VPWR VGND sg13g2_buf_1
XFILLER_40_182 VPWR VGND sg13g2_decap_8
Xoutput119 net137 E6BEG[9] VPWR VGND sg13g2_buf_1
Xoutput90 net108 E1BEG[2] VPWR VGND sg13g2_buf_1
XFILLER_49_5 VPWR VGND sg13g2_decap_8
XFILLER_23_149 VPWR VGND sg13g2_decap_8
XFILLER_11_27 VPWR VGND sg13g2_fill_1
XFILLER_52_12 VPWR VGND sg13g2_decap_8
X_240_ net8 net54 Inst_W_IO_ConfigMem.Inst_frame0_bit14.Q VPWR VGND sg13g2_dlhq_1
XFILLER_52_89 VPWR VGND sg13g2_decap_8
X_171_ net34 net39 Inst_W_IO_ConfigMem.Inst_frame2_bit9.Q VPWR VGND sg13g2_dlhq_1
XFILLER_22_182 VPWR VGND sg13g2_decap_8
XFILLER_9_175 VPWR VGND sg13g2_decap_8
XFILLER_13_193 VPWR VGND sg13g2_decap_8
XFILLER_3_61 VPWR VGND sg13g2_decap_8
XFILLER_47_12 VPWR VGND sg13g2_decap_8
XFILLER_47_89 VPWR VGND sg13g2_decap_8
X_223_ net24 net48 Inst_W_IO_ConfigMem.Inst_frame1_bit29.Q VPWR VGND sg13g2_dlhq_1
XFILLER_10_196 VPWR VGND sg13g2_decap_8
XFILLER_6_189 VPWR VGND sg13g2_decap_8
XFILLER_6_112 VPWR VGND sg13g2_decap_8
XFILLER_12_70 VPWR VGND sg13g2_fill_1
X_085_ Inst_W_IO_ConfigMem.Inst_frame0_bit16.Q net36 net86 net74 Inst_B_IO_1_bidirectional_frame_config_pass.Q
+ Inst_W_IO_ConfigMem.Inst_frame0_bit17.Q Inst_W_IO_switch_matrix.E6BEG11 VPWR VGND
+ sg13g2_mux4_1
X_154_ net19 net35 Inst_W_IO_ConfigMem.Inst_frame3_bit24.Q VPWR VGND sg13g2_dlhq_1
XFILLER_33_8 VPWR VGND sg13g2_fill_2
XFILLER_3_137 VPWR VGND sg13g2_decap_8
X_137_ _035_ VPWR _036_ VGND Inst_W_IO_ConfigMem.Inst_frame0_bit24.Q _033_ sg13g2_o21ai_1
X_206_ net6 net49 Inst_W_IO_ConfigMem.Inst_frame1_bit12.Q VPWR VGND sg13g2_dlhq_1
X_068_ _017_ _016_ Inst_W_IO_ConfigMem.Inst_frame0_bit28.Q VPWR VGND sg13g2_nand2b_1
XFILLER_21_203 VPWR VGND sg13g2_fill_1
XFILLER_28_47 VPWR VGND sg13g2_decap_4
XFILLER_44_68 VPWR VGND sg13g2_decap_8
XFILLER_5_18 VPWR VGND sg13g2_decap_8
XFILLER_47_166 VPWR VGND sg13g2_decap_8
XFILLER_18_91 VPWR VGND sg13g2_fill_2
XFILLER_15_0 VPWR VGND sg13g2_fill_2
XFILLER_38_144 VPWR VGND sg13g2_decap_8
XFILLER_14_27 VPWR VGND sg13g2_decap_4
XFILLER_29_100 VPWR VGND sg13g2_fill_1
XFILLER_29_188 VPWR VGND sg13g2_decap_8
XFILLER_39_46 VPWR VGND sg13g2_fill_1
XFILLER_44_103 VPWR VGND sg13g2_decap_8
XFILLER_52_180 VPWR VGND sg13g2_decap_8
XFILLER_20_70 VPWR VGND sg13g2_fill_2
XFILLER_35_169 VPWR VGND sg13g2_decap_8
XFILLER_43_180 VPWR VGND sg13g2_decap_8
XFILLER_6_50 VPWR VGND sg13g2_decap_8
XFILLER_34_191 VPWR VGND sg13g2_decap_8
XFILLER_41_47 VPWR VGND sg13g2_decap_8
XFILLER_17_158 VPWR VGND sg13g2_decap_8
XFILLER_32_139 VPWR VGND sg13g2_decap_8
XFILLER_40_161 VPWR VGND sg13g2_decap_8
Xoutput109 net127 E6BEG[10] VPWR VGND sg13g2_buf_1
Xoutput91 net109 E1BEG[3] VPWR VGND sg13g2_buf_1
XFILLER_23_106 VPWR VGND sg13g2_decap_8
XFILLER_52_68 VPWR VGND sg13g2_decap_8
X_170_ net33 net39 Inst_W_IO_ConfigMem.Inst_frame2_bit8.Q VPWR VGND sg13g2_dlhq_1
XFILLER_22_161 VPWR VGND sg13g2_decap_8
XFILLER_9_154 VPWR VGND sg13g2_decap_8
XFILLER_13_172 VPWR VGND sg13g2_decap_8
X_299_ net5 net156 VPWR VGND sg13g2_buf_1
XFILLER_54_4 VPWR VGND sg13g2_fill_1
XFILLER_3_40 VPWR VGND sg13g2_decap_8
XFILLER_3_95 VPWR VGND sg13g2_decap_8
XFILLER_51_201 VPWR VGND sg13g2_fill_2
XFILLER_47_68 VPWR VGND sg13g2_decap_8
XFILLER_10_175 VPWR VGND sg13g2_decap_8
X_222_ net23 net48 Inst_W_IO_ConfigMem.Inst_frame1_bit28.Q VPWR VGND sg13g2_dlhq_1
X_153_ net18 net35 Inst_W_IO_ConfigMem.Inst_frame3_bit23.Q VPWR VGND sg13g2_dlhq_1
X_084_ _031_ VPWR net102 VGND _019_ _025_ sg13g2_o21ai_1
XFILLER_6_168 VPWR VGND sg13g2_decap_8
XFILLER_17_49 VPWR VGND sg13g2_fill_1
XFILLER_3_116 VPWR VGND sg13g2_decap_8
X_136_ VGND VPWR Inst_W_IO_ConfigMem.Inst_frame0_bit24.Q _034_ _035_ Inst_W_IO_ConfigMem.Inst_frame0_bit22.Q
+ sg13g2_a21oi_1
X_205_ net5 net48 Inst_W_IO_ConfigMem.Inst_frame1_bit11.Q VPWR VGND sg13g2_dlhq_1
XFILLER_2_182 VPWR VGND sg13g2_decap_8
X_067_ Inst_W_IO_ConfigMem.Inst_frame0_bit27.Q _013_ _015_ _012_ _014_ Inst_W_IO_ConfigMem.Inst_frame0_bit26.Q
+ _016_ VPWR VGND sg13g2_mux4_1
XFILLER_31_6 VPWR VGND sg13g2_fill_1
XFILLER_0_85 VPWR VGND sg13g2_decap_8
XFILLER_44_47 VPWR VGND sg13g2_decap_8
XFILLER_47_145 VPWR VGND sg13g2_decap_8
X_119_ Inst_W_IO_ConfigMem.Inst_frame2_bit12.Q net64 net98 net91 net82 Inst_W_IO_ConfigMem.Inst_frame2_bit13.Q
+ Inst_W_IO_switch_matrix.E2BEGb1 VPWR VGND sg13g2_mux4_1
XFILLER_53_137 VPWR VGND sg13g2_fill_2
XFILLER_39_25 VPWR VGND sg13g2_decap_8
XFILLER_29_112 VPWR VGND sg13g2_decap_4
XFILLER_29_167 VPWR VGND sg13g2_decap_8
XFILLER_44_159 VPWR VGND sg13g2_decap_8
XFILLER_4_200 VPWR VGND sg13g2_fill_2
XFILLER_35_148 VPWR VGND sg13g2_decap_8
XFILLER_6_84 VPWR VGND sg13g2_decap_8
XFILLER_26_159 VPWR VGND sg13g2_decap_8
XFILLER_34_170 VPWR VGND sg13g2_decap_8
XFILLER_41_26 VPWR VGND sg13g2_decap_8
XFILLER_9_6 VPWR VGND sg13g2_fill_1
XFILLER_17_104 VPWR VGND sg13g2_fill_2
XFILLER_17_126 VPWR VGND sg13g2_fill_1
XFILLER_40_140 VPWR VGND sg13g2_decap_8
Xoutput92 net110 E2BEG[0] VPWR VGND sg13g2_buf_1
XFILLER_31_184 VPWR VGND sg13g2_decap_8
XFILLER_52_47 VPWR VGND sg13g2_decap_8
XFILLER_22_140 VPWR VGND sg13g2_decap_8
XFILLER_13_151 VPWR VGND sg13g2_decap_8
XFILLER_9_133 VPWR VGND sg13g2_decap_8
X_298_ net4 net155 VPWR VGND sg13g2_buf_1
XFILLER_42_91 VPWR VGND sg13g2_decap_8
XFILLER_47_47 VPWR VGND sg13g2_decap_8
XFILLER_10_154 VPWR VGND sg13g2_decap_8
XFILLER_6_147 VPWR VGND sg13g2_decap_8
X_083_ _031_ _030_ Inst_W_IO_ConfigMem.Inst_frame0_bit21.Q VPWR VGND sg13g2_nand2b_1
X_152_ net17 net38 Inst_W_IO_ConfigMem.Inst_frame3_bit22.Q VPWR VGND sg13g2_dlhq_1
X_221_ net22 net48 Inst_W_IO_ConfigMem.Inst_frame1_bit27.Q VPWR VGND sg13g2_dlhq_1
XFILLER_38_0 VPWR VGND sg13g2_decap_8
X_204_ net4 net48 Inst_W_IO_ConfigMem.Inst_frame1_bit10.Q VPWR VGND sg13g2_dlhq_1
X_135_ Inst_W_IO_ConfigMem.Inst_frame0_bit23.Q net61 _034_ VPWR VGND sg13g2_nor2b_1
X_066_ net70 net71 Inst_W_IO_ConfigMem.Inst_frame0_bit25.Q _015_ VPWR VGND sg13g2_mux2_1
XFILLER_2_161 VPWR VGND sg13g2_decap_8
XFILLER_0_42 VPWR VGND sg13g2_fill_2
XFILLER_0_64 VPWR VGND sg13g2_decap_8
XFILLER_44_26 VPWR VGND sg13g2_decap_8
XFILLER_47_124 VPWR VGND sg13g2_decap_8
XFILLER_50_91 VPWR VGND sg13g2_decap_8
X_118_ Inst_W_IO_ConfigMem.Inst_frame2_bit14.Q net63 net97 net90 net81 Inst_W_IO_ConfigMem.Inst_frame2_bit15.Q
+ Inst_W_IO_switch_matrix.E2BEGb2 VPWR VGND sg13g2_mux4_1
XFILLER_38_179 VPWR VGND sg13g2_decap_8
XFILLER_53_149 VPWR VGND sg13g2_fill_2
XFILLER_29_146 VPWR VGND sg13g2_decap_8
XFILLER_44_138 VPWR VGND sg13g2_decap_8
XFILLER_20_72 VPWR VGND sg13g2_fill_1
XFILLER_20_94 VPWR VGND sg13g2_decap_4
XFILLER_50_119 VPWR VGND sg13g2_decap_8
XFILLER_35_127 VPWR VGND sg13g2_decap_8
XFILLER_25_28 VPWR VGND sg13g2_decap_4
XFILLER_41_119 VPWR VGND sg13g2_decap_4
XFILLER_15_83 VPWR VGND sg13g2_fill_2
XFILLER_40_196 VPWR VGND sg13g2_decap_4
Xoutput93 net111 E2BEG[1] VPWR VGND sg13g2_buf_1
XFILLER_16_182 VPWR VGND sg13g2_decap_8
XFILLER_31_163 VPWR VGND sg13g2_decap_8
XFILLER_52_26 VPWR VGND sg13g2_decap_8
XFILLER_22_196 VPWR VGND sg13g2_decap_8
XFILLER_9_112 VPWR VGND sg13g2_decap_8
XFILLER_9_189 VPWR VGND sg13g2_decap_8
X_297_ net34 net185 VPWR VGND sg13g2_buf_1
XFILLER_42_70 VPWR VGND sg13g2_decap_8
XFILLER_3_75 VPWR VGND sg13g2_decap_8
X_258__189 VPWR VGND net207 sg13g2_tiehi
XFILLER_47_5 VPWR VGND sg13g2_decap_8
XFILLER_51_203 VPWR VGND sg13g2_fill_1
XFILLER_47_26 VPWR VGND sg13g2_decap_8
X_220_ net21 net48 Inst_W_IO_ConfigMem.Inst_frame1_bit26.Q VPWR VGND sg13g2_dlhq_1
XFILLER_42_203 VPWR VGND sg13g2_fill_1
XFILLER_10_133 VPWR VGND sg13g2_decap_8
X_151_ net105 _048_ _044_ VPWR VGND sg13g2_nand2b_1
XFILLER_6_126 VPWR VGND sg13g2_decap_8
X_082_ Inst_W_IO_ConfigMem.Inst_frame0_bit20.Q _027_ _029_ _026_ _028_ Inst_W_IO_ConfigMem.Inst_frame0_bit19.Q
+ _030_ VPWR VGND sg13g2_mux4_1
XFILLER_18_200 VPWR VGND sg13g2_fill_2
XFILLER_33_203 VPWR VGND sg13g2_fill_1
X_349_ Inst_W_IO_switch_matrix.E2BEG4 net114 VPWR VGND sg13g2_buf_1
XFILLER_33_39 VPWR VGND sg13g2_fill_2
X_203_ net34 net45 Inst_W_IO_ConfigMem.Inst_frame1_bit9.Q VPWR VGND sg13g2_dlhq_1
X_134_ _032_ VPWR _033_ VGND net73 Inst_W_IO_ConfigMem.Inst_frame0_bit23.Q sg13g2_o21ai_1
XFILLER_2_140 VPWR VGND sg13g2_decap_8
X_065_ net72 net73 Inst_W_IO_ConfigMem.Inst_frame0_bit25.Q _014_ VPWR VGND sg13g2_mux2_1
XFILLER_0_21 VPWR VGND sg13g2_decap_8
XFILLER_9_74 VPWR VGND sg13g2_fill_1
XFILLER_50_0 VPWR VGND sg13g2_decap_8
Xclkbuf_0_UserCLK UserCLK clknet_0_UserCLK VPWR VGND sg13g2_buf_8
XFILLER_47_103 VPWR VGND sg13g2_decap_8
X_117_ Inst_W_IO_ConfigMem.Inst_frame2_bit16.Q net62 net96 net89 net80 Inst_W_IO_ConfigMem.Inst_frame2_bit17.Q
+ Inst_W_IO_switch_matrix.E2BEGb3 VPWR VGND sg13g2_mux4_1
XFILLER_50_70 VPWR VGND sg13g2_decap_8
XFILLER_22_4 VPWR VGND sg13g2_fill_2
XFILLER_38_114 VPWR VGND sg13g2_fill_2
XFILLER_38_158 VPWR VGND sg13g2_decap_8
XFILLER_37_180 VPWR VGND sg13g2_decap_8
XFILLER_44_117 VPWR VGND sg13g2_decap_8
XFILLER_52_194 VPWR VGND sg13g2_fill_2
XFILLER_43_194 VPWR VGND sg13g2_decap_8
XFILLER_17_106 VPWR VGND sg13g2_fill_1
XFILLER_15_40 VPWR VGND sg13g2_fill_2
XFILLER_25_183 VPWR VGND sg13g2_decap_8
XFILLER_40_175 VPWR VGND sg13g2_decap_8
Xoutput94 net112 E2BEG[2] VPWR VGND sg13g2_buf_1
XFILLER_16_161 VPWR VGND sg13g2_decap_8
XFILLER_31_142 VPWR VGND sg13g2_decap_8
XFILLER_22_175 VPWR VGND sg13g2_decap_8
XFILLER_7_5 VPWR VGND sg13g2_decap_8
XFILLER_45_201 VPWR VGND sg13g2_fill_2
XFILLER_13_186 VPWR VGND sg13g2_decap_8
X_296_ net33 net184 VPWR VGND sg13g2_buf_1
XFILLER_9_168 VPWR VGND sg13g2_decap_8
XFILLER_3_54 VPWR VGND sg13g2_decap_8
X_150_ _046_ _047_ Inst_W_IO_ConfigMem.Inst_frame0_bit29.Q _048_ VPWR VGND sg13g2_nand3_1
XFILLER_10_189 VPWR VGND sg13g2_decap_8
XFILLER_6_105 VPWR VGND sg13g2_decap_8
XFILLER_12_30 VPWR VGND sg13g2_fill_2
X_081_ net70 net71 Inst_W_IO_ConfigMem.Inst_frame0_bit18.Q _029_ VPWR VGND sg13g2_mux2_1
XFILLER_53_70 VPWR VGND sg13g2_decap_8
X_348_ Inst_W_IO_switch_matrix.E2BEG3 net113 VPWR VGND sg13g2_buf_1
X_279_ Inst_W_IO_switch_matrix.EE4BEG7 net151 VPWR VGND sg13g2_buf_1
XFILLER_5_193 VPWR VGND sg13g2_decap_8
X_133_ _032_ Inst_W_IO_ConfigMem.Inst_frame0_bit23.Q net59 VPWR VGND sg13g2_nand2b_1
X_202_ net33 net45 Inst_W_IO_ConfigMem.Inst_frame1_bit8.Q VPWR VGND sg13g2_dlhq_1
X_064_ net66 net67 Inst_W_IO_ConfigMem.Inst_frame0_bit25.Q _013_ VPWR VGND sg13g2_mux2_1
XFILLER_0_44 VPWR VGND sg13g2_fill_1
XFILLER_2_196 VPWR VGND sg13g2_fill_1
XFILLER_0_99 VPWR VGND sg13g2_decap_8
XFILLER_47_159 VPWR VGND sg13g2_decap_8
XFILLER_7_200 VPWR VGND sg13g2_fill_2
X_116_ Inst_W_IO_ConfigMem.Inst_frame2_bit18.Q net61 net95 net88 net79 Inst_W_IO_ConfigMem.Inst_frame2_bit19.Q
+ Inst_W_IO_switch_matrix.E2BEGb4 VPWR VGND sg13g2_mux4_1
XFILLER_38_137 VPWR VGND sg13g2_decap_8
XFILLER_39_39 VPWR VGND sg13g2_decap_8
XFILLER_52_173 VPWR VGND sg13g2_decap_8
XFILLER_20_63 VPWR VGND sg13g2_decap_8
XFILLER_43_173 VPWR VGND sg13g2_decap_8
XFILLER_45_82 VPWR VGND sg13g2_decap_8
XFILLER_6_98 VPWR VGND sg13g2_decap_8
XFILLER_19_192 VPWR VGND sg13g2_decap_8
XFILLER_34_184 VPWR VGND sg13g2_decap_8
XFILLER_25_162 VPWR VGND sg13g2_decap_8
XFILLER_40_154 VPWR VGND sg13g2_decap_8
Xoutput84 net102 A_I_top VPWR VGND sg13g2_buf_1
Xoutput95 net113 E2BEG[3] VPWR VGND sg13g2_buf_1
XFILLER_16_140 VPWR VGND sg13g2_decap_8
XFILLER_31_198 VPWR VGND sg13g2_decap_4
XFILLER_22_154 VPWR VGND sg13g2_fill_2
XFILLER_26_40 VPWR VGND sg13g2_fill_1
XFILLER_9_147 VPWR VGND sg13g2_decap_8
XFILLER_13_165 VPWR VGND sg13g2_decap_8
X_295_ net32 net183 VPWR VGND sg13g2_buf_1
XFILLER_3_33 VPWR VGND sg13g2_decap_8
XFILLER_27_202 VPWR VGND sg13g2_fill_2
XFILLER_10_168 VPWR VGND sg13g2_decap_8
X_080_ net72 net73 Inst_W_IO_ConfigMem.Inst_frame0_bit18.Q _028_ VPWR VGND sg13g2_mux2_1
X_347_ Inst_W_IO_switch_matrix.E2BEG2 net112 VPWR VGND sg13g2_buf_1
X_278_ Inst_W_IO_switch_matrix.EE4BEG6 net150 VPWR VGND sg13g2_buf_1
XFILLER_52_5 VPWR VGND sg13g2_decap_8
XFILLER_5_172 VPWR VGND sg13g2_decap_8
XFILLER_3_109 VPWR VGND sg13g2_decap_8
X_063_ net68 net69 Inst_W_IO_ConfigMem.Inst_frame0_bit25.Q _012_ VPWR VGND sg13g2_mux2_1
X_201_ net32 net45 Inst_W_IO_ConfigMem.Inst_frame1_bit7.Q VPWR VGND sg13g2_dlhq_1
X_132_ net57 net1 Inst_W_IO_ConfigMem.Inst_frame3_bit22.Q Inst_W_IO_switch_matrix.E1BEG0
+ VPWR VGND sg13g2_mux2_1
XFILLER_2_175 VPWR VGND sg13g2_decap_8
XFILLER_0_78 VPWR VGND sg13g2_decap_8
XFILLER_17_8 VPWR VGND sg13g2_fill_1
XFILLER_48_82 VPWR VGND sg13g2_decap_8
XFILLER_18_30 VPWR VGND sg13g2_fill_2
XFILLER_47_138 VPWR VGND sg13g2_decap_8
X_115_ Inst_W_IO_ConfigMem.Inst_frame2_bit20.Q net60 net94 net87 net78 Inst_W_IO_ConfigMem.Inst_frame2_bit21.Q
+ Inst_W_IO_switch_matrix.E2BEGb5 VPWR VGND sg13g2_mux4_1
XFILLER_22_6 VPWR VGND sg13g2_fill_1
XFILLER_38_116 VPWR VGND sg13g2_fill_1
XFILLER_53_108 VPWR VGND sg13g2_decap_8
XFILLER_46_182 VPWR VGND sg13g2_decap_8
XFILLER_39_18 VPWR VGND sg13g2_decap_8
XFILLER_29_105 VPWR VGND sg13g2_decap_8
XFILLER_52_152 VPWR VGND sg13g2_decap_8
XFILLER_29_62 VPWR VGND sg13g2_decap_8
XFILLER_28_193 VPWR VGND sg13g2_decap_8
XFILLER_43_152 VPWR VGND sg13g2_decap_8
XFILLER_45_61 VPWR VGND sg13g2_decap_8
XFILLER_19_171 VPWR VGND sg13g2_decap_8
XFILLER_34_163 VPWR VGND sg13g2_decap_8
XFILLER_41_19 VPWR VGND sg13g2_decap_8
XFILLER_40_133 VPWR VGND sg13g2_decap_8
XFILLER_31_74 VPWR VGND sg13g2_fill_2
Xoutput85 net103 A_T_top VPWR VGND sg13g2_buf_1
Xoutput96 net114 E2BEG[4] VPWR VGND sg13g2_buf_1
XFILLER_16_196 VPWR VGND sg13g2_decap_4
XFILLER_31_177 VPWR VGND sg13g2_decap_8
.ends
