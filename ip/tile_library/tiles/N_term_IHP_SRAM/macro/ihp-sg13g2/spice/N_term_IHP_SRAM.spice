* NGSPICE file created from N_term_IHP_SRAM.ext - technology: ihp-sg13g2

* Black-box entry subcircuit for sg13g2_decap_8 abstract view
.subckt sg13g2_decap_8 VDD VSS
.ends

* Black-box entry subcircuit for sg13g2_buf_1 abstract view
.subckt sg13g2_buf_1 A X VDD VSS
.ends

* Black-box entry subcircuit for sg13g2_decap_4 abstract view
.subckt sg13g2_decap_4 VDD VSS
.ends

* Black-box entry subcircuit for sg13g2_fill_1 abstract view
.subckt sg13g2_fill_1 VDD VSS
.ends

* Black-box entry subcircuit for sg13g2_fill_2 abstract view
.subckt sg13g2_fill_2 VDD VSS
.ends

.subckt N_term_IHP_SRAM FrameData[0] FrameData[10] FrameData[11] FrameData[12] FrameData[13]
+ FrameData[14] FrameData[15] FrameData[16] FrameData[17] FrameData[18] FrameData[19]
+ FrameData[1] FrameData[20] FrameData[21] FrameData[22] FrameData[23] FrameData[24]
+ FrameData[25] FrameData[26] FrameData[27] FrameData[28] FrameData[29] FrameData[2]
+ FrameData[30] FrameData[31] FrameData[3] FrameData[4] FrameData[5] FrameData[6]
+ FrameData[7] FrameData[8] FrameData[9] FrameData_O[0] FrameData_O[10] FrameData_O[11]
+ FrameData_O[12] FrameData_O[13] FrameData_O[14] FrameData_O[15] FrameData_O[16]
+ FrameData_O[17] FrameData_O[18] FrameData_O[19] FrameData_O[1] FrameData_O[20] FrameData_O[21]
+ FrameData_O[22] FrameData_O[23] FrameData_O[24] FrameData_O[25] FrameData_O[26]
+ FrameData_O[27] FrameData_O[28] FrameData_O[29] FrameData_O[2] FrameData_O[30] FrameData_O[31]
+ FrameData_O[3] FrameData_O[4] FrameData_O[5] FrameData_O[6] FrameData_O[7] FrameData_O[8]
+ FrameData_O[9] FrameStrobe[0] FrameStrobe[10] FrameStrobe[11] FrameStrobe[12] FrameStrobe[13]
+ FrameStrobe[14] FrameStrobe[15] FrameStrobe[16] FrameStrobe[17] FrameStrobe[18]
+ FrameStrobe[19] FrameStrobe[1] FrameStrobe[2] FrameStrobe[3] FrameStrobe[4] FrameStrobe[5]
+ FrameStrobe[6] FrameStrobe[7] FrameStrobe[8] FrameStrobe[9] FrameStrobe_O[0] FrameStrobe_O[10]
+ FrameStrobe_O[11] FrameStrobe_O[12] FrameStrobe_O[13] FrameStrobe_O[14] FrameStrobe_O[15]
+ FrameStrobe_O[16] FrameStrobe_O[17] FrameStrobe_O[18] FrameStrobe_O[19] FrameStrobe_O[1]
+ FrameStrobe_O[2] FrameStrobe_O[3] FrameStrobe_O[4] FrameStrobe_O[5] FrameStrobe_O[6]
+ FrameStrobe_O[7] FrameStrobe_O[8] FrameStrobe_O[9] N1END[0] N1END[1] N1END[2] N1END[3]
+ N2END[0] N2END[1] N2END[2] N2END[3] N2END[4] N2END[5] N2END[6] N2END[7] N2MID[0]
+ N2MID[1] N2MID[2] N2MID[3] N2MID[4] N2MID[5] N2MID[6] N2MID[7] N4END[0] N4END[10]
+ N4END[11] N4END[12] N4END[13] N4END[14] N4END[15] N4END[1] N4END[2] N4END[3] N4END[4]
+ N4END[5] N4END[6] N4END[7] N4END[8] N4END[9] S1BEG[0] S1BEG[1] S1BEG[2] S1BEG[3]
+ S2BEG[0] S2BEG[1] S2BEG[2] S2BEG[3] S2BEG[4] S2BEG[5] S2BEG[6] S2BEG[7] S2BEGb[0]
+ S2BEGb[1] S2BEGb[2] S2BEGb[3] S2BEGb[4] S2BEGb[5] S2BEGb[6] S2BEGb[7] S4BEG[0] S4BEG[10]
+ S4BEG[11] S4BEG[12] S4BEG[13] S4BEG[14] S4BEG[15] S4BEG[1] S4BEG[2] S4BEG[3] S4BEG[4]
+ S4BEG[5] S4BEG[6] S4BEG[7] S4BEG[8] S4BEG[9] UserCLK UserCLKo VGND VPWR
XFILLER_7_7 VPWR VGND sg13g2_decap_8
X_83_ N4END[4] net75 VPWR VGND sg13g2_buf_1
XFILLER_3_56 VPWR VGND sg13g2_decap_8
XFILLER_8_192 VPWR VGND sg13g2_decap_8
X_66_ N2END[5] net67 VPWR VGND sg13g2_buf_1
XFILLER_5_151 VPWR VGND sg13g2_decap_8
XFILLER_5_184 VPWR VGND sg13g2_decap_8
XFILLER_5_195 VPWR VGND sg13g2_decap_4
XFILLER_9_77 VPWR VGND sg13g2_decap_8
XFILLER_0_35 VPWR VGND sg13g2_decap_8
XFILLER_2_176 VPWR VGND sg13g2_decap_8
X_49_ FrameStrobe[17] net41 VPWR VGND sg13g2_buf_1
XFILLER_6_89 VPWR VGND sg13g2_fill_1
Xoutput42 net42 FrameStrobe_O[18] VPWR VGND sg13g2_buf_1
Xoutput20 net20 FrameData_O[27] VPWR VGND sg13g2_buf_1
Xoutput75 net75 S4BEG[11] VPWR VGND sg13g2_buf_1
Xoutput64 net64 S2BEG[7] VPWR VGND sg13g2_buf_1
Xoutput86 net86 S4BEG[7] VPWR VGND sg13g2_buf_1
Xoutput31 net31 FrameData_O[8] VPWR VGND sg13g2_buf_1
Xoutput53 net53 S1BEG[0] VPWR VGND sg13g2_buf_1
Xoutput7 net7 FrameData_O[15] VPWR VGND sg13g2_buf_1
XFILLER_11_0 VPWR VGND sg13g2_decap_8
XFILLER_3_35 VPWR VGND sg13g2_decap_8
X_82_ N4END[5] net74 VPWR VGND sg13g2_buf_1
XFILLER_8_171 VPWR VGND sg13g2_decap_8
XFILLER_10_159 VPWR VGND sg13g2_decap_8
X_65_ N2END[6] net66 VPWR VGND sg13g2_buf_1
XFILLER_9_56 VPWR VGND sg13g2_decap_8
XFILLER_0_14 VPWR VGND sg13g2_decap_8
XFILLER_2_111 VPWR VGND sg13g2_decap_8
XFILLER_2_155 VPWR VGND sg13g2_decap_8
X_48_ FrameStrobe[16] net40 VPWR VGND sg13g2_buf_1
XFILLER_4_206 VPWR VGND sg13g2_fill_2
XFILLER_6_35 VPWR VGND sg13g2_decap_8
XFILLER_6_79 VPWR VGND sg13g2_decap_4
Xoutput43 net43 FrameStrobe_O[19] VPWR VGND sg13g2_buf_1
Xoutput21 net21 FrameData_O[28] VPWR VGND sg13g2_buf_1
Xoutput87 net87 S4BEG[8] VPWR VGND sg13g2_buf_1
Xoutput65 net65 S2BEGb[0] VPWR VGND sg13g2_buf_1
Xoutput54 net54 S1BEG[1] VPWR VGND sg13g2_buf_1
Xoutput76 net76 S4BEG[12] VPWR VGND sg13g2_buf_1
Xoutput32 net32 FrameData_O[9] VPWR VGND sg13g2_buf_1
Xoutput8 net8 FrameData_O[16] VPWR VGND sg13g2_buf_1
Xoutput10 net10 FrameData_O[18] VPWR VGND sg13g2_buf_1
XFILLER_9_139 VPWR VGND sg13g2_decap_8
X_81_ N4END[6] net88 VPWR VGND sg13g2_buf_1
XFILLER_3_14 VPWR VGND sg13g2_decap_8
XFILLER_8_150 VPWR VGND sg13g2_decap_8
XFILLER_10_138 VPWR VGND sg13g2_decap_8
XFILLER_10_105 VPWR VGND sg13g2_fill_2
X_64_ N2END[7] net65 VPWR VGND sg13g2_buf_1
XFILLER_5_131 VPWR VGND sg13g2_decap_8
XFILLER_9_35 VPWR VGND sg13g2_decap_8
XFILLER_2_101 VPWR VGND sg13g2_fill_2
X_47_ FrameStrobe[15] net39 VPWR VGND sg13g2_buf_1
XFILLER_11_211 VPWR VGND sg13g2_fill_1
XFILLER_7_204 VPWR VGND sg13g2_decap_4
XFILLER_1_0 VPWR VGND sg13g2_decap_8
XFILLER_6_14 VPWR VGND sg13g2_decap_8
XFILLER_6_58 VPWR VGND sg13g2_decap_8
Xoutput44 net44 FrameStrobe_O[1] VPWR VGND sg13g2_buf_1
Xoutput33 net33 FrameStrobe_O[0] VPWR VGND sg13g2_buf_1
Xoutput22 net22 FrameData_O[29] VPWR VGND sg13g2_buf_1
Xoutput88 net88 S4BEG[9] VPWR VGND sg13g2_buf_1
Xoutput77 net77 S4BEG[13] VPWR VGND sg13g2_buf_1
Xoutput66 net66 S2BEGb[1] VPWR VGND sg13g2_buf_1
Xoutput55 net55 S1BEG[2] VPWR VGND sg13g2_buf_1
Xoutput9 net9 FrameData_O[17] VPWR VGND sg13g2_buf_1
Xoutput11 net11 FrameData_O[19] VPWR VGND sg13g2_buf_1
XFILLER_9_118 VPWR VGND sg13g2_decap_8
X_80_ N4END[7] net87 VPWR VGND sg13g2_buf_1
XFILLER_10_117 VPWR VGND sg13g2_decap_8
XFILLER_5_7 VPWR VGND sg13g2_decap_8
X_63_ N2MID[0] net64 VPWR VGND sg13g2_buf_1
XFILLER_4_80 VPWR VGND sg13g2_decap_8
X_46_ FrameStrobe[14] net38 VPWR VGND sg13g2_buf_1
XFILLER_9_14 VPWR VGND sg13g2_decap_8
XFILLER_11_201 VPWR VGND sg13g2_fill_2
X_29_ FrameData[29] net22 VPWR VGND sg13g2_buf_1
Xoutput34 net34 FrameStrobe_O[10] VPWR VGND sg13g2_buf_1
Xoutput45 net45 FrameStrobe_O[2] VPWR VGND sg13g2_buf_1
Xoutput89 net89 UserCLKo VPWR VGND sg13g2_buf_1
Xoutput23 net23 FrameData_O[2] VPWR VGND sg13g2_buf_1
Xoutput12 net12 FrameData_O[1] VPWR VGND sg13g2_buf_1
Xoutput78 net78 S4BEG[14] VPWR VGND sg13g2_buf_1
Xoutput67 net67 S2BEGb[2] VPWR VGND sg13g2_buf_1
Xoutput56 net56 S1BEG[3] VPWR VGND sg13g2_buf_1
XFILLER_7_91 VPWR VGND sg13g2_fill_1
XFILLER_3_49 VPWR VGND sg13g2_decap_8
XFILLER_8_185 VPWR VGND sg13g2_decap_8
XFILLER_5_122 VPWR VGND sg13g2_fill_1
X_62_ N2MID[1] net63 VPWR VGND sg13g2_buf_1
XFILLER_5_177 VPWR VGND sg13g2_decap_8
XFILLER_5_199 VPWR VGND sg13g2_fill_2
XFILLER_2_125 VPWR VGND sg13g2_fill_2
XFILLER_2_169 VPWR VGND sg13g2_decap_8
XFILLER_4_70 VPWR VGND sg13g2_decap_4
XFILLER_0_28 VPWR VGND sg13g2_decap_8
X_45_ FrameStrobe[13] net37 VPWR VGND sg13g2_buf_1
X_28_ FrameData[28] net21 VPWR VGND sg13g2_buf_1
XFILLER_10_91 VPWR VGND sg13g2_decap_8
XFILLER_6_49 VPWR VGND sg13g2_decap_4
Xoutput35 net35 FrameStrobe_O[11] VPWR VGND sg13g2_buf_1
Xoutput46 net46 FrameStrobe_O[3] VPWR VGND sg13g2_buf_1
Xoutput24 net24 FrameData_O[30] VPWR VGND sg13g2_buf_1
Xoutput57 net57 S2BEG[0] VPWR VGND sg13g2_buf_1
Xoutput13 net13 FrameData_O[20] VPWR VGND sg13g2_buf_1
Xoutput79 net79 S4BEG[15] VPWR VGND sg13g2_buf_1
Xoutput68 net68 S2BEGb[3] VPWR VGND sg13g2_buf_1
XFILLER_7_70 VPWR VGND sg13g2_decap_8
XFILLER_3_28 VPWR VGND sg13g2_decap_8
XFILLER_8_164 VPWR VGND sg13g2_decap_8
X_61_ N2MID[2] net62 VPWR VGND sg13g2_buf_1
XFILLER_5_101 VPWR VGND sg13g2_fill_2
XFILLER_5_112 VPWR VGND sg13g2_fill_2
XFILLER_5_145 VPWR VGND sg13g2_fill_2
XFILLER_9_49 VPWR VGND sg13g2_decap_8
XFILLER_1_181 VPWR VGND sg13g2_decap_8
X_44_ FrameStrobe[12] net36 VPWR VGND sg13g2_buf_1
X_27_ FrameData[27] net20 VPWR VGND sg13g2_buf_1
XFILLER_10_70 VPWR VGND sg13g2_decap_8
XFILLER_6_28 VPWR VGND sg13g2_decap_8
Xoutput36 net36 FrameStrobe_O[12] VPWR VGND sg13g2_buf_1
Xoutput47 net47 FrameStrobe_O[4] VPWR VGND sg13g2_buf_1
Xoutput14 net14 FrameData_O[21] VPWR VGND sg13g2_buf_1
Xoutput25 net25 FrameData_O[31] VPWR VGND sg13g2_buf_1
Xoutput69 net69 S2BEGb[4] VPWR VGND sg13g2_buf_1
Xoutput58 net58 S2BEG[1] VPWR VGND sg13g2_buf_1
XFILLER_8_143 VPWR VGND sg13g2_decap_8
X_60_ N2MID[3] net61 VPWR VGND sg13g2_buf_1
XFILLER_4_94 VPWR VGND sg13g2_decap_4
XFILLER_3_7 VPWR VGND sg13g2_decap_8
XFILLER_9_28 VPWR VGND sg13g2_decap_8
X_43_ FrameStrobe[11] net35 VPWR VGND sg13g2_buf_1
X_26_ FrameData[26] net19 VPWR VGND sg13g2_buf_1
X_09_ FrameData[9] net32 VPWR VGND sg13g2_buf_1
Xoutput37 net37 FrameStrobe_O[13] VPWR VGND sg13g2_buf_1
Xoutput48 net48 FrameStrobe_O[5] VPWR VGND sg13g2_buf_1
Xoutput15 net15 FrameData_O[22] VPWR VGND sg13g2_buf_1
Xoutput26 net26 FrameData_O[3] VPWR VGND sg13g2_buf_1
Xoutput59 net59 S2BEG[2] VPWR VGND sg13g2_buf_1
XFILLER_8_122 VPWR VGND sg13g2_decap_8
XFILLER_8_199 VPWR VGND sg13g2_decap_8
XFILLER_5_103 VPWR VGND sg13g2_fill_1
XFILLER_5_158 VPWR VGND sg13g2_decap_8
XFILLER_5_169 VPWR VGND sg13g2_decap_4
X_42_ FrameStrobe[10] net34 VPWR VGND sg13g2_buf_1
X_25_ FrameData[25] net18 VPWR VGND sg13g2_buf_1
X_08_ FrameData[8] net31 VPWR VGND sg13g2_buf_1
Xoutput38 net38 FrameStrobe_O[14] VPWR VGND sg13g2_buf_1
Xoutput49 net49 FrameStrobe_O[6] VPWR VGND sg13g2_buf_1
Xoutput16 net16 FrameData_O[23] VPWR VGND sg13g2_buf_1
Xoutput27 net27 FrameData_O[4] VPWR VGND sg13g2_buf_1
XFILLER_7_84 VPWR VGND sg13g2_decap_8
XFILLER_8_178 VPWR VGND sg13g2_decap_8
XFILLER_4_63 VPWR VGND sg13g2_decap_8
XFILLER_4_74 VPWR VGND sg13g2_fill_2
XFILLER_4_181 VPWR VGND sg13g2_decap_8
XFILLER_2_118 VPWR VGND sg13g2_decap_8
XFILLER_1_195 VPWR VGND sg13g2_decap_8
X_41_ FrameStrobe[9] net52 VPWR VGND sg13g2_buf_1
X_24_ FrameData[24] net17 VPWR VGND sg13g2_buf_1
XFILLER_1_42 VPWR VGND sg13g2_decap_8
XFILLER_10_84 VPWR VGND sg13g2_decap_8
Xoutput39 net39 FrameStrobe_O[15] VPWR VGND sg13g2_buf_1
Xoutput17 net17 FrameData_O[24] VPWR VGND sg13g2_buf_1
Xoutput28 net28 FrameData_O[5] VPWR VGND sg13g2_buf_1
X_07_ FrameData[7] net30 VPWR VGND sg13g2_buf_1
XFILLER_7_63 VPWR VGND sg13g2_decap_8
XFILLER_8_102 VPWR VGND sg13g2_fill_2
XFILLER_8_157 VPWR VGND sg13g2_decap_8
XFILLER_5_138 VPWR VGND sg13g2_decap_8
XFILLER_7_190 VPWR VGND sg13g2_decap_8
XFILLER_4_42 VPWR VGND sg13g2_decap_8
XFILLER_4_160 VPWR VGND sg13g2_decap_8
XFILLER_1_174 VPWR VGND sg13g2_decap_8
X_40_ FrameStrobe[8] net51 VPWR VGND sg13g2_buf_1
XFILLER_8_0 VPWR VGND sg13g2_decap_8
XFILLER_1_7 VPWR VGND sg13g2_decap_8
X_23_ FrameData[23] net16 VPWR VGND sg13g2_buf_1
XFILLER_1_21 VPWR VGND sg13g2_decap_8
XFILLER_10_63 VPWR VGND sg13g2_decap_8
XFILLER_3_203 VPWR VGND sg13g2_decap_4
Xoutput18 net18 FrameData_O[25] VPWR VGND sg13g2_buf_1
Xoutput29 net29 FrameData_O[6] VPWR VGND sg13g2_buf_1
X_06_ FrameData[6] net29 VPWR VGND sg13g2_buf_1
XFILLER_7_42 VPWR VGND sg13g2_decap_8
XFILLER_8_136 VPWR VGND sg13g2_decap_8
XFILLER_4_21 VPWR VGND sg13g2_decap_8
XFILLER_4_87 VPWR VGND sg13g2_decap_8
XFILLER_4_98 VPWR VGND sg13g2_fill_1
X_22_ FrameData[22] net15 VPWR VGND sg13g2_buf_1
XFILLER_10_42 VPWR VGND sg13g2_decap_8
X_05_ FrameData[5] net28 VPWR VGND sg13g2_buf_1
Xoutput19 net19 FrameData_O[26] VPWR VGND sg13g2_buf_1
XFILLER_7_21 VPWR VGND sg13g2_decap_8
XFILLER_8_115 VPWR VGND sg13g2_decap_8
XFILLER_5_118 VPWR VGND sg13g2_decap_4
XFILLER_4_195 VPWR VGND sg13g2_decap_8
X_21_ FrameData[21] net14 VPWR VGND sg13g2_buf_1
XFILLER_10_98 VPWR VGND sg13g2_decap_8
XFILLER_10_21 VPWR VGND sg13g2_decap_8
X_04_ FrameData[4] net27 VPWR VGND sg13g2_buf_1
XFILLER_7_77 VPWR VGND sg13g2_decap_8
XFILLER_5_108 VPWR VGND sg13g2_decap_4
XFILLER_4_56 VPWR VGND sg13g2_decap_8
XFILLER_4_174 VPWR VGND sg13g2_decap_8
XFILLER_1_188 VPWR VGND sg13g2_decap_8
XFILLER_6_0 VPWR VGND sg13g2_decap_8
XFILLER_6_203 VPWR VGND sg13g2_decap_4
XFILLER_1_35 VPWR VGND sg13g2_decap_8
X_20_ FrameData[20] net13 VPWR VGND sg13g2_buf_1
XFILLER_10_77 VPWR VGND sg13g2_decap_8
X_03_ FrameData[3] net26 VPWR VGND sg13g2_buf_1
XFILLER_7_56 VPWR VGND sg13g2_decap_8
XFILLER_7_183 VPWR VGND sg13g2_decap_8
XFILLER_4_35 VPWR VGND sg13g2_decap_8
XFILLER_4_153 VPWR VGND sg13g2_decap_8
XFILLER_1_167 VPWR VGND sg13g2_decap_8
XFILLER_1_14 VPWR VGND sg13g2_decap_8
XFILLER_10_56 VPWR VGND sg13g2_decap_8
X_79_ N4END[8] net86 VPWR VGND sg13g2_buf_1
XFILLER_3_207 VPWR VGND sg13g2_fill_1
X_02_ FrameData[2] net23 VPWR VGND sg13g2_buf_1
XFILLER_7_35 VPWR VGND sg13g2_decap_8
XFILLER_11_191 VPWR VGND sg13g2_fill_2
XFILLER_8_129 VPWR VGND sg13g2_decap_8
XFILLER_7_162 VPWR VGND sg13g2_decap_8
XFILLER_4_14 VPWR VGND sg13g2_decap_8
XFILLER_4_132 VPWR VGND sg13g2_decap_8
XFILLER_9_202 VPWR VGND sg13g2_fill_2
X_78_ N4END[9] net85 VPWR VGND sg13g2_buf_1
XFILLER_10_35 VPWR VGND sg13g2_decap_8
X_01_ FrameData[1] net12 VPWR VGND sg13g2_buf_1
XFILLER_7_14 VPWR VGND sg13g2_decap_8
XFILLER_8_108 VPWR VGND sg13g2_decap_8
XFILLER_11_181 VPWR VGND sg13g2_decap_4
XFILLER_7_141 VPWR VGND sg13g2_decap_8
XFILLER_4_111 VPWR VGND sg13g2_decap_8
XFILLER_4_188 VPWR VGND sg13g2_decap_8
XFILLER_0_180 VPWR VGND sg13g2_decap_8
XFILLER_5_91 VPWR VGND sg13g2_decap_4
XFILLER_1_49 VPWR VGND sg13g2_fill_1
X_77_ N4END[10] net84 VPWR VGND sg13g2_buf_1
XFILLER_10_14 VPWR VGND sg13g2_decap_8
X_00_ FrameData[0] net1 VPWR VGND sg13g2_buf_1
XFILLER_4_0 VPWR VGND sg13g2_decap_8
XFILLER_11_171 VPWR VGND sg13g2_decap_4
XFILLER_7_120 VPWR VGND sg13g2_decap_8
XFILLER_7_197 VPWR VGND sg13g2_decap_8
XFILLER_8_91 VPWR VGND sg13g2_decap_8
XFILLER_4_49 VPWR VGND sg13g2_decap_8
XFILLER_4_167 VPWR VGND sg13g2_decap_8
XFILLER_8_7 VPWR VGND sg13g2_decap_8
XFILLER_5_70 VPWR VGND sg13g2_decap_8
XFILLER_1_28 VPWR VGND sg13g2_decap_8
XFILLER_6_207 VPWR VGND sg13g2_fill_1
X_76_ N4END[11] net83 VPWR VGND sg13g2_buf_1
X_59_ N2MID[4] net60 VPWR VGND sg13g2_buf_1
XFILLER_7_49 VPWR VGND sg13g2_decap_8
XFILLER_11_91 VPWR VGND sg13g2_fill_2
XFILLER_11_161 VPWR VGND sg13g2_decap_4
XFILLER_7_176 VPWR VGND sg13g2_decap_8
XFILLER_8_70 VPWR VGND sg13g2_decap_8
XFILLER_4_28 VPWR VGND sg13g2_decap_8
XFILLER_4_146 VPWR VGND sg13g2_decap_8
XFILLER_10_49 VPWR VGND sg13g2_decap_8
X_75_ N4END[12] net82 VPWR VGND sg13g2_buf_1
X_58_ N2MID[5] net59 VPWR VGND sg13g2_buf_1
XFILLER_2_83 VPWR VGND sg13g2_fill_1
XFILLER_11_81 VPWR VGND sg13g2_decap_4
XFILLER_7_28 VPWR VGND sg13g2_decap_8
XFILLER_11_151 VPWR VGND sg13g2_decap_4
XFILLER_7_155 VPWR VGND sg13g2_decap_8
XFILLER_4_125 VPWR VGND sg13g2_decap_8
XFILLER_0_194 VPWR VGND sg13g2_decap_4
X_74_ N4END[13] net81 VPWR VGND sg13g2_buf_1
XFILLER_10_28 VPWR VGND sg13g2_decap_8
X_57_ N2MID[6] net58 VPWR VGND sg13g2_buf_1
XFILLER_11_93 VPWR VGND sg13g2_fill_1
XFILLER_11_71 VPWR VGND sg13g2_decap_4
XFILLER_2_0 VPWR VGND sg13g2_decap_8
XFILLER_11_185 VPWR VGND sg13g2_fill_2
XFILLER_11_141 VPWR VGND sg13g2_decap_4
XFILLER_7_134 VPWR VGND sg13g2_decap_8
XFILLER_1_118 VPWR VGND sg13g2_fill_1
XFILLER_0_173 VPWR VGND sg13g2_decap_8
XFILLER_5_84 VPWR VGND sg13g2_decap_8
XFILLER_5_95 VPWR VGND sg13g2_fill_2
XFILLER_6_7 VPWR VGND sg13g2_decap_8
X_73_ N4END[14] net80 VPWR VGND sg13g2_buf_1
X_56_ N2MID[7] net57 VPWR VGND sg13g2_buf_1
XFILLER_2_63 VPWR VGND sg13g2_decap_4
XFILLER_2_96 VPWR VGND sg13g2_fill_1
XFILLER_11_61 VPWR VGND sg13g2_decap_4
X_39_ FrameStrobe[7] net50 VPWR VGND sg13g2_buf_1
XFILLER_11_175 VPWR VGND sg13g2_fill_2
XFILLER_11_131 VPWR VGND sg13g2_decap_4
XFILLER_8_84 VPWR VGND sg13g2_decap_8
XFILLER_3_182 VPWR VGND sg13g2_decap_8
XFILLER_5_63 VPWR VGND sg13g2_decap_8
XFILLER_10_0 VPWR VGND sg13g2_decap_8
X_72_ N4END[15] net73 VPWR VGND sg13g2_buf_1
X_55_ N1END[0] net56 VPWR VGND sg13g2_buf_1
XFILLER_2_42 VPWR VGND sg13g2_decap_8
XFILLER_11_51 VPWR VGND sg13g2_decap_4
X_38_ FrameStrobe[6] net49 VPWR VGND sg13g2_buf_1
XFILLER_11_165 VPWR VGND sg13g2_fill_2
XFILLER_7_169 VPWR VGND sg13g2_decap_8
XFILLER_6_180 VPWR VGND sg13g2_fill_1
XFILLER_8_63 VPWR VGND sg13g2_decap_8
XFILLER_4_139 VPWR VGND sg13g2_decap_8
XFILLER_3_161 VPWR VGND sg13g2_decap_8
XFILLER_5_42 VPWR VGND sg13g2_decap_8
X_71_ N2END[0] net72 VPWR VGND sg13g2_buf_1
XFILLER_2_204 VPWR VGND sg13g2_decap_4
X_54_ N1END[1] net55 VPWR VGND sg13g2_buf_1
XFILLER_2_21 VPWR VGND sg13g2_decap_8
XFILLER_11_41 VPWR VGND sg13g2_decap_4
XFILLER_11_85 VPWR VGND sg13g2_fill_2
X_37_ FrameStrobe[5] net48 VPWR VGND sg13g2_buf_1
XFILLER_11_155 VPWR VGND sg13g2_fill_2
XFILLER_0_0 VPWR VGND sg13g2_decap_8
XFILLER_7_148 VPWR VGND sg13g2_decap_8
XFILLER_6_192 VPWR VGND sg13g2_decap_8
XFILLER_8_42 VPWR VGND sg13g2_decap_8
XFILLER_4_118 VPWR VGND sg13g2_decap_8
XFILLER_3_140 VPWR VGND sg13g2_decap_8
XFILLER_0_198 VPWR VGND sg13g2_fill_2
XFILLER_0_187 VPWR VGND sg13g2_decap_8
XFILLER_5_21 VPWR VGND sg13g2_decap_8
X_70_ N2END[1] net71 VPWR VGND sg13g2_buf_1
XFILLER_4_7 VPWR VGND sg13g2_decap_8
X_53_ N1END[2] net54 VPWR VGND sg13g2_buf_1
XFILLER_11_75 VPWR VGND sg13g2_fill_2
XFILLER_11_31 VPWR VGND sg13g2_decap_4
X_36_ FrameStrobe[4] net47 VPWR VGND sg13g2_buf_1
XFILLER_11_145 VPWR VGND sg13g2_fill_2
XFILLER_11_123 VPWR VGND sg13g2_decap_4
XFILLER_7_127 VPWR VGND sg13g2_decap_8
XFILLER_8_21 VPWR VGND sg13g2_decap_8
XFILLER_8_98 VPWR VGND sg13g2_decap_4
X_19_ FrameData[19] net11 VPWR VGND sg13g2_buf_1
XFILLER_3_196 VPWR VGND sg13g2_decap_8
XFILLER_5_77 VPWR VGND sg13g2_decap_8
X_52_ N1END[3] net53 VPWR VGND sg13g2_buf_1
XFILLER_2_56 VPWR VGND sg13g2_decap_8
XFILLER_11_65 VPWR VGND sg13g2_fill_2
XFILLER_11_21 VPWR VGND sg13g2_decap_4
X_35_ FrameStrobe[3] net46 VPWR VGND sg13g2_buf_1
XFILLER_11_135 VPWR VGND sg13g2_fill_2
XFILLER_8_77 VPWR VGND sg13g2_decap_8
X_18_ FrameData[18] net10 VPWR VGND sg13g2_buf_1
XFILLER_3_175 VPWR VGND sg13g2_decap_8
XFILLER_5_56 VPWR VGND sg13g2_decap_8
XFILLER_2_35 VPWR VGND sg13g2_decap_8
X_51_ FrameStrobe[19] net43 VPWR VGND sg13g2_buf_1
XFILLER_11_55 VPWR VGND sg13g2_fill_2
XFILLER_11_11 VPWR VGND sg13g2_decap_4
X_34_ FrameStrobe[2] net45 VPWR VGND sg13g2_buf_1
XFILLER_11_114 VPWR VGND sg13g2_fill_1
XFILLER_9_181 VPWR VGND sg13g2_decap_8
XFILLER_8_56 VPWR VGND sg13g2_decap_8
XFILLER_10_180 VPWR VGND sg13g2_decap_8
XFILLER_6_162 VPWR VGND sg13g2_decap_8
X_17_ FrameData[17] net9 VPWR VGND sg13g2_buf_1
XFILLER_3_154 VPWR VGND sg13g2_decap_8
XFILLER_5_35 VPWR VGND sg13g2_decap_8
XFILLER_5_205 VPWR VGND sg13g2_fill_2
XFILLER_2_14 VPWR VGND sg13g2_decap_8
X_50_ FrameStrobe[18] net42 VPWR VGND sg13g2_buf_1
XFILLER_9_0 VPWR VGND sg13g2_decap_8
XFILLER_11_45 VPWR VGND sg13g2_fill_2
XFILLER_2_7 VPWR VGND sg13g2_decap_8
X_33_ FrameStrobe[1] net44 VPWR VGND sg13g2_buf_1
XFILLER_9_160 VPWR VGND sg13g2_decap_8
X_16_ FrameData[16] net8 VPWR VGND sg13g2_buf_1
XFILLER_6_141 VPWR VGND sg13g2_decap_8
XFILLER_6_185 VPWR VGND sg13g2_fill_2
XFILLER_8_35 VPWR VGND sg13g2_decap_8
XFILLER_3_133 VPWR VGND sg13g2_decap_8
XFILLER_5_14 VPWR VGND sg13g2_decap_8
XFILLER_11_35 VPWR VGND sg13g2_fill_2
X_32_ FrameStrobe[0] net33 VPWR VGND sg13g2_buf_1
X_15_ FrameData[15] net7 VPWR VGND sg13g2_buf_1
XFILLER_6_131 VPWR VGND sg13g2_decap_4
XFILLER_8_14 VPWR VGND sg13g2_decap_8
XFILLER_3_112 VPWR VGND sg13g2_decap_8
XFILLER_3_189 VPWR VGND sg13g2_decap_8
XFILLER_10_7 VPWR VGND sg13g2_decap_8
XFILLER_5_207 VPWR VGND sg13g2_fill_1
XFILLER_2_49 VPWR VGND sg13g2_decap_8
XFILLER_11_25 VPWR VGND sg13g2_fill_2
X_31_ FrameData[31] net25 VPWR VGND sg13g2_buf_1
XFILLER_9_195 VPWR VGND sg13g2_decap_8
XFILLER_3_70 VPWR VGND sg13g2_decap_8
XFILLER_10_194 VPWR VGND sg13g2_fill_2
XFILLER_6_110 VPWR VGND sg13g2_decap_8
XFILLER_6_176 VPWR VGND sg13g2_decap_4
XFILLER_6_187 VPWR VGND sg13g2_fill_1
X_14_ FrameData[14] net6 VPWR VGND sg13g2_buf_1
XFILLER_3_168 VPWR VGND sg13g2_decap_8
XFILLER_2_190 VPWR VGND sg13g2_decap_8
XFILLER_9_91 VPWR VGND sg13g2_decap_8
XFILLER_5_49 VPWR VGND sg13g2_decap_8
XFILLER_2_28 VPWR VGND sg13g2_decap_8
XFILLER_11_15 VPWR VGND sg13g2_fill_2
X_30_ FrameData[30] net24 VPWR VGND sg13g2_buf_1
XFILLER_7_0 VPWR VGND sg13g2_decap_8
XFILLER_9_174 VPWR VGND sg13g2_decap_8
XFILLER_10_173 VPWR VGND sg13g2_decap_8
XFILLER_0_7 VPWR VGND sg13g2_decap_8
XFILLER_6_155 VPWR VGND sg13g2_decap_8
XFILLER_8_49 VPWR VGND sg13g2_decap_8
X_13_ FrameData[13] net5 VPWR VGND sg13g2_buf_1
XFILLER_3_147 VPWR VGND sg13g2_decap_8
XFILLER_9_70 VPWR VGND sg13g2_decap_8
XFILLER_5_28 VPWR VGND sg13g2_decap_8
XFILLER_8_206 VPWR VGND sg13g2_fill_2
XFILLER_9_153 VPWR VGND sg13g2_decap_8
XFILLER_10_152 VPWR VGND sg13g2_decap_8
XFILLER_8_28 VPWR VGND sg13g2_decap_8
X_12_ FrameData[12] net4 VPWR VGND sg13g2_buf_1
XFILLER_3_126 VPWR VGND sg13g2_decap_8
XFILLER_6_72 VPWR VGND sg13g2_decap_8
XFILLER_6_94 VPWR VGND sg13g2_decap_4
Xoutput1 net1 FrameData_O[0] VPWR VGND sg13g2_buf_1
XFILLER_1_202 VPWR VGND sg13g2_fill_2
Xoutput80 net80 S4BEG[1] VPWR VGND sg13g2_buf_1
XFILLER_9_132 VPWR VGND sg13g2_decap_8
XFILLER_3_84 VPWR VGND sg13g2_fill_2
X_88_ UserCLK net89 VPWR VGND sg13g2_buf_1
XFILLER_10_131 VPWR VGND sg13g2_decap_8
X_11_ FrameData[11] net3 VPWR VGND sg13g2_buf_1
XFILLER_6_124 VPWR VGND sg13g2_fill_2
XFILLER_6_135 VPWR VGND sg13g2_fill_2
Xoutput81 net81 S4BEG[2] VPWR VGND sg13g2_buf_1
Xoutput70 net70 S2BEGb[5] VPWR VGND sg13g2_buf_1
Xoutput2 net2 FrameData_O[10] VPWR VGND sg13g2_buf_1
XFILLER_9_188 VPWR VGND sg13g2_decap_8
XFILLER_3_63 VPWR VGND sg13g2_decap_8
X_87_ N4END[0] net79 VPWR VGND sg13g2_buf_1
XFILLER_10_187 VPWR VGND sg13g2_decap_8
X_10_ FrameData[10] net2 VPWR VGND sg13g2_buf_1
XFILLER_5_0 VPWR VGND sg13g2_decap_8
XFILLER_6_169 VPWR VGND sg13g2_decap_8
XFILLER_9_84 VPWR VGND sg13g2_decap_8
XFILLER_0_42 VPWR VGND sg13g2_decap_8
XFILLER_2_183 VPWR VGND sg13g2_decap_8
XFILLER_9_7 VPWR VGND sg13g2_decap_8
Xoutput71 net71 S2BEGb[6] VPWR VGND sg13g2_buf_1
Xoutput60 net60 S2BEG[3] VPWR VGND sg13g2_buf_1
Xoutput82 net82 S4BEG[3] VPWR VGND sg13g2_buf_1
Xoutput3 net3 FrameData_O[11] VPWR VGND sg13g2_buf_1
XFILLER_9_167 VPWR VGND sg13g2_decap_8
X_86_ N4END[1] net78 VPWR VGND sg13g2_buf_1
XFILLER_3_42 VPWR VGND sg13g2_decap_8
XFILLER_3_86 VPWR VGND sg13g2_fill_1
XFILLER_10_166 VPWR VGND sg13g2_decap_8
XFILLER_10_111 VPWR VGND sg13g2_fill_2
XFILLER_6_126 VPWR VGND sg13g2_fill_1
XFILLER_6_148 VPWR VGND sg13g2_decap_8
X_69_ N2END[2] net70 VPWR VGND sg13g2_buf_1
XFILLER_3_107 VPWR VGND sg13g2_fill_1
XFILLER_0_21 VPWR VGND sg13g2_decap_8
XFILLER_2_162 VPWR VGND sg13g2_decap_8
XFILLER_9_63 VPWR VGND sg13g2_decap_8
XFILLER_4_202 VPWR VGND sg13g2_decap_4
XFILLER_6_42 VPWR VGND sg13g2_decap_8
XFILLER_6_53 VPWR VGND sg13g2_fill_1
Xoutput50 net50 FrameStrobe_O[7] VPWR VGND sg13g2_buf_1
Xoutput83 net83 S4BEG[4] VPWR VGND sg13g2_buf_1
Xoutput72 net72 S2BEGb[7] VPWR VGND sg13g2_buf_1
Xoutput61 net61 S2BEG[4] VPWR VGND sg13g2_buf_1
Xoutput4 net4 FrameData_O[12] VPWR VGND sg13g2_buf_1
XFILLER_9_146 VPWR VGND sg13g2_decap_8
X_85_ N4END[2] net77 VPWR VGND sg13g2_buf_1
XFILLER_3_21 VPWR VGND sg13g2_decap_8
XFILLER_10_145 VPWR VGND sg13g2_decap_8
X_68_ N2END[3] net69 VPWR VGND sg13g2_buf_1
XFILLER_3_119 VPWR VGND sg13g2_decap_8
XFILLER_9_42 VPWR VGND sg13g2_decap_8
XFILLER_6_21 VPWR VGND sg13g2_decap_8
XFILLER_6_65 VPWR VGND sg13g2_decap_8
XFILLER_6_87 VPWR VGND sg13g2_fill_2
Xoutput40 net40 FrameStrobe_O[16] VPWR VGND sg13g2_buf_1
Xoutput51 net51 FrameStrobe_O[8] VPWR VGND sg13g2_buf_1
Xoutput84 net84 S4BEG[5] VPWR VGND sg13g2_buf_1
Xoutput73 net73 S4BEG[0] VPWR VGND sg13g2_buf_1
Xoutput62 net62 S2BEG[5] VPWR VGND sg13g2_buf_1
Xoutput5 net5 FrameData_O[13] VPWR VGND sg13g2_buf_1
XFILLER_9_125 VPWR VGND sg13g2_decap_8
X_84_ N4END[3] net76 VPWR VGND sg13g2_buf_1
XFILLER_3_77 VPWR VGND sg13g2_decap_8
XFILLER_3_99 VPWR VGND sg13g2_decap_4
XFILLER_10_124 VPWR VGND sg13g2_decap_8
XFILLER_6_117 VPWR VGND sg13g2_decap_8
X_67_ N2END[4] net68 VPWR VGND sg13g2_buf_1
XFILLER_2_197 VPWR VGND sg13g2_decap_8
XFILLER_3_0 VPWR VGND sg13g2_decap_8
XFILLER_9_98 VPWR VGND sg13g2_decap_4
XFILLER_9_21 VPWR VGND sg13g2_decap_8
Xoutput41 net41 FrameStrobe_O[17] VPWR VGND sg13g2_buf_1
Xoutput52 net52 FrameStrobe_O[9] VPWR VGND sg13g2_buf_1
Xoutput30 net30 FrameData_O[7] VPWR VGND sg13g2_buf_1
Xoutput6 net6 FrameData_O[14] VPWR VGND sg13g2_buf_1
Xoutput74 net74 S4BEG[10] VPWR VGND sg13g2_buf_1
Xoutput85 net85 S4BEG[6] VPWR VGND sg13g2_buf_1
Xoutput63 net63 S2BEG[6] VPWR VGND sg13g2_buf_1
.ends
