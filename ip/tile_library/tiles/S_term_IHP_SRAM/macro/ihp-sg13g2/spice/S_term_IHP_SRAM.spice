* NGSPICE file created from S_term_IHP_SRAM.ext - technology: ihp-sg13g2

* Black-box entry subcircuit for sg13g2_decap_8 abstract view
.subckt sg13g2_decap_8 VDD VSS
.ends

* Black-box entry subcircuit for sg13g2_buf_1 abstract view
.subckt sg13g2_buf_1 A X VDD VSS
.ends

* Black-box entry subcircuit for sg13g2_fill_1 abstract view
.subckt sg13g2_fill_1 VDD VSS
.ends

* Black-box entry subcircuit for sg13g2_decap_4 abstract view
.subckt sg13g2_decap_4 VDD VSS
.ends

* Black-box entry subcircuit for sg13g2_fill_2 abstract view
.subckt sg13g2_fill_2 VDD VSS
.ends

.subckt S_term_IHP_SRAM FrameData[0] FrameData[10] FrameData[11] FrameData[12] FrameData[13]
+ FrameData[14] FrameData[15] FrameData[16] FrameData[17] FrameData[18] FrameData[19]
+ FrameData[1] FrameData[20] FrameData[21] FrameData[22] FrameData[23] FrameData[24]
+ FrameData[25] FrameData[26] FrameData[27] FrameData[28] FrameData[29] FrameData[2]
+ FrameData[30] FrameData[31] FrameData[3] FrameData[4] FrameData[5] FrameData[6]
+ FrameData[7] FrameData[8] FrameData[9] FrameData_O[0] FrameData_O[10] FrameData_O[11]
+ FrameData_O[12] FrameData_O[13] FrameData_O[14] FrameData_O[15] FrameData_O[16]
+ FrameData_O[17] FrameData_O[18] FrameData_O[19] FrameData_O[1] FrameData_O[20] FrameData_O[21]
+ FrameData_O[22] FrameData_O[23] FrameData_O[24] FrameData_O[25] FrameData_O[26]
+ FrameData_O[27] FrameData_O[28] FrameData_O[29] FrameData_O[2] FrameData_O[30] FrameData_O[31]
+ FrameData_O[3] FrameData_O[4] FrameData_O[5] FrameData_O[6] FrameData_O[7] FrameData_O[8]
+ FrameData_O[9] FrameStrobe[0] FrameStrobe[10] FrameStrobe[11] FrameStrobe[12] FrameStrobe[13]
+ FrameStrobe[14] FrameStrobe[15] FrameStrobe[16] FrameStrobe[17] FrameStrobe[18]
+ FrameStrobe[19] FrameStrobe[1] FrameStrobe[2] FrameStrobe[3] FrameStrobe[4] FrameStrobe[5]
+ FrameStrobe[6] FrameStrobe[7] FrameStrobe[8] FrameStrobe[9] FrameStrobe_O[0] FrameStrobe_O[10]
+ FrameStrobe_O[11] FrameStrobe_O[12] FrameStrobe_O[13] FrameStrobe_O[14] FrameStrobe_O[15]
+ FrameStrobe_O[16] FrameStrobe_O[17] FrameStrobe_O[18] FrameStrobe_O[19] FrameStrobe_O[1]
+ FrameStrobe_O[2] FrameStrobe_O[3] FrameStrobe_O[4] FrameStrobe_O[5] FrameStrobe_O[6]
+ FrameStrobe_O[7] FrameStrobe_O[8] FrameStrobe_O[9] N1BEG[0] N1BEG[1] N1BEG[2] N1BEG[3]
+ N2BEG[0] N2BEG[1] N2BEG[2] N2BEG[3] N2BEG[4] N2BEG[5] N2BEG[6] N2BEG[7] N2BEGb[0]
+ N2BEGb[1] N2BEGb[2] N2BEGb[3] N2BEGb[4] N2BEGb[5] N2BEGb[6] N2BEGb[7] N4BEG[0] N4BEG[10]
+ N4BEG[11] N4BEG[12] N4BEG[13] N4BEG[14] N4BEG[15] N4BEG[1] N4BEG[2] N4BEG[3] N4BEG[4]
+ N4BEG[5] N4BEG[6] N4BEG[7] N4BEG[8] N4BEG[9] S1END[0] S1END[1] S1END[2] S1END[3]
+ S2END[0] S2END[1] S2END[2] S2END[3] S2END[4] S2END[5] S2END[6] S2END[7] S2MID[0]
+ S2MID[1] S2MID[2] S2MID[3] S2MID[4] S2MID[5] S2MID[6] S2MID[7] S4END[0] S4END[10]
+ S4END[11] S4END[12] S4END[13] S4END[14] S4END[15] S4END[1] S4END[2] S4END[3] S4END[4]
+ S4END[5] S4END[6] S4END[7] S4END[8] S4END[9] UserCLK UserCLKo VGND VPWR
XFILLER_7_7 VPWR VGND sg13g2_decap_8
X_83_ S4END[4] net75 VPWR VGND sg13g2_buf_1
XFILLER_3_56 VPWR VGND sg13g2_decap_8
XFILLER_8_170 VPWR VGND sg13g2_decap_8
XFILLER_6_129 VPWR VGND sg13g2_decap_8
X_66_ S2END[5] net67 VPWR VGND sg13g2_buf_1
XFILLER_5_140 VPWR VGND sg13g2_decap_8
XFILLER_5_173 VPWR VGND sg13g2_fill_1
XFILLER_5_195 VPWR VGND sg13g2_decap_4
XFILLER_2_121 VPWR VGND sg13g2_decap_8
XFILLER_0_35 VPWR VGND sg13g2_decap_8
XFILLER_2_198 VPWR VGND sg13g2_decap_8
X_49_ FrameStrobe[17] net41 VPWR VGND sg13g2_buf_1
XFILLER_7_202 VPWR VGND sg13g2_decap_4
XFILLER_6_67 VPWR VGND sg13g2_decap_8
Xoutput42 net42 FrameStrobe_O[18] VPWR VGND sg13g2_buf_1
Xoutput53 net53 N1BEG[0] VPWR VGND sg13g2_buf_1
Xoutput20 net20 FrameData_O[27] VPWR VGND sg13g2_buf_1
Xoutput75 net75 N4BEG[11] VPWR VGND sg13g2_buf_1
Xoutput31 net31 FrameData_O[8] VPWR VGND sg13g2_buf_1
Xoutput7 net7 FrameData_O[15] VPWR VGND sg13g2_buf_1
Xoutput64 net64 N2BEG[7] VPWR VGND sg13g2_buf_1
Xoutput86 net86 N4BEG[7] VPWR VGND sg13g2_buf_1
XFILLER_11_0 VPWR VGND sg13g2_fill_2
XFILLER_9_127 VPWR VGND sg13g2_fill_1
XFILLER_9_116 VPWR VGND sg13g2_decap_8
XFILLER_3_35 VPWR VGND sg13g2_decap_8
X_82_ S4END[5] net74 VPWR VGND sg13g2_buf_1
XFILLER_10_148 VPWR VGND sg13g2_decap_8
X_65_ S2END[6] net66 VPWR VGND sg13g2_buf_1
XFILLER_5_163 VPWR VGND sg13g2_decap_4
XFILLER_5_185 VPWR VGND sg13g2_decap_4
XFILLER_0_14 VPWR VGND sg13g2_decap_8
XFILLER_2_177 VPWR VGND sg13g2_decap_8
X_48_ FrameStrobe[16] net40 VPWR VGND sg13g2_buf_1
XFILLER_6_35 VPWR VGND sg13g2_decap_8
Xoutput87 net87 N4BEG[8] VPWR VGND sg13g2_buf_1
Xoutput65 net65 N2BEGb[0] VPWR VGND sg13g2_buf_1
Xoutput21 net21 FrameData_O[28] VPWR VGND sg13g2_buf_1
Xoutput43 net43 FrameStrobe_O[19] VPWR VGND sg13g2_buf_1
Xoutput76 net76 N4BEG[12] VPWR VGND sg13g2_buf_1
Xoutput32 net32 FrameData_O[9] VPWR VGND sg13g2_buf_1
Xoutput8 net8 FrameData_O[16] VPWR VGND sg13g2_buf_1
Xoutput10 net10 FrameData_O[18] VPWR VGND sg13g2_buf_1
Xoutput54 net54 N1BEG[1] VPWR VGND sg13g2_buf_1
XFILLER_9_139 VPWR VGND sg13g2_decap_8
X_81_ S4END[6] net88 VPWR VGND sg13g2_buf_1
XFILLER_3_14 VPWR VGND sg13g2_decap_8
X_64_ S2END[7] net65 VPWR VGND sg13g2_buf_1
XFILLER_2_156 VPWR VGND sg13g2_decap_8
XFILLER_9_35 VPWR VGND sg13g2_decap_8
X_47_ FrameStrobe[15] net39 VPWR VGND sg13g2_buf_1
XFILLER_9_46 VPWR VGND sg13g2_fill_1
XFILLER_1_0 VPWR VGND sg13g2_decap_8
XFILLER_1_91 VPWR VGND sg13g2_fill_1
XFILLER_4_207 VPWR VGND sg13g2_fill_1
XFILLER_6_14 VPWR VGND sg13g2_decap_8
Xoutput44 net44 FrameStrobe_O[1] VPWR VGND sg13g2_buf_1
Xoutput33 net33 FrameStrobe_O[0] VPWR VGND sg13g2_buf_1
Xoutput77 net77 N4BEG[13] VPWR VGND sg13g2_buf_1
Xoutput55 net55 N1BEG[2] VPWR VGND sg13g2_buf_1
Xoutput22 net22 FrameData_O[29] VPWR VGND sg13g2_buf_1
Xoutput88 net88 N4BEG[9] VPWR VGND sg13g2_buf_1
Xoutput9 net9 FrameData_O[17] VPWR VGND sg13g2_buf_1
Xoutput11 net11 FrameData_O[19] VPWR VGND sg13g2_buf_1
Xoutput66 net66 N2BEGb[1] VPWR VGND sg13g2_buf_1
XFILLER_11_2 VPWR VGND sg13g2_fill_1
X_80_ S4END[7] net87 VPWR VGND sg13g2_buf_1
XFILLER_8_184 VPWR VGND sg13g2_decap_8
XFILLER_10_106 VPWR VGND sg13g2_decap_8
XFILLER_5_7 VPWR VGND sg13g2_decap_8
XFILLER_5_154 VPWR VGND sg13g2_decap_4
XFILLER_4_80 VPWR VGND sg13g2_decap_8
X_63_ S2MID[0] net64 VPWR VGND sg13g2_buf_1
XFILLER_2_135 VPWR VGND sg13g2_decap_8
XFILLER_0_49 VPWR VGND sg13g2_decap_8
X_46_ FrameStrobe[14] net38 VPWR VGND sg13g2_buf_1
XFILLER_9_14 VPWR VGND sg13g2_decap_8
X_29_ FrameData[29] net22 VPWR VGND sg13g2_buf_1
XFILLER_1_70 VPWR VGND sg13g2_decap_8
Xoutput34 net34 FrameStrobe_O[10] VPWR VGND sg13g2_buf_1
Xoutput45 net45 FrameStrobe_O[2] VPWR VGND sg13g2_buf_1
Xoutput89 net89 UserCLKo VPWR VGND sg13g2_buf_1
Xoutput78 net78 N4BEG[14] VPWR VGND sg13g2_buf_1
Xoutput67 net67 N2BEGb[2] VPWR VGND sg13g2_buf_1
Xoutput23 net23 FrameData_O[2] VPWR VGND sg13g2_buf_1
Xoutput12 net12 FrameData_O[1] VPWR VGND sg13g2_buf_1
Xoutput56 net56 N1BEG[3] VPWR VGND sg13g2_buf_1
XFILLER_7_91 VPWR VGND sg13g2_decap_8
XFILLER_3_49 VPWR VGND sg13g2_decap_8
XFILLER_8_163 VPWR VGND sg13g2_decap_8
XFILLER_5_133 VPWR VGND sg13g2_fill_2
X_62_ S2MID[1] net63 VPWR VGND sg13g2_buf_1
XFILLER_5_199 VPWR VGND sg13g2_fill_2
XFILLER_2_114 VPWR VGND sg13g2_decap_8
XFILLER_4_70 VPWR VGND sg13g2_decap_4
XFILLER_0_28 VPWR VGND sg13g2_decap_8
X_45_ FrameStrobe[13] net37 VPWR VGND sg13g2_buf_1
XFILLER_7_206 VPWR VGND sg13g2_fill_2
X_28_ FrameData[28] net21 VPWR VGND sg13g2_buf_1
XFILLER_6_49 VPWR VGND sg13g2_decap_8
Xoutput57 net57 N2BEG[0] VPWR VGND sg13g2_buf_1
Xoutput35 net35 FrameStrobe_O[11] VPWR VGND sg13g2_buf_1
Xoutput46 net46 FrameStrobe_O[3] VPWR VGND sg13g2_buf_1
Xoutput13 net13 FrameData_O[20] VPWR VGND sg13g2_buf_1
Xoutput24 net24 FrameData_O[30] VPWR VGND sg13g2_buf_1
Xoutput79 net79 N4BEG[15] VPWR VGND sg13g2_buf_1
Xoutput68 net68 N2BEGb[3] VPWR VGND sg13g2_buf_1
XFILLER_7_70 VPWR VGND sg13g2_decap_8
XFILLER_9_109 VPWR VGND sg13g2_decap_8
XFILLER_3_28 VPWR VGND sg13g2_decap_8
XFILLER_8_142 VPWR VGND sg13g2_decap_8
X_61_ S2MID[2] net62 VPWR VGND sg13g2_buf_1
XFILLER_5_112 VPWR VGND sg13g2_fill_2
XFILLER_5_123 VPWR VGND sg13g2_fill_2
XFILLER_5_178 VPWR VGND sg13g2_decap_8
XFILLER_5_189 VPWR VGND sg13g2_fill_2
X_44_ FrameStrobe[12] net36 VPWR VGND sg13g2_buf_1
X_27_ FrameData[27] net20 VPWR VGND sg13g2_buf_1
XFILLER_6_28 VPWR VGND sg13g2_decap_8
Xoutput36 net36 FrameStrobe_O[12] VPWR VGND sg13g2_buf_1
Xoutput47 net47 FrameStrobe_O[4] VPWR VGND sg13g2_buf_1
Xoutput14 net14 FrameData_O[21] VPWR VGND sg13g2_buf_1
Xoutput25 net25 FrameData_O[31] VPWR VGND sg13g2_buf_1
Xoutput58 net58 N2BEG[1] VPWR VGND sg13g2_buf_1
Xoutput69 net69 N2BEGb[4] VPWR VGND sg13g2_buf_1
XFILLER_8_121 VPWR VGND sg13g2_decap_8
XFILLER_8_198 VPWR VGND sg13g2_decap_4
X_60_ S2MID[3] net61 VPWR VGND sg13g2_buf_1
XFILLER_5_135 VPWR VGND sg13g2_fill_1
XFILLER_4_94 VPWR VGND sg13g2_fill_2
XFILLER_2_149 VPWR VGND sg13g2_decap_8
XFILLER_3_7 VPWR VGND sg13g2_decap_8
XFILLER_9_28 VPWR VGND sg13g2_decap_8
XFILLER_1_182 VPWR VGND sg13g2_decap_8
X_43_ FrameStrobe[11] net35 VPWR VGND sg13g2_buf_1
XFILLER_1_84 VPWR VGND sg13g2_decap_8
X_26_ FrameData[26] net19 VPWR VGND sg13g2_buf_1
X_09_ FrameData[9] net32 VPWR VGND sg13g2_buf_1
Xoutput59 net59 N2BEG[2] VPWR VGND sg13g2_buf_1
Xoutput15 net15 FrameData_O[22] VPWR VGND sg13g2_buf_1
Xoutput37 net37 FrameStrobe_O[13] VPWR VGND sg13g2_buf_1
Xoutput48 net48 FrameStrobe_O[5] VPWR VGND sg13g2_buf_1
Xoutput26 net26 FrameData_O[3] VPWR VGND sg13g2_buf_1
XFILLER_8_177 VPWR VGND sg13g2_decap_8
XFILLER_5_114 VPWR VGND sg13g2_fill_1
XFILLER_5_147 VPWR VGND sg13g2_decap_8
XFILLER_5_158 VPWR VGND sg13g2_fill_1
XFILLER_2_128 VPWR VGND sg13g2_decap_8
XFILLER_1_161 VPWR VGND sg13g2_decap_8
X_42_ FrameStrobe[10] net34 VPWR VGND sg13g2_buf_1
XFILLER_1_96 VPWR VGND sg13g2_decap_8
XFILLER_1_63 VPWR VGND sg13g2_decap_8
X_25_ FrameData[25] net18 VPWR VGND sg13g2_buf_1
X_08_ FrameData[8] net31 VPWR VGND sg13g2_buf_1
Xoutput38 net38 FrameStrobe_O[14] VPWR VGND sg13g2_buf_1
Xoutput49 net49 FrameStrobe_O[6] VPWR VGND sg13g2_buf_1
Xoutput16 net16 FrameData_O[23] VPWR VGND sg13g2_buf_1
Xoutput27 net27 FrameData_O[4] VPWR VGND sg13g2_buf_1
XFILLER_7_84 VPWR VGND sg13g2_decap_8
XFILLER_8_156 VPWR VGND sg13g2_decap_8
XFILLER_4_63 VPWR VGND sg13g2_decap_8
XFILLER_4_74 VPWR VGND sg13g2_fill_2
XFILLER_4_96 VPWR VGND sg13g2_fill_1
XFILLER_2_107 VPWR VGND sg13g2_decap_8
XFILLER_1_140 VPWR VGND sg13g2_decap_8
X_41_ FrameStrobe[9] net52 VPWR VGND sg13g2_buf_1
XFILLER_1_42 VPWR VGND sg13g2_decap_8
X_24_ FrameData[24] net17 VPWR VGND sg13g2_buf_1
XFILLER_3_202 VPWR VGND sg13g2_decap_4
Xoutput17 net17 FrameData_O[24] VPWR VGND sg13g2_buf_1
Xoutput39 net39 FrameStrobe_O[15] VPWR VGND sg13g2_buf_1
X_07_ FrameData[7] net30 VPWR VGND sg13g2_buf_1
Xoutput28 net28 FrameData_O[5] VPWR VGND sg13g2_buf_1
XFILLER_7_63 VPWR VGND sg13g2_decap_8
XFILLER_8_135 VPWR VGND sg13g2_decap_8
XFILLER_5_105 VPWR VGND sg13g2_decap_8
XFILLER_4_42 VPWR VGND sg13g2_decap_8
XFILLER_4_193 VPWR VGND sg13g2_decap_8
XFILLER_1_196 VPWR VGND sg13g2_decap_8
X_40_ FrameStrobe[8] net51 VPWR VGND sg13g2_buf_1
XFILLER_8_0 VPWR VGND sg13g2_decap_8
XFILLER_11_207 VPWR VGND sg13g2_fill_1
XFILLER_1_7 VPWR VGND sg13g2_decap_8
X_23_ FrameData[23] net16 VPWR VGND sg13g2_buf_1
XFILLER_1_21 VPWR VGND sg13g2_decap_8
XFILLER_6_200 VPWR VGND sg13g2_decap_8
Xoutput18 net18 FrameData_O[25] VPWR VGND sg13g2_buf_1
Xoutput29 net29 FrameData_O[6] VPWR VGND sg13g2_buf_1
X_06_ FrameData[6] net29 VPWR VGND sg13g2_buf_1
XFILLER_7_42 VPWR VGND sg13g2_decap_8
XFILLER_4_21 VPWR VGND sg13g2_decap_8
XFILLER_4_87 VPWR VGND sg13g2_decap_8
XFILLER_4_172 VPWR VGND sg13g2_decap_8
XFILLER_1_175 VPWR VGND sg13g2_decap_8
XFILLER_1_77 VPWR VGND sg13g2_decap_8
X_22_ FrameData[22] net15 VPWR VGND sg13g2_buf_1
X_05_ FrameData[5] net28 VPWR VGND sg13g2_buf_1
Xoutput19 net19 FrameData_O[26] VPWR VGND sg13g2_buf_1
XFILLER_7_21 VPWR VGND sg13g2_decap_8
XFILLER_7_98 VPWR VGND sg13g2_fill_1
XFILLER_7_181 VPWR VGND sg13g2_decap_8
XFILLER_4_151 VPWR VGND sg13g2_decap_8
XFILLER_1_154 VPWR VGND sg13g2_decap_8
X_21_ FrameData[21] net14 VPWR VGND sg13g2_buf_1
XFILLER_1_56 VPWR VGND sg13g2_decap_8
X_04_ FrameData[4] net27 VPWR VGND sg13g2_buf_1
XFILLER_7_77 VPWR VGND sg13g2_decap_8
XFILLER_8_149 VPWR VGND sg13g2_decap_8
XFILLER_7_160 VPWR VGND sg13g2_decap_8
XFILLER_5_119 VPWR VGND sg13g2_decap_4
XFILLER_4_56 VPWR VGND sg13g2_decap_8
XFILLER_4_130 VPWR VGND sg13g2_decap_8
XFILLER_1_133 VPWR VGND sg13g2_decap_8
XFILLER_6_0 VPWR VGND sg13g2_decap_8
XFILLER_1_35 VPWR VGND sg13g2_decap_8
X_20_ FrameData[20] net13 VPWR VGND sg13g2_buf_1
XFILLER_10_99 VPWR VGND sg13g2_fill_2
XFILLER_3_206 VPWR VGND sg13g2_fill_2
X_03_ FrameData[3] net26 VPWR VGND sg13g2_buf_1
XFILLER_7_56 VPWR VGND sg13g2_decap_8
XFILLER_8_128 VPWR VGND sg13g2_decap_8
XFILLER_4_35 VPWR VGND sg13g2_decap_8
XFILLER_4_186 VPWR VGND sg13g2_decap_8
XFILLER_1_189 VPWR VGND sg13g2_decap_8
XFILLER_1_112 VPWR VGND sg13g2_decap_8
XFILLER_1_14 VPWR VGND sg13g2_decap_8
X_79_ S4END[8] net86 VPWR VGND sg13g2_buf_1
X_02_ FrameData[2] net23 VPWR VGND sg13g2_buf_1
XFILLER_7_35 VPWR VGND sg13g2_decap_8
XFILLER_7_195 VPWR VGND sg13g2_decap_8
XFILLER_4_14 VPWR VGND sg13g2_decap_8
XFILLER_4_165 VPWR VGND sg13g2_decap_8
XFILLER_1_168 VPWR VGND sg13g2_decap_8
X_78_ S4END[9] net85 VPWR VGND sg13g2_buf_1
X_01_ FrameData[1] net12 VPWR VGND sg13g2_buf_1
XFILLER_2_91 VPWR VGND sg13g2_decap_8
XFILLER_7_14 VPWR VGND sg13g2_decap_8
XFILLER_7_174 VPWR VGND sg13g2_decap_8
XFILLER_4_144 VPWR VGND sg13g2_decap_8
XFILLER_1_147 VPWR VGND sg13g2_decap_8
XFILLER_1_103 VPWR VGND sg13g2_fill_1
XFILLER_0_180 VPWR VGND sg13g2_decap_8
XFILLER_5_91 VPWR VGND sg13g2_decap_4
XFILLER_1_49 VPWR VGND sg13g2_decap_8
X_77_ S4END[10] net84 VPWR VGND sg13g2_buf_1
X_00_ FrameData[0] net1 VPWR VGND sg13g2_buf_1
XFILLER_4_0 VPWR VGND sg13g2_decap_8
XFILLER_2_70 VPWR VGND sg13g2_decap_8
XFILLER_7_153 VPWR VGND sg13g2_decap_8
XFILLER_8_91 VPWR VGND sg13g2_decap_4
XFILLER_4_49 VPWR VGND sg13g2_decap_8
XFILLER_4_123 VPWR VGND sg13g2_decap_8
XFILLER_1_126 VPWR VGND sg13g2_decap_8
XFILLER_8_7 VPWR VGND sg13g2_decap_8
XFILLER_5_70 VPWR VGND sg13g2_decap_8
XFILLER_10_203 VPWR VGND sg13g2_fill_1
XFILLER_1_28 VPWR VGND sg13g2_decap_8
XFILLER_6_207 VPWR VGND sg13g2_fill_1
X_76_ S4END[11] net83 VPWR VGND sg13g2_buf_1
X_59_ S2MID[4] net60 VPWR VGND sg13g2_buf_1
XFILLER_7_49 VPWR VGND sg13g2_decap_8
XFILLER_7_132 VPWR VGND sg13g2_decap_8
XFILLER_8_70 VPWR VGND sg13g2_decap_8
XFILLER_4_28 VPWR VGND sg13g2_decap_8
XFILLER_4_179 VPWR VGND sg13g2_decap_8
X_75_ S4END[12] net82 VPWR VGND sg13g2_buf_1
X_58_ S2MID[5] net59 VPWR VGND sg13g2_buf_1
XFILLER_7_28 VPWR VGND sg13g2_decap_8
XFILLER_7_111 VPWR VGND sg13g2_decap_8
XFILLER_7_188 VPWR VGND sg13g2_decap_8
XFILLER_4_158 VPWR VGND sg13g2_decap_8
XFILLER_0_194 VPWR VGND sg13g2_decap_4
X_74_ S4END[13] net81 VPWR VGND sg13g2_buf_1
XFILLER_2_84 VPWR VGND sg13g2_decap_8
X_57_ S2MID[6] net58 VPWR VGND sg13g2_buf_1
XFILLER_2_0 VPWR VGND sg13g2_decap_8
XFILLER_11_130 VPWR VGND sg13g2_fill_2
XFILLER_7_167 VPWR VGND sg13g2_decap_8
XFILLER_4_137 VPWR VGND sg13g2_decap_8
XFILLER_3_181 VPWR VGND sg13g2_decap_8
XFILLER_0_173 VPWR VGND sg13g2_decap_8
XFILLER_5_84 VPWR VGND sg13g2_fill_2
XFILLER_5_95 VPWR VGND sg13g2_fill_2
XFILLER_6_7 VPWR VGND sg13g2_decap_8
X_73_ S4END[14] net80 VPWR VGND sg13g2_buf_1
X_56_ S2MID[7] net57 VPWR VGND sg13g2_buf_1
XFILLER_2_63 VPWR VGND sg13g2_decap_8
X_39_ FrameStrobe[7] net50 VPWR VGND sg13g2_buf_1
XFILLER_7_146 VPWR VGND sg13g2_decap_8
XFILLER_8_84 VPWR VGND sg13g2_decap_8
XFILLER_8_95 VPWR VGND sg13g2_fill_2
XFILLER_4_116 VPWR VGND sg13g2_decap_8
XFILLER_1_119 VPWR VGND sg13g2_decap_8
XFILLER_3_160 VPWR VGND sg13g2_decap_8
XFILLER_0_152 VPWR VGND sg13g2_decap_8
XFILLER_5_63 VPWR VGND sg13g2_decap_8
XFILLER_10_0 VPWR VGND sg13g2_decap_8
X_72_ S4END[15] net73 VPWR VGND sg13g2_buf_1
XFILLER_2_42 VPWR VGND sg13g2_decap_8
X_55_ S1END[0] net56 VPWR VGND sg13g2_buf_1
X_38_ FrameStrobe[6] net49 VPWR VGND sg13g2_buf_1
XFILLER_7_103 VPWR VGND sg13g2_decap_4
XFILLER_7_125 VPWR VGND sg13g2_decap_8
XFILLER_8_63 VPWR VGND sg13g2_decap_8
XFILLER_0_131 VPWR VGND sg13g2_decap_8
XFILLER_5_42 VPWR VGND sg13g2_decap_8
XFILLER_5_86 VPWR VGND sg13g2_fill_1
X_71_ S2END[0] net72 VPWR VGND sg13g2_buf_1
XFILLER_2_98 VPWR VGND sg13g2_fill_1
XFILLER_2_21 VPWR VGND sg13g2_decap_8
X_54_ S1END[1] net55 VPWR VGND sg13g2_buf_1
X_37_ FrameStrobe[5] net48 VPWR VGND sg13g2_buf_1
XFILLER_0_0 VPWR VGND sg13g2_decap_8
XFILLER_8_42 VPWR VGND sg13g2_decap_8
XFILLER_3_195 VPWR VGND sg13g2_decap_8
XFILLER_0_198 VPWR VGND sg13g2_fill_2
XFILLER_0_187 VPWR VGND sg13g2_decap_8
XFILLER_0_110 VPWR VGND sg13g2_decap_8
XFILLER_5_21 VPWR VGND sg13g2_decap_8
X_70_ S2END[1] net71 VPWR VGND sg13g2_buf_1
XFILLER_2_205 VPWR VGND sg13g2_fill_2
XFILLER_4_7 VPWR VGND sg13g2_decap_8
XFILLER_2_77 VPWR VGND sg13g2_decap_8
X_53_ S1END[2] net54 VPWR VGND sg13g2_buf_1
X_36_ FrameStrobe[4] net47 VPWR VGND sg13g2_buf_1
XFILLER_11_156 VPWR VGND sg13g2_fill_2
XFILLER_6_171 VPWR VGND sg13g2_decap_8
XFILLER_6_193 VPWR VGND sg13g2_fill_2
XFILLER_8_21 VPWR VGND sg13g2_decap_8
X_19_ FrameData[19] net11 VPWR VGND sg13g2_buf_1
XFILLER_3_174 VPWR VGND sg13g2_decap_8
XFILLER_0_166 VPWR VGND sg13g2_decap_8
XFILLER_5_77 VPWR VGND sg13g2_decap_8
XFILLER_2_56 VPWR VGND sg13g2_decap_8
X_52_ S1END[3] net53 VPWR VGND sg13g2_buf_1
XFILLER_11_87 VPWR VGND sg13g2_fill_2
X_35_ FrameStrobe[3] net46 VPWR VGND sg13g2_buf_1
XFILLER_11_113 VPWR VGND sg13g2_fill_1
XFILLER_7_139 VPWR VGND sg13g2_decap_8
XFILLER_6_150 VPWR VGND sg13g2_decap_8
XFILLER_8_77 VPWR VGND sg13g2_decap_8
XFILLER_4_109 VPWR VGND sg13g2_decap_8
X_18_ FrameData[18] net10 VPWR VGND sg13g2_buf_1
XFILLER_3_153 VPWR VGND sg13g2_decap_8
XFILLER_0_145 VPWR VGND sg13g2_decap_8
XFILLER_5_56 VPWR VGND sg13g2_decap_8
XFILLER_2_207 VPWR VGND sg13g2_fill_1
XFILLER_2_35 VPWR VGND sg13g2_decap_8
X_51_ FrameStrobe[19] net43 VPWR VGND sg13g2_buf_1
X_34_ FrameStrobe[2] net45 VPWR VGND sg13g2_buf_1
XFILLER_9_181 VPWR VGND sg13g2_decap_8
XFILLER_11_158 VPWR VGND sg13g2_fill_1
XFILLER_7_118 VPWR VGND sg13g2_decap_8
XFILLER_8_56 VPWR VGND sg13g2_decap_8
X_17_ FrameData[17] net9 VPWR VGND sg13g2_buf_1
XFILLER_6_195 VPWR VGND sg13g2_fill_1
XFILLER_3_132 VPWR VGND sg13g2_decap_8
XFILLER_0_124 VPWR VGND sg13g2_decap_8
XFILLER_5_35 VPWR VGND sg13g2_decap_8
XFILLER_8_202 VPWR VGND sg13g2_fill_2
XFILLER_5_205 VPWR VGND sg13g2_fill_2
XFILLER_2_14 VPWR VGND sg13g2_decap_8
X_50_ FrameStrobe[18] net42 VPWR VGND sg13g2_buf_1
XFILLER_9_0 VPWR VGND sg13g2_decap_8
XFILLER_2_7 VPWR VGND sg13g2_decap_8
X_33_ FrameStrobe[1] net44 VPWR VGND sg13g2_buf_1
XFILLER_9_160 VPWR VGND sg13g2_decap_8
X_16_ FrameData[16] net8 VPWR VGND sg13g2_buf_1
XFILLER_8_35 VPWR VGND sg13g2_decap_8
XFILLER_3_111 VPWR VGND sg13g2_decap_8
XFILLER_3_188 VPWR VGND sg13g2_decap_8
XFILLER_0_103 VPWR VGND sg13g2_decap_8
XFILLER_5_14 VPWR VGND sg13g2_decap_8
X_32_ FrameStrobe[0] net33 VPWR VGND sg13g2_buf_1
XFILLER_3_91 VPWR VGND sg13g2_fill_2
X_15_ FrameData[15] net7 VPWR VGND sg13g2_buf_1
XFILLER_6_164 VPWR VGND sg13g2_decap_8
XFILLER_6_186 VPWR VGND sg13g2_fill_2
XFILLER_8_14 VPWR VGND sg13g2_decap_8
XFILLER_3_167 VPWR VGND sg13g2_decap_8
XFILLER_0_70 VPWR VGND sg13g2_decap_8
XFILLER_0_159 VPWR VGND sg13g2_decap_8
XFILLER_10_7 VPWR VGND sg13g2_decap_4
XFILLER_5_207 VPWR VGND sg13g2_fill_1
XFILLER_2_49 VPWR VGND sg13g2_decap_8
X_31_ FrameData[31] net25 VPWR VGND sg13g2_buf_1
XFILLER_9_195 VPWR VGND sg13g2_fill_1
XFILLER_3_70 VPWR VGND sg13g2_decap_8
XFILLER_6_143 VPWR VGND sg13g2_decap_8
X_14_ FrameData[14] net6 VPWR VGND sg13g2_buf_1
XFILLER_3_102 VPWR VGND sg13g2_fill_1
XFILLER_3_146 VPWR VGND sg13g2_decap_8
XFILLER_0_138 VPWR VGND sg13g2_decap_8
XFILLER_5_49 VPWR VGND sg13g2_decap_8
XFILLER_6_81 VPWR VGND sg13g2_fill_2
XFILLER_2_28 VPWR VGND sg13g2_decap_8
X_30_ FrameData[30] net24 VPWR VGND sg13g2_buf_1
XFILLER_7_0 VPWR VGND sg13g2_decap_8
XFILLER_9_174 VPWR VGND sg13g2_decap_8
XFILLER_3_93 VPWR VGND sg13g2_fill_1
XFILLER_10_162 VPWR VGND sg13g2_decap_4
XFILLER_0_7 VPWR VGND sg13g2_decap_8
XFILLER_6_188 VPWR VGND sg13g2_fill_1
XFILLER_8_49 VPWR VGND sg13g2_decap_8
X_13_ FrameData[13] net5 VPWR VGND sg13g2_buf_1
XFILLER_3_125 VPWR VGND sg13g2_decap_8
XFILLER_2_191 VPWR VGND sg13g2_decap_8
XFILLER_0_117 VPWR VGND sg13g2_decap_8
XFILLER_5_28 VPWR VGND sg13g2_decap_8
XFILLER_6_60 VPWR VGND sg13g2_decap_8
XFILLER_9_153 VPWR VGND sg13g2_decap_8
XFILLER_10_141 VPWR VGND sg13g2_decap_8
XFILLER_8_28 VPWR VGND sg13g2_decap_8
X_12_ FrameData[12] net4 VPWR VGND sg13g2_buf_1
XFILLER_6_123 VPWR VGND sg13g2_fill_2
XFILLER_6_178 VPWR VGND sg13g2_decap_4
XFILLER_2_170 VPWR VGND sg13g2_decap_8
XFILLER_0_84 VPWR VGND sg13g2_fill_2
XFILLER_6_83 VPWR VGND sg13g2_fill_1
Xoutput1 net1 FrameData_O[0] VPWR VGND sg13g2_buf_1
Xoutput80 net80 N4BEG[1] VPWR VGND sg13g2_buf_1
XFILLER_9_132 VPWR VGND sg13g2_decap_8
XFILLER_3_84 VPWR VGND sg13g2_decap_8
X_88_ UserCLK net89 VPWR VGND sg13g2_buf_1
XFILLER_10_120 VPWR VGND sg13g2_fill_1
X_11_ FrameData[11] net3 VPWR VGND sg13g2_buf_1
XFILLER_6_102 VPWR VGND sg13g2_fill_2
XFILLER_6_113 VPWR VGND sg13g2_fill_2
XFILLER_6_157 VPWR VGND sg13g2_decap_8
XFILLER_9_94 VPWR VGND sg13g2_decap_8
XFILLER_0_63 VPWR VGND sg13g2_decap_8
XFILLER_4_200 VPWR VGND sg13g2_decap_8
XFILLER_6_95 VPWR VGND sg13g2_fill_2
XFILLER_1_203 VPWR VGND sg13g2_fill_1
Xoutput81 net81 N4BEG[2] VPWR VGND sg13g2_buf_1
Xoutput70 net70 N2BEGb[5] VPWR VGND sg13g2_buf_1
Xoutput2 net2 FrameData_O[10] VPWR VGND sg13g2_buf_1
XFILLER_9_188 VPWR VGND sg13g2_decap_8
XFILLER_3_63 VPWR VGND sg13g2_decap_8
X_87_ S4END[0] net79 VPWR VGND sg13g2_buf_1
X_10_ FrameData[10] net2 VPWR VGND sg13g2_buf_1
XFILLER_5_0 VPWR VGND sg13g2_decap_8
XFILLER_6_136 VPWR VGND sg13g2_decap_8
XFILLER_3_139 VPWR VGND sg13g2_decap_8
XFILLER_0_86 VPWR VGND sg13g2_fill_1
XFILLER_0_42 VPWR VGND sg13g2_decap_8
XFILLER_6_74 VPWR VGND sg13g2_decap_8
XFILLER_9_7 VPWR VGND sg13g2_decap_8
Xoutput3 net3 FrameData_O[11] VPWR VGND sg13g2_buf_1
Xoutput60 net60 N2BEG[3] VPWR VGND sg13g2_buf_1
Xoutput71 net71 N2BEGb[6] VPWR VGND sg13g2_buf_1
Xoutput82 net82 N4BEG[3] VPWR VGND sg13g2_buf_1
XFILLER_9_167 VPWR VGND sg13g2_decap_8
XFILLER_9_123 VPWR VGND sg13g2_decap_4
X_86_ S4END[1] net78 VPWR VGND sg13g2_buf_1
XFILLER_3_42 VPWR VGND sg13g2_decap_8
XFILLER_10_166 VPWR VGND sg13g2_fill_1
XFILLER_10_155 VPWR VGND sg13g2_decap_8
XFILLER_6_104 VPWR VGND sg13g2_fill_1
X_69_ S2END[2] net70 VPWR VGND sg13g2_buf_1
XFILLER_3_118 VPWR VGND sg13g2_decap_8
XFILLER_0_21 VPWR VGND sg13g2_decap_8
XFILLER_2_184 VPWR VGND sg13g2_decap_8
XFILLER_6_42 VPWR VGND sg13g2_decap_8
XFILLER_6_97 VPWR VGND sg13g2_fill_1
Xoutput83 net83 N4BEG[4] VPWR VGND sg13g2_buf_1
Xoutput61 net61 N2BEG[4] VPWR VGND sg13g2_buf_1
Xoutput50 net50 FrameStrobe_O[7] VPWR VGND sg13g2_buf_1
Xoutput4 net4 FrameData_O[12] VPWR VGND sg13g2_buf_1
Xoutput72 net72 N2BEGb[7] VPWR VGND sg13g2_buf_1
XFILLER_9_146 VPWR VGND sg13g2_decap_8
X_85_ S4END[2] net77 VPWR VGND sg13g2_buf_1
XFILLER_3_21 VPWR VGND sg13g2_decap_8
XFILLER_3_98 VPWR VGND sg13g2_decap_4
XFILLER_10_101 VPWR VGND sg13g2_fill_1
XFILLER_5_171 VPWR VGND sg13g2_fill_2
X_68_ S2END[3] net69 VPWR VGND sg13g2_buf_1
XFILLER_2_163 VPWR VGND sg13g2_decap_8
XFILLER_0_77 VPWR VGND sg13g2_decap_8
XFILLER_9_42 VPWR VGND sg13g2_decap_4
XFILLER_6_21 VPWR VGND sg13g2_decap_8
Xoutput40 net40 FrameStrobe_O[16] VPWR VGND sg13g2_buf_1
Xoutput51 net51 FrameStrobe_O[8] VPWR VGND sg13g2_buf_1
Xoutput73 net73 N4BEG[0] VPWR VGND sg13g2_buf_1
Xoutput5 net5 FrameData_O[13] VPWR VGND sg13g2_buf_1
Xoutput62 net62 N2BEG[5] VPWR VGND sg13g2_buf_1
Xoutput84 net84 N4BEG[5] VPWR VGND sg13g2_buf_1
X_84_ S4END[3] net76 VPWR VGND sg13g2_buf_1
XFILLER_3_77 VPWR VGND sg13g2_decap_8
XFILLER_10_113 VPWR VGND sg13g2_decap_8
XFILLER_8_191 VPWR VGND sg13g2_decap_8
X_67_ S2END[4] net68 VPWR VGND sg13g2_buf_1
XFILLER_2_142 VPWR VGND sg13g2_decap_8
XFILLER_3_0 VPWR VGND sg13g2_decap_8
XFILLER_9_87 VPWR VGND sg13g2_decap_8
XFILLER_0_56 VPWR VGND sg13g2_decap_8
XFILLER_9_21 VPWR VGND sg13g2_decap_8
XFILLER_6_88 VPWR VGND sg13g2_decap_8
Xoutput41 net41 FrameStrobe_O[17] VPWR VGND sg13g2_buf_1
Xoutput52 net52 FrameStrobe_O[9] VPWR VGND sg13g2_buf_1
Xoutput30 net30 FrameData_O[7] VPWR VGND sg13g2_buf_1
Xoutput6 net6 FrameData_O[14] VPWR VGND sg13g2_buf_1
Xoutput85 net85 N4BEG[6] VPWR VGND sg13g2_buf_1
Xoutput63 net63 N2BEG[6] VPWR VGND sg13g2_buf_1
Xoutput74 net74 N4BEG[10] VPWR VGND sg13g2_buf_1
.ends
