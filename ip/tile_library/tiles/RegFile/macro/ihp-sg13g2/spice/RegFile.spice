* NGSPICE file created from RegFile.ext - technology: ihp-sg13g2

* Black-box entry subcircuit for sg13g2_dlhq_1 abstract view
.subckt sg13g2_dlhq_1 D GATE Q VDD VSS
.ends

* Black-box entry subcircuit for sg13g2_mux2_1 abstract view
.subckt sg13g2_mux2_1 A0 A1 S X VDD VSS
.ends

* Black-box entry subcircuit for sg13g2_fill_1 abstract view
.subckt sg13g2_fill_1 VDD VSS
.ends

* Black-box entry subcircuit for sg13g2_a21oi_1 abstract view
.subckt sg13g2_a21oi_1 VSS VDD A1 A2 Y B1
.ends

* Black-box entry subcircuit for sg13g2_buf_8 abstract view
.subckt sg13g2_buf_8 A X VDD VSS
.ends

* Black-box entry subcircuit for sg13g2_o21ai_1 abstract view
.subckt sg13g2_o21ai_1 B1 VDD Y VSS A1 A2
.ends

* Black-box entry subcircuit for sg13g2_nand2_1 abstract view
.subckt sg13g2_nand2_1 Y A B VDD VSS
.ends

* Black-box entry subcircuit for sg13g2_dfrbpq_1 abstract view
.subckt sg13g2_dfrbpq_1 RESET_B VSS VDD D Q CLK
.ends

* Black-box entry subcircuit for sg13g2_a22oi_1 abstract view
.subckt sg13g2_a22oi_1 Y B1 B2 A2 A1 VDD VSS
.ends

* Black-box entry subcircuit for sg13g2_inv_1 abstract view
.subckt sg13g2_inv_1 VDD Y A VSS
.ends

* Black-box entry subcircuit for sg13g2_fill_2 abstract view
.subckt sg13g2_fill_2 VDD VSS
.ends

* Black-box entry subcircuit for sg13g2_mux4_1 abstract view
.subckt sg13g2_mux4_1 S0 A0 A1 A2 A3 S1 X VDD VSS
.ends

* Black-box entry subcircuit for sg13g2_buf_1 abstract view
.subckt sg13g2_buf_1 A X VDD VSS
.ends

* Black-box entry subcircuit for sg13g2_nor2_1 abstract view
.subckt sg13g2_nor2_1 A B Y VDD VSS
.ends

* Black-box entry subcircuit for sg13g2_tiehi abstract view
.subckt sg13g2_tiehi VDD VSS L_HI
.ends

* Black-box entry subcircuit for sg13g2_antennanp abstract view
.subckt sg13g2_antennanp VDD VSS A
.ends

* Black-box entry subcircuit for sg13g2_and2_1 abstract view
.subckt sg13g2_and2_1 A B X VDD VSS
.ends

* Black-box entry subcircuit for sg13g2_or2_1 abstract view
.subckt sg13g2_or2_1 VSS VDD X B A
.ends

* Black-box entry subcircuit for sg13g2_a21o_1 abstract view
.subckt sg13g2_a21o_1 A2 A1 B1 X VDD VSS
.ends

* Black-box entry subcircuit for sg13g2_nor2b_1 abstract view
.subckt sg13g2_nor2b_1 A B_N Y VDD VSS
.ends

* Black-box entry subcircuit for sg13g2_decap_4 abstract view
.subckt sg13g2_decap_4 VDD VSS
.ends

* Black-box entry subcircuit for sg13g2_nand2b_1 abstract view
.subckt sg13g2_nand2b_1 Y B A_N VDD VSS
.ends

* Black-box entry subcircuit for sg13g2_or3_1 abstract view
.subckt sg13g2_or3_1 A B C X VDD VSS
.ends

* Black-box entry subcircuit for sg13g2_a221oi_1 abstract view
.subckt sg13g2_a221oi_1 VDD VSS B2 C1 B1 A1 Y A2
.ends

* Black-box entry subcircuit for sg13g2_decap_8 abstract view
.subckt sg13g2_decap_8 VDD VSS
.ends

* Black-box entry subcircuit for sg13g2_nor3_1 abstract view
.subckt sg13g2_nor3_1 A B C Y VDD VSS
.ends

* Black-box entry subcircuit for sg13g2_nand3_1 abstract view
.subckt sg13g2_nand3_1 B C A Y VDD VSS
.ends

* Black-box entry subcircuit for sg13g2_nand3b_1 abstract view
.subckt sg13g2_nand3b_1 B C Y VDD VSS A_N
.ends

.subckt RegFile E1BEG[0] E1BEG[1] E1BEG[2] E1BEG[3] E1END[0] E1END[1] E1END[2] E1END[3]
+ E2BEG[0] E2BEG[1] E2BEG[2] E2BEG[3] E2BEG[4] E2BEG[5] E2BEG[6] E2BEG[7] E2BEGb[0]
+ E2BEGb[1] E2BEGb[2] E2BEGb[3] E2BEGb[4] E2BEGb[5] E2BEGb[6] E2BEGb[7] E2END[0] E2END[1]
+ E2END[2] E2END[3] E2END[4] E2END[5] E2END[6] E2END[7] E2MID[0] E2MID[1] E2MID[2]
+ E2MID[3] E2MID[4] E2MID[5] E2MID[6] E2MID[7] E6BEG[0] E6BEG[10] E6BEG[11] E6BEG[1]
+ E6BEG[2] E6BEG[3] E6BEG[4] E6BEG[5] E6BEG[6] E6BEG[7] E6BEG[8] E6BEG[9] E6END[0]
+ E6END[10] E6END[11] E6END[1] E6END[2] E6END[3] E6END[4] E6END[5] E6END[6] E6END[7]
+ E6END[8] E6END[9] EE4BEG[0] EE4BEG[10] EE4BEG[11] EE4BEG[12] EE4BEG[13] EE4BEG[14]
+ EE4BEG[15] EE4BEG[1] EE4BEG[2] EE4BEG[3] EE4BEG[4] EE4BEG[5] EE4BEG[6] EE4BEG[7]
+ EE4BEG[8] EE4BEG[9] EE4END[0] EE4END[10] EE4END[11] EE4END[12] EE4END[13] EE4END[14]
+ EE4END[15] EE4END[1] EE4END[2] EE4END[3] EE4END[4] EE4END[5] EE4END[6] EE4END[7]
+ EE4END[8] EE4END[9] FrameData[0] FrameData[10] FrameData[11] FrameData[12] FrameData[13]
+ FrameData[14] FrameData[15] FrameData[16] FrameData[17] FrameData[18] FrameData[19]
+ FrameData[1] FrameData[20] FrameData[21] FrameData[22] FrameData[23] FrameData[24]
+ FrameData[25] FrameData[26] FrameData[27] FrameData[28] FrameData[29] FrameData[2]
+ FrameData[30] FrameData[31] FrameData[3] FrameData[4] FrameData[5] FrameData[6]
+ FrameData[7] FrameData[8] FrameData[9] FrameData_O[0] FrameData_O[10] FrameData_O[11]
+ FrameData_O[12] FrameData_O[13] FrameData_O[14] FrameData_O[15] FrameData_O[16]
+ FrameData_O[17] FrameData_O[18] FrameData_O[19] FrameData_O[1] FrameData_O[20] FrameData_O[21]
+ FrameData_O[22] FrameData_O[23] FrameData_O[24] FrameData_O[25] FrameData_O[26]
+ FrameData_O[27] FrameData_O[28] FrameData_O[29] FrameData_O[2] FrameData_O[30] FrameData_O[31]
+ FrameData_O[3] FrameData_O[4] FrameData_O[5] FrameData_O[6] FrameData_O[7] FrameData_O[8]
+ FrameData_O[9] FrameStrobe[0] FrameStrobe[10] FrameStrobe[11] FrameStrobe[12] FrameStrobe[13]
+ FrameStrobe[14] FrameStrobe[15] FrameStrobe[16] FrameStrobe[17] FrameStrobe[18]
+ FrameStrobe[19] FrameStrobe[1] FrameStrobe[2] FrameStrobe[3] FrameStrobe[4] FrameStrobe[5]
+ FrameStrobe[6] FrameStrobe[7] FrameStrobe[8] FrameStrobe[9] FrameStrobe_O[0] FrameStrobe_O[10]
+ FrameStrobe_O[11] FrameStrobe_O[12] FrameStrobe_O[13] FrameStrobe_O[14] FrameStrobe_O[15]
+ FrameStrobe_O[16] FrameStrobe_O[17] FrameStrobe_O[18] FrameStrobe_O[19] FrameStrobe_O[1]
+ FrameStrobe_O[2] FrameStrobe_O[3] FrameStrobe_O[4] FrameStrobe_O[5] FrameStrobe_O[6]
+ FrameStrobe_O[7] FrameStrobe_O[8] FrameStrobe_O[9] N1BEG[0] N1BEG[1] N1BEG[2] N1BEG[3]
+ N1END[0] N1END[1] N1END[2] N1END[3] N2BEG[0] N2BEG[1] N2BEG[2] N2BEG[3] N2BEG[4]
+ N2BEG[5] N2BEG[6] N2BEG[7] N2BEGb[0] N2BEGb[1] N2BEGb[2] N2BEGb[3] N2BEGb[4] N2BEGb[5]
+ N2BEGb[6] N2BEGb[7] N2END[0] N2END[1] N2END[2] N2END[3] N2END[4] N2END[5] N2END[6]
+ N2END[7] N2MID[0] N2MID[1] N2MID[2] N2MID[3] N2MID[4] N2MID[5] N2MID[6] N2MID[7]
+ N4BEG[0] N4BEG[10] N4BEG[11] N4BEG[12] N4BEG[13] N4BEG[14] N4BEG[15] N4BEG[1] N4BEG[2]
+ N4BEG[3] N4BEG[4] N4BEG[5] N4BEG[6] N4BEG[7] N4BEG[8] N4BEG[9] N4END[0] N4END[10]
+ N4END[11] N4END[12] N4END[13] N4END[14] N4END[15] N4END[1] N4END[2] N4END[3] N4END[4]
+ N4END[5] N4END[6] N4END[7] N4END[8] N4END[9] NN4BEG[0] NN4BEG[10] NN4BEG[11] NN4BEG[12]
+ NN4BEG[13] NN4BEG[14] NN4BEG[15] NN4BEG[1] NN4BEG[2] NN4BEG[3] NN4BEG[4] NN4BEG[5]
+ NN4BEG[6] NN4BEG[7] NN4BEG[8] NN4BEG[9] NN4END[0] NN4END[10] NN4END[11] NN4END[12]
+ NN4END[13] NN4END[14] NN4END[15] NN4END[1] NN4END[2] NN4END[3] NN4END[4] NN4END[5]
+ NN4END[6] NN4END[7] NN4END[8] NN4END[9] S1BEG[0] S1BEG[1] S1BEG[2] S1BEG[3] S1END[0]
+ S1END[1] S1END[2] S1END[3] S2BEG[0] S2BEG[1] S2BEG[2] S2BEG[3] S2BEG[4] S2BEG[5]
+ S2BEG[6] S2BEG[7] S2BEGb[0] S2BEGb[1] S2BEGb[2] S2BEGb[3] S2BEGb[4] S2BEGb[5] S2BEGb[6]
+ S2BEGb[7] S2END[0] S2END[1] S2END[2] S2END[3] S2END[4] S2END[5] S2END[6] S2END[7]
+ S2MID[0] S2MID[1] S2MID[2] S2MID[3] S2MID[4] S2MID[5] S2MID[6] S2MID[7] S4BEG[0]
+ S4BEG[10] S4BEG[11] S4BEG[12] S4BEG[13] S4BEG[14] S4BEG[15] S4BEG[1] S4BEG[2] S4BEG[3]
+ S4BEG[4] S4BEG[5] S4BEG[6] S4BEG[7] S4BEG[8] S4BEG[9] S4END[0] S4END[10] S4END[11]
+ S4END[12] S4END[13] S4END[14] S4END[15] S4END[1] S4END[2] S4END[3] S4END[4] S4END[5]
+ S4END[6] S4END[7] S4END[8] S4END[9] SS4BEG[0] SS4BEG[10] SS4BEG[11] SS4BEG[12] SS4BEG[13]
+ SS4BEG[14] SS4BEG[15] SS4BEG[1] SS4BEG[2] SS4BEG[3] SS4BEG[4] SS4BEG[5] SS4BEG[6]
+ SS4BEG[7] SS4BEG[8] SS4BEG[9] SS4END[0] SS4END[10] SS4END[11] SS4END[12] SS4END[13]
+ SS4END[14] SS4END[15] SS4END[1] SS4END[2] SS4END[3] SS4END[4] SS4END[5] SS4END[6]
+ SS4END[7] SS4END[8] SS4END[9] UserCLK UserCLKo VGND VPWR W1BEG[0] W1BEG[1] W1BEG[2]
+ W1BEG[3] W1END[0] W1END[1] W1END[2] W1END[3] W2BEG[0] W2BEG[1] W2BEG[2] W2BEG[3]
+ W2BEG[4] W2BEG[5] W2BEG[6] W2BEG[7] W2BEGb[0] W2BEGb[1] W2BEGb[2] W2BEGb[3] W2BEGb[4]
+ W2BEGb[5] W2BEGb[6] W2BEGb[7] W2END[0] W2END[1] W2END[2] W2END[3] W2END[4] W2END[5]
+ W2END[6] W2END[7] W2MID[0] W2MID[1] W2MID[2] W2MID[3] W2MID[4] W2MID[5] W2MID[6]
+ W2MID[7] W6BEG[0] W6BEG[10] W6BEG[11] W6BEG[1] W6BEG[2] W6BEG[3] W6BEG[4] W6BEG[5]
+ W6BEG[6] W6BEG[7] W6BEG[8] W6BEG[9] W6END[0] W6END[10] W6END[11] W6END[1] W6END[2]
+ W6END[3] W6END[4] W6END[5] W6END[6] W6END[7] W6END[8] W6END[9] WW4BEG[0] WW4BEG[10]
+ WW4BEG[11] WW4BEG[12] WW4BEG[13] WW4BEG[14] WW4BEG[15] WW4BEG[1] WW4BEG[2] WW4BEG[3]
+ WW4BEG[4] WW4BEG[5] WW4BEG[6] WW4BEG[7] WW4BEG[8] WW4BEG[9] WW4END[0] WW4END[10]
+ WW4END[11] WW4END[12] WW4END[13] WW4END[14] WW4END[15] WW4END[1] WW4END[2] WW4END[3]
+ WW4END[4] WW4END[5] WW4END[6] WW4END[7] WW4END[8] WW4END[9]
X_3155_ FrameData[23] FrameStrobe[1] Inst_RegFile_ConfigMem.Inst_frame1_bit23.Q VPWR
+ VGND sg13g2_dlhq_1
X_2037_ BD2 BD3 Inst_RegFile_ConfigMem.Inst_frame1_bit8.Q _0651_ VPWR VGND sg13g2_mux2_1
X_3086_ FrameData[18] FrameStrobe[3] Inst_RegFile_ConfigMem.Inst_frame3_bit18.Q VPWR
+ VGND sg13g2_dlhq_1
XFILLER_39_244 VPWR VGND sg13g2_fill_1
X_2106_ VGND VPWR Inst_RegFile_ConfigMem.Inst_frame1_bit4.Q _1164_ _0716_ Inst_RegFile_ConfigMem.Inst_frame1_bit5.Q
+ sg13g2_a21oi_1
X_2939_ FrameData[31] FrameStrobe[8] Inst_RegFile_ConfigMem.Inst_frame8_bit31.Q VPWR
+ VGND sg13g2_dlhq_1
Xclkbuf_5_29__f_UserCLK_regs clknet_4_14_0_UserCLK_regs clknet_5_29__leaf_UserCLK_regs
+ VPWR VGND sg13g2_buf_8
XFILLER_36_247 VPWR VGND sg13g2_fill_1
X_1606_ _0245_ VPWR _0246_ VGND _1210_ _0242_ sg13g2_o21ai_1
X_2655_ _1121_ _1092_ _1097_ VPWR VGND sg13g2_nand2_1
X_2724_ _1345_ VGND VPWR _0018_ Inst_RegFile_32x4.mem\[28\]\[2\] clknet_5_9__leaf_UserCLK_regs
+ sg13g2_dfrbpq_1
X_1537_ Inst_RegFile_switch_matrix.JW2BEG5 _0177_ _0179_ _0175_ _0174_ VPWR VGND sg13g2_a22oi_1
X_1468_ N1END[2] N2END[6] Inst_RegFile_ConfigMem.Inst_frame2_bit20.Q _1224_ VPWR VGND
+ sg13g2_mux2_1
X_1399_ VPWR _1157_ Inst_RegFile_ConfigMem.Inst_frame11_bit23.Q VGND sg13g2_inv_1
X_2586_ Inst_RegFile_32x4.mem\[13\]\[3\] _1087_ _1104_ _0035_ VPWR VGND sg13g2_mux2_1
X_3207_ _1276_ VGND VPWR _0079_ Inst_RegFile_32x4.mem\[19\]\[3\] clknet_5_3__leaf_UserCLK_regs
+ sg13g2_dfrbpq_1
XFILLER_27_236 VPWR VGND sg13g2_fill_2
X_3138_ FrameData[6] FrameStrobe[1] Inst_RegFile_ConfigMem.Inst_frame1_bit6.Q VPWR
+ VGND sg13g2_dlhq_1
X_3069_ FrameData[1] FrameStrobe[3] Inst_RegFile_ConfigMem.Inst_frame3_bit1.Q VPWR
+ VGND sg13g2_dlhq_1
X_2440_ Inst_RegFile_ConfigMem.Inst_frame10_bit28.Q BD3 _0338_ Inst_RegFile_switch_matrix.JS2BEG1
+ _0429_ Inst_RegFile_ConfigMem.Inst_frame10_bit29.Q Inst_RegFile_switch_matrix.W1BEG2
+ VPWR VGND sg13g2_mux4_1
X_2371_ Inst_RegFile_ConfigMem.Inst_frame11_bit25.Q BD0 BD2 BD1 BD3 Inst_RegFile_ConfigMem.Inst_frame11_bit24.Q
+ _0959_ VPWR VGND sg13g2_mux4_1
XFILLER_49_394 VPWR VGND sg13g2_fill_1
XFILLER_24_228 VPWR VGND sg13g2_fill_1
Xoutput253 net253 WW4BEG[9] VPWR VGND sg13g2_buf_1
Xoutput220 net220 W2BEGb[2] VPWR VGND sg13g2_buf_1
Xoutput231 net231 W6BEG[3] VPWR VGND sg13g2_buf_1
X_2638_ _1069_ Inst_RegFile_32x4.mem\[21\]\[2\] _1117_ _0074_ VPWR VGND sg13g2_mux2_1
Xoutput242 net242 WW4BEG[13] VPWR VGND sg13g2_buf_1
X_2707_ _1362_ VGND VPWR _0001_ Inst_RegFile_32x4.mem\[24\]\[1\] clknet_5_5__leaf_UserCLK_regs
+ sg13g2_dfrbpq_1
X_2569_ _1099_ _1090_ _1094_ VPWR VGND sg13g2_nand2_1
XFILLER_47_309 VPWR VGND sg13g2_fill_1
XFILLER_2_143 VPWR VGND sg13g2_fill_2
X_1871_ _0497_ _0494_ _0496_ _0462_ _0460_ VPWR VGND sg13g2_a22oi_1
X_3610_ W2MID[1] net219 VPWR VGND sg13g2_buf_1
XFILLER_14_294 VPWR VGND sg13g2_fill_1
X_1940_ VGND VPWR _0367_ _0558_ _0560_ _0409_ sg13g2_a21oi_1
X_3472_ FrameStrobe[0] net81 VPWR VGND sg13g2_buf_1
X_3541_ Inst_RegFile_switch_matrix.NN4BEG1 net141 VPWR VGND sg13g2_buf_1
X_2423_ Inst_RegFile_ConfigMem.Inst_frame12_bit26.Q N1END[0] E1END[0] W1END[0] AD3
+ Inst_RegFile_ConfigMem.Inst_frame12_bit27.Q _1004_ VPWR VGND sg13g2_mux4_1
X_2354_ Inst_RegFile_ConfigMem.Inst_frame10_bit20.Q _0944_ _0945_ VPWR VGND sg13g2_nor2_1
X_2285_ _0883_ VPWR _0884_ VGND Inst_RegFile_ConfigMem.Inst_frame4_bit0.Q BD0 sg13g2_o21ai_1
XFILLER_44_19 VPWR VGND sg13g2_fill_2
X_2070_ Inst_RegFile_ConfigMem.Inst_frame3_bit10.Q VPWR _0682_ VGND Inst_RegFile_ConfigMem.Inst_frame3_bit9.Q
+ _0681_ sg13g2_o21ai_1
X_2972_ FrameData[0] FrameStrobe[6] Inst_RegFile_ConfigMem.Inst_frame6_bit0.Q VPWR
+ VGND sg13g2_dlhq_1
XFILLER_34_378 VPWR VGND sg13g2_fill_1
X_1854_ _0480_ VPWR _0481_ VGND Inst_RegFile_ConfigMem.Inst_frame4_bit25.Q _0479_
+ sg13g2_o21ai_1
X_1923_ VGND VPWR Inst_RegFile_32x4.mem\[11\]\[3\] B_ADR0 _0545_ _0544_ sg13g2_a21oi_1
X_1785_ _0413_ VPWR _0414_ VGND Inst_RegFile_ConfigMem.Inst_frame1_bit16.Q _1167_
+ sg13g2_o21ai_1
X_3524_ Inst_RegFile_switch_matrix.N4BEG0 net124 VPWR VGND sg13g2_buf_1
X_3455_ FrameData[15] net55 VPWR VGND sg13g2_buf_1
X_2406_ Inst_RegFile_ConfigMem.Inst_frame11_bit12.Q BD2 _0895_ _0896_ _0641_ Inst_RegFile_ConfigMem.Inst_frame11_bit11.Q
+ _0990_ VPWR VGND sg13g2_mux4_1
X_3386_ VPWR VGND _1368_ sg13g2_tiehi
XFILLER_39_19 VPWR VGND sg13g2_fill_1
X_2268_ Inst_RegFile_ConfigMem.Inst_frame4_bit30.Q VPWR _0868_ VGND Inst_RegFile_ConfigMem.Inst_frame4_bit29.Q
+ _0867_ sg13g2_o21ai_1
X_2199_ VGND VPWR Inst_RegFile_ConfigMem.Inst_frame2_bit28.Q BD2 _0803_ _0802_ sg13g2_a21oi_1
X_2337_ Inst_RegFile_ConfigMem.Inst_frame9_bit4.Q BD2 _0895_ _0896_ _0138_ Inst_RegFile_ConfigMem.Inst_frame9_bit3.Q
+ _0931_ VPWR VGND sg13g2_mux4_1
XFILLER_52_142 VPWR VGND sg13g2_fill_1
XFILLER_40_304 VPWR VGND sg13g2_fill_2
XFILLER_43_131 VPWR VGND sg13g2_fill_2
XFILLER_28_161 VPWR VGND sg13g2_fill_2
XFILLER_16_312 VPWR VGND sg13g2_fill_2
XANTENNA_5 VPWR VGND EE4END[5] sg13g2_antennanp
X_3240_ _1243_ VGND VPWR _0112_ Inst_RegFile_32x4.mem\[0\]\[0\] clknet_5_25__leaf_UserCLK_regs
+ sg13g2_dfrbpq_1
X_1570_ _0211_ Inst_RegFile_ConfigMem.Inst_frame8_bit20.Q _0210_ VPWR VGND sg13g2_nand2_1
X_2053_ VGND VPWR _0664_ _0665_ _0666_ Inst_RegFile_ConfigMem.Inst_frame2_bit9.Q sg13g2_a21oi_1
X_2122_ _0730_ VPWR _0731_ VGND Inst_RegFile_ConfigMem.Inst_frame2_bit4.Q BD0 sg13g2_o21ai_1
X_3171_ FrameData[7] FrameStrobe[0] Inst_RegFile_ConfigMem.Inst_frame0_bit7.Q VPWR
+ VGND sg13g2_dlhq_1
X_2955_ FrameData[15] FrameStrobe[7] Inst_RegFile_ConfigMem.Inst_frame7_bit15.Q VPWR
+ VGND sg13g2_dlhq_1
X_1837_ _0463_ VPWR _0464_ VGND Inst_RegFile_ConfigMem.Inst_frame4_bit24.Q _1167_
+ sg13g2_o21ai_1
X_1768_ _0398_ Inst_RegFile_ConfigMem.Inst_frame2_bit16.Q BD1 VPWR VGND sg13g2_nand2_1
X_3507_ N2MID[3] net116 VPWR VGND sg13g2_buf_1
X_1906_ VGND VPWR _0409_ _0529_ _0530_ _0460_ sg13g2_a21oi_1
X_2886_ FrameData[10] FrameStrobe[9] Inst_RegFile_ConfigMem.Inst_frame9_bit10.Q VPWR
+ VGND sg13g2_dlhq_1
X_3438_ Inst_RegFile_switch_matrix.EE4BEG2 net38 VPWR VGND sg13g2_buf_1
X_1699_ VGND VPWR Inst_RegFile_32x4.mem\[23\]\[3\] A_ADR0 _0333_ _0332_ sg13g2_a21oi_1
X_3369_ VPWR VGND _1351_ sg13g2_tiehi
Xclkbuf_5_1__f_UserCLK_regs clknet_4_0_0_UserCLK_regs clknet_5_1__leaf_UserCLK_regs
+ VPWR VGND sg13g2_buf_8
XFILLER_31_20 VPWR VGND sg13g2_fill_1
Xoutput53 net53 FrameData_O[13] VPWR VGND sg13g2_buf_1
Xoutput75 net75 FrameData_O[4] VPWR VGND sg13g2_buf_1
Xoutput64 net64 FrameData_O[23] VPWR VGND sg13g2_buf_1
Xoutput20 net20 E2BEGb[7] VPWR VGND sg13g2_buf_1
Xoutput31 net31 E6BEG[8] VPWR VGND sg13g2_buf_1
Xoutput42 net42 EE4BEG[3] VPWR VGND sg13g2_buf_1
Xoutput7 net7 E2BEG[2] VPWR VGND sg13g2_buf_1
Xoutput86 net86 FrameStrobe_O[14] VPWR VGND sg13g2_buf_1
Xoutput97 net97 FrameStrobe_O[6] VPWR VGND sg13g2_buf_1
X_2671_ _1090_ _1122_ _1125_ VPWR VGND sg13g2_and2_1
X_2740_ _1329_ VGND VPWR _0034_ Inst_RegFile_32x4.mem\[13\]\[2\] clknet_5_25__leaf_UserCLK_regs
+ sg13g2_dfrbpq_1
X_1622_ _0186_ _0192_ _0247_ _0250_ _0261_ _0236_ Inst_RegFile_32x4.AD_comb\[0\] VPWR
+ VGND sg13g2_mux4_1
X_3223_ _1260_ VGND VPWR _0095_ Inst_RegFile_32x4.mem\[4\]\[3\] clknet_5_29__leaf_UserCLK_regs
+ sg13g2_dfrbpq_1
X_1553_ VGND VPWR _0195_ W1END[2] Inst_RegFile_ConfigMem.Inst_frame4_bit20.Q sg13g2_or2_1
X_1484_ _0128_ Inst_RegFile_ConfigMem.Inst_frame2_bit13.Q _1143_ _0129_ VPWR VGND
+ sg13g2_a21o_1
X_3154_ FrameData[22] FrameStrobe[1] Inst_RegFile_ConfigMem.Inst_frame1_bit22.Q VPWR
+ VGND sg13g2_dlhq_1
XFILLER_54_215 VPWR VGND sg13g2_fill_1
X_2036_ VGND VPWR Inst_RegFile_ConfigMem.Inst_frame1_bit8.Q BD1 _0650_ _0649_ sg13g2_a21oi_1
X_3085_ FrameData[17] FrameStrobe[3] Inst_RegFile_ConfigMem.Inst_frame3_bit17.Q VPWR
+ VGND sg13g2_dlhq_1
XFILLER_39_267 VPWR VGND sg13g2_fill_2
X_2105_ _1165_ Inst_RegFile_ConfigMem.Inst_frame1_bit4.Q _0714_ _0715_ VPWR VGND sg13g2_a21o_1
XFILLER_11_0 VPWR VGND sg13g2_fill_1
X_2938_ FrameData[30] FrameStrobe[8] Inst_RegFile_ConfigMem.Inst_frame8_bit30.Q VPWR
+ VGND sg13g2_dlhq_1
Xclkbuf_5_16__f_UserCLK_regs clknet_4_8_0_UserCLK_regs clknet_5_16__leaf_UserCLK_regs
+ VPWR VGND sg13g2_buf_8
X_2869_ FrameData[25] FrameStrobe[10] Inst_RegFile_ConfigMem.Inst_frame10_bit25.Q
+ VPWR VGND sg13g2_dlhq_1
X_2723_ _1346_ VGND VPWR _0017_ Inst_RegFile_32x4.mem\[28\]\[1\] clknet_5_12__leaf_UserCLK_regs
+ sg13g2_dfrbpq_1
X_1536_ VGND VPWR Inst_RegFile_ConfigMem.Inst_frame1_bit22.Q _0178_ _0179_ Inst_RegFile_ConfigMem.Inst_frame1_bit23.Q
+ sg13g2_a21oi_1
X_1605_ VGND VPWR _1210_ _0244_ _0245_ _0143_ sg13g2_a21oi_1
X_2585_ Inst_RegFile_32x4.mem\[13\]\[2\] _1069_ _1104_ _0034_ VPWR VGND sg13g2_mux2_1
XFILLER_8_171 VPWR VGND sg13g2_fill_1
X_2654_ _1087_ Inst_RegFile_32x4.mem\[31\]\[3\] _1120_ _0087_ VPWR VGND sg13g2_mux2_1
X_1467_ E1END[2] E2END[6] Inst_RegFile_ConfigMem.Inst_frame2_bit20.Q _1223_ VPWR VGND
+ sg13g2_mux2_1
X_1398_ VPWR _1156_ Inst_RegFile_ConfigMem.Inst_frame11_bit22.Q VGND sg13g2_inv_1
X_3206_ _1277_ VGND VPWR _0078_ Inst_RegFile_32x4.mem\[19\]\[2\] clknet_5_0__leaf_UserCLK_regs
+ sg13g2_dfrbpq_1
X_3137_ FrameData[5] FrameStrobe[1] Inst_RegFile_ConfigMem.Inst_frame1_bit5.Q VPWR
+ VGND sg13g2_dlhq_1
X_2019_ _0634_ VPWR _0635_ VGND Inst_RegFile_ConfigMem.Inst_frame4_bit14.Q _0633_
+ sg13g2_o21ai_1
X_3068_ FrameData[0] FrameStrobe[3] Inst_RegFile_ConfigMem.Inst_frame3_bit0.Q VPWR
+ VGND sg13g2_dlhq_1
XFILLER_41_295 VPWR VGND sg13g2_fill_2
X_2370_ Inst_RegFile_ConfigMem.Inst_frame11_bit24.Q _0896_ _0895_ _1229_ _0388_ Inst_RegFile_ConfigMem.Inst_frame11_bit25.Q
+ _0958_ VPWR VGND sg13g2_mux4_1
XFILLER_32_295 VPWR VGND sg13g2_fill_2
X_2706_ _1314_ VGND VPWR _0000_ Inst_RegFile_32x4.mem\[24\]\[0\] clknet_5_13__leaf_UserCLK_regs
+ sg13g2_dfrbpq_1
X_2568_ Inst_RegFile_32x4.mem\[2\]\[3\] _1087_ _1098_ _0023_ VPWR VGND sg13g2_mux2_1
Xoutput243 net243 WW4BEG[14] VPWR VGND sg13g2_buf_1
Xoutput232 net232 W6BEG[4] VPWR VGND sg13g2_buf_1
Xoutput221 net221 W2BEGb[3] VPWR VGND sg13g2_buf_1
Xoutput210 net210 W2BEG[0] VPWR VGND sg13g2_buf_1
X_2637_ _1067_ Inst_RegFile_32x4.mem\[21\]\[1\] _1117_ _0073_ VPWR VGND sg13g2_mux2_1
X_1519_ VGND VPWR Inst_RegFile_ConfigMem.Inst_frame0_bit22.Q Inst_RegFile_switch_matrix.JW2BEG3
+ _0162_ _0161_ sg13g2_a21oi_1
X_2499_ Inst_RegFile_ConfigMem.Inst_frame7_bit11.Q N2MID[2] W2MID[2] E2MID[2] Inst_RegFile_switch_matrix.E2BEG4
+ Inst_RegFile_ConfigMem.Inst_frame7_bit10.Q _1053_ VPWR VGND sg13g2_mux4_1
XFILLER_11_446 VPWR VGND sg13g2_fill_2
XFILLER_46_398 VPWR VGND sg13g2_fill_2
XFILLER_46_332 VPWR VGND sg13g2_fill_2
X_3540_ Inst_RegFile_switch_matrix.NN4BEG0 net140 VPWR VGND sg13g2_buf_1
X_1870_ VGND VPWR _0409_ _0495_ _0496_ _0460_ sg13g2_a21oi_1
X_3471_ FrameData[31] net73 VPWR VGND sg13g2_buf_1
X_2422_ _0999_ _1002_ _1003_ VPWR VGND sg13g2_nor2_1
X_2353_ Inst_RegFile_ConfigMem.Inst_frame10_bit18.Q N1END[0] E1END[0] W1END[0] AD3
+ Inst_RegFile_ConfigMem.Inst_frame10_bit19.Q _0944_ VPWR VGND sg13g2_mux4_1
X_2284_ VGND VPWR Inst_RegFile_ConfigMem.Inst_frame4_bit0.Q _1164_ _0883_ Inst_RegFile_ConfigMem.Inst_frame4_bit1.Q
+ sg13g2_a21oi_1
XFILLER_52_335 VPWR VGND sg13g2_fill_1
X_1999_ _0615_ VPWR B_ADR0 VGND _0602_ _0604_ sg13g2_o21ai_1
XFILLER_43_368 VPWR VGND sg13g2_fill_2
XFILLER_34_20 VPWR VGND sg13g2_fill_1
Xclkbuf_4_6_0_UserCLK_regs clknet_0_UserCLK_regs clknet_4_6_0_UserCLK_regs VPWR VGND
+ sg13g2_buf_8
XFILLER_50_52 VPWR VGND sg13g2_fill_2
X_1922_ B_ADR0 Inst_RegFile_32x4.mem\[10\]\[3\] _0544_ VPWR VGND sg13g2_nor2b_1
XFILLER_34_313 VPWR VGND sg13g2_fill_2
X_2971_ FrameData[31] FrameStrobe[7] Inst_RegFile_ConfigMem.Inst_frame7_bit31.Q VPWR
+ VGND sg13g2_dlhq_1
X_1853_ VGND VPWR Inst_RegFile_ConfigMem.Inst_frame4_bit25.Q _0477_ _0480_ _1132_
+ sg13g2_a21oi_1
X_1784_ _0413_ Inst_RegFile_ConfigMem.Inst_frame1_bit16.Q AD2 VPWR VGND sg13g2_nand2_1
X_3523_ N4END[15] net123 VPWR VGND sg13g2_buf_1
XFILLER_6_280 VPWR VGND sg13g2_fill_2
X_3454_ FrameData[14] net54 VPWR VGND sg13g2_buf_1
XFILLER_41_0 VPWR VGND sg13g2_fill_2
X_3385_ VPWR VGND _1367_ sg13g2_tiehi
X_2405_ _0987_ _0989_ Inst_RegFile_switch_matrix.EE4BEG2 VPWR VGND sg13g2_nor2_1
X_2336_ _0928_ _0930_ Inst_RegFile_switch_matrix.WW4BEG2 VPWR VGND sg13g2_nor2_1
X_2267_ VGND VPWR Inst_RegFile_ConfigMem.Inst_frame4_bit28.Q BD0 _0867_ _0866_ sg13g2_a21oi_1
X_2198_ Inst_RegFile_ConfigMem.Inst_frame2_bit28.Q BD1 _0802_ VPWR VGND sg13g2_nor2b_1
XFILLER_28_184 VPWR VGND sg13g2_decap_4
XANTENNA_6 VPWR VGND EE4END[6] sg13g2_antennanp
XFILLER_3_272 VPWR VGND sg13g2_fill_2
X_3170_ FrameData[6] FrameStrobe[0] Inst_RegFile_ConfigMem.Inst_frame0_bit6.Q VPWR
+ VGND sg13g2_dlhq_1
X_2052_ _0665_ BD0 Inst_RegFile_ConfigMem.Inst_frame2_bit8.Q VPWR VGND sg13g2_nand2b_1
X_2121_ VGND VPWR Inst_RegFile_ConfigMem.Inst_frame2_bit4.Q _1164_ _0730_ Inst_RegFile_ConfigMem.Inst_frame2_bit5.Q
+ sg13g2_a21oi_1
X_1905_ B_ADR0 Inst_RegFile_32x4.mem\[4\]\[1\] Inst_RegFile_32x4.mem\[5\]\[1\] Inst_RegFile_32x4.mem\[6\]\[1\]
+ Inst_RegFile_32x4.mem\[7\]\[1\] _0368_ _0529_ VPWR VGND sg13g2_mux4_1
X_2885_ FrameData[9] FrameStrobe[9] Inst_RegFile_ConfigMem.Inst_frame9_bit9.Q VPWR
+ VGND sg13g2_dlhq_1
Xclkbuf_5_24__f_UserCLK_regs clknet_4_12_0_UserCLK_regs clknet_5_24__leaf_UserCLK_regs
+ VPWR VGND sg13g2_buf_8
X_2954_ FrameData[14] FrameStrobe[7] Inst_RegFile_ConfigMem.Inst_frame7_bit14.Q VPWR
+ VGND sg13g2_dlhq_1
X_3506_ N2MID[2] net115 VPWR VGND sg13g2_buf_1
X_1836_ _0463_ Inst_RegFile_ConfigMem.Inst_frame4_bit24.Q AD2 VPWR VGND sg13g2_nand2_1
X_1767_ Inst_RegFile_ConfigMem.Inst_frame2_bit17.Q VPWR _0397_ VGND Inst_RegFile_ConfigMem.Inst_frame2_bit16.Q
+ BD2 sg13g2_o21ai_1
X_1698_ A_ADR0 Inst_RegFile_32x4.mem\[22\]\[3\] _0332_ VPWR VGND sg13g2_nor2b_1
X_3437_ Inst_RegFile_switch_matrix.EE4BEG1 net37 VPWR VGND sg13g2_buf_1
X_2319_ _0915_ VPWR _0916_ VGND Inst_RegFile_ConfigMem.Inst_frame9_bit13.Q _0912_
+ sg13g2_o21ai_1
X_3299_ VPWR VGND _1281_ sg13g2_tiehi
X_3368_ VPWR VGND _1350_ sg13g2_tiehi
XFILLER_53_485 VPWR VGND sg13g2_fill_1
Xoutput98 net98 FrameStrobe_O[7] VPWR VGND sg13g2_buf_1
Xoutput87 net87 FrameStrobe_O[15] VPWR VGND sg13g2_buf_1
Xoutput32 net32 E6BEG[9] VPWR VGND sg13g2_buf_1
Xoutput54 net54 FrameData_O[14] VPWR VGND sg13g2_buf_1
Xoutput65 net65 FrameData_O[24] VPWR VGND sg13g2_buf_1
Xoutput76 net76 FrameData_O[5] VPWR VGND sg13g2_buf_1
Xoutput43 net43 EE4BEG[4] VPWR VGND sg13g2_buf_1
Xoutput10 net10 E2BEG[5] VPWR VGND sg13g2_buf_1
Xoutput8 net8 E2BEG[3] VPWR VGND sg13g2_buf_1
Xoutput21 net21 E6BEG[0] VPWR VGND sg13g2_buf_1
X_2670_ _1087_ Inst_RegFile_32x4.mem\[5\]\[3\] _1124_ _0099_ VPWR VGND sg13g2_mux2_1
X_1552_ _0193_ VPWR _0194_ VGND Inst_RegFile_ConfigMem.Inst_frame4_bit20.Q _1167_
+ sg13g2_o21ai_1
X_1621_ _0261_ _0260_ _0255_ VPWR VGND sg13g2_nand2b_1
X_3153_ FrameData[21] FrameStrobe[1] Inst_RegFile_ConfigMem.Inst_frame1_bit21.Q VPWR
+ VGND sg13g2_dlhq_1
X_3222_ _1261_ VGND VPWR _0094_ Inst_RegFile_32x4.mem\[4\]\[2\] clknet_5_31__leaf_UserCLK_regs
+ sg13g2_dfrbpq_1
X_2104_ Inst_RegFile_ConfigMem.Inst_frame1_bit5.Q VPWR _0714_ VGND Inst_RegFile_ConfigMem.Inst_frame1_bit4.Q
+ BD2 sg13g2_o21ai_1
X_1483_ BD2 BD3 Inst_RegFile_ConfigMem.Inst_frame2_bit12.Q _0128_ VPWR VGND sg13g2_mux2_1
X_2035_ Inst_RegFile_ConfigMem.Inst_frame1_bit8.Q BD0 _0649_ VPWR VGND sg13g2_nor2b_1
X_3084_ FrameData[16] FrameStrobe[3] Inst_RegFile_ConfigMem.Inst_frame3_bit16.Q VPWR
+ VGND sg13g2_dlhq_1
XFILLER_35_485 VPWR VGND sg13g2_fill_1
X_2868_ FrameData[24] FrameStrobe[10] Inst_RegFile_ConfigMem.Inst_frame10_bit24.Q
+ VPWR VGND sg13g2_dlhq_1
X_2937_ FrameData[29] FrameStrobe[8] Inst_RegFile_ConfigMem.Inst_frame8_bit29.Q VPWR
+ VGND sg13g2_dlhq_1
X_1819_ _0447_ _0446_ Inst_RegFile_ConfigMem.Inst_frame1_bit26.Q VPWR VGND sg13g2_nand2b_1
X_2799_ FrameData[19] FrameStrobe[12] Inst_RegFile_ConfigMem.Inst_frame12_bit19.Q
+ VPWR VGND sg13g2_dlhq_1
XFILLER_45_205 VPWR VGND sg13g2_fill_2
XFILLER_5_389 VPWR VGND sg13g2_fill_1
XFILLER_32_455 VPWR VGND sg13g2_fill_2
X_2722_ _1347_ VGND VPWR _0016_ Inst_RegFile_32x4.mem\[28\]\[0\] clknet_5_15__leaf_UserCLK_regs
+ sg13g2_dfrbpq_1
X_1535_ Inst_RegFile_ConfigMem.Inst_frame1_bit21.Q S1END[0] S2END[6] S1END[2] W1END[2]
+ Inst_RegFile_ConfigMem.Inst_frame1_bit20.Q _0178_ VPWR VGND sg13g2_mux4_1
X_1604_ VGND VPWR Inst_RegFile_32x4.mem\[5\]\[0\] A_ADR0 _0244_ _0243_ sg13g2_a21oi_1
X_2584_ Inst_RegFile_32x4.mem\[13\]\[1\] _1067_ _1104_ _0033_ VPWR VGND sg13g2_mux2_1
X_2653_ _1069_ Inst_RegFile_32x4.mem\[31\]\[2\] _1120_ _0086_ VPWR VGND sg13g2_mux2_1
X_1466_ Inst_RegFile_ConfigMem.Inst_frame2_bit23.Q VPWR _1222_ VGND _1219_ _1221_
+ sg13g2_o21ai_1
X_3067_ FrameData[31] FrameStrobe[4] Inst_RegFile_ConfigMem.Inst_frame4_bit31.Q VPWR
+ VGND sg13g2_dlhq_1
X_3136_ FrameData[4] FrameStrobe[1] Inst_RegFile_ConfigMem.Inst_frame1_bit4.Q VPWR
+ VGND sg13g2_dlhq_1
X_3205_ _1278_ VGND VPWR _0077_ Inst_RegFile_32x4.mem\[19\]\[1\] clknet_5_2__leaf_UserCLK_regs
+ sg13g2_dfrbpq_1
X_1397_ VPWR _1155_ Inst_RegFile_ConfigMem.Inst_frame10_bit13.Q VGND sg13g2_inv_1
XFILLER_42_208 VPWR VGND sg13g2_fill_1
X_2018_ Inst_RegFile_ConfigMem.Inst_frame4_bit15.Q _0632_ _0634_ VPWR VGND sg13g2_nor2_1
XFILLER_14_411 VPWR VGND sg13g2_fill_1
XFILLER_14_433 VPWR VGND sg13g2_fill_2
XFILLER_32_274 VPWR VGND sg13g2_fill_1
XFILLER_32_230 VPWR VGND sg13g2_fill_2
X_2705_ _1087_ Inst_RegFile_32x4.mem\[12\]\[3\] _1131_ _0127_ VPWR VGND sg13g2_mux2_1
X_2636_ _1065_ Inst_RegFile_32x4.mem\[21\]\[0\] _1117_ _0072_ VPWR VGND sg13g2_mux2_1
Xoutput200 net200 SS4BEG[5] VPWR VGND sg13g2_buf_1
X_2567_ Inst_RegFile_32x4.mem\[2\]\[2\] _1069_ _1098_ _0022_ VPWR VGND sg13g2_mux2_1
X_1449_ Inst_RegFile_ConfigMem.Inst_frame8_bit12.Q VPWR _1205_ VGND Inst_RegFile_ConfigMem.Inst_frame0_bit19.Q
+ _1204_ sg13g2_o21ai_1
Xoutput244 net244 WW4BEG[15] VPWR VGND sg13g2_buf_1
Xoutput222 net222 W2BEGb[4] VPWR VGND sg13g2_buf_1
Xoutput211 net211 W2BEG[1] VPWR VGND sg13g2_buf_1
Xoutput233 net233 W6BEG[5] VPWR VGND sg13g2_buf_1
X_2498_ VGND VPWR Inst_RegFile_ConfigMem.Inst_frame8_bit7.Q Inst_RegFile_switch_matrix.JN2BEG0
+ _1052_ _1051_ sg13g2_a21oi_1
X_1518_ Inst_RegFile_ConfigMem.Inst_frame0_bit23.Q VPWR _0161_ VGND _1138_ Inst_RegFile_ConfigMem.Inst_frame0_bit22.Q
+ sg13g2_o21ai_1
X_3119_ FrameData[19] FrameStrobe[2] Inst_RegFile_ConfigMem.Inst_frame2_bit19.Q VPWR
+ VGND sg13g2_dlhq_1
Xclkbuf_4_14_0_UserCLK_regs clknet_0_UserCLK_regs clknet_4_14_0_UserCLK_regs VPWR
+ VGND sg13g2_buf_8
XFILLER_14_263 VPWR VGND sg13g2_fill_2
X_3470_ FrameData[30] net72 VPWR VGND sg13g2_buf_1
X_2421_ Inst_RegFile_ConfigMem.Inst_frame12_bit28.Q VPWR _1002_ VGND Inst_RegFile_ConfigMem.Inst_frame12_bit27.Q
+ _1001_ sg13g2_o21ai_1
X_2352_ _0939_ _0942_ _0943_ VPWR VGND sg13g2_nor2_1
X_2283_ _0881_ VPWR _0882_ VGND Inst_RegFile_ConfigMem.Inst_frame4_bit1.Q _0880_ sg13g2_o21ai_1
XFILLER_37_322 VPWR VGND sg13g2_fill_2
X_1998_ Inst_RegFile_ConfigMem.Inst_frame8_bit22.Q _0609_ _0614_ _0615_ VPWR VGND
+ sg13g2_or3_1
X_2619_ _1087_ Inst_RegFile_32x4.mem\[16\]\[3\] _1113_ _0059_ VPWR VGND sg13g2_mux2_1
X_3599_ Inst_RegFile_switch_matrix.W1BEG2 net208 VPWR VGND sg13g2_buf_1
XFILLER_28_366 VPWR VGND sg13g2_fill_1
XFILLER_1_0 VPWR VGND sg13g2_fill_2
X_1852_ VGND VPWR Inst_RegFile_ConfigMem.Inst_frame4_bit24.Q S1END[3] _0479_ _0478_
+ sg13g2_a21oi_1
X_2970_ FrameData[30] FrameStrobe[7] Inst_RegFile_ConfigMem.Inst_frame7_bit30.Q VPWR
+ VGND sg13g2_dlhq_1
X_1921_ VPWR VGND _0542_ _0491_ _0540_ _0536_ _0543_ _0538_ sg13g2_a221oi_1
X_3453_ FrameData[13] net53 VPWR VGND sg13g2_buf_1
X_1783_ VGND VPWR _0367_ _0411_ _0412_ _0409_ sg13g2_a21oi_1
X_3522_ N4END[14] net122 VPWR VGND sg13g2_buf_1
X_2404_ Inst_RegFile_ConfigMem.Inst_frame11_bit16.Q _0988_ _0989_ VPWR VGND sg13g2_nor2_1
X_2266_ Inst_RegFile_ConfigMem.Inst_frame4_bit28.Q AD3 _0866_ VPWR VGND sg13g2_nor2b_1
X_3384_ VPWR VGND _1366_ sg13g2_tiehi
X_2335_ Inst_RegFile_ConfigMem.Inst_frame9_bit8.Q _0929_ _0930_ VPWR VGND sg13g2_nor2_1
XFILLER_52_133 VPWR VGND sg13g2_fill_1
XFILLER_40_306 VPWR VGND sg13g2_fill_1
X_2197_ _0801_ VPWR Inst_RegFile_switch_matrix.JW2BEG0 VGND _0790_ _0796_ sg13g2_o21ai_1
XFILLER_29_21 VPWR VGND sg13g2_fill_1
XFILLER_45_97 VPWR VGND sg13g2_fill_2
XFILLER_43_133 VPWR VGND sg13g2_fill_1
XANTENNA_7 VPWR VGND EE4END[7] sg13g2_antennanp
Xclkbuf_5_11__f_UserCLK_regs clknet_4_5_0_UserCLK_regs clknet_5_11__leaf_UserCLK_regs
+ VPWR VGND sg13g2_buf_8
X_2120_ VGND VPWR Inst_RegFile_ConfigMem.Inst_frame2_bit4.Q _1165_ _0729_ _0728_ sg13g2_a21oi_1
X_2051_ _0664_ Inst_RegFile_ConfigMem.Inst_frame2_bit8.Q BD1 VPWR VGND sg13g2_nand2_1
X_1835_ _0462_ _0461_ _0409_ _0412_ _0371_ VPWR VGND sg13g2_a22oi_1
X_1904_ _0528_ _0527_ _0409_ VPWR VGND sg13g2_nand2b_1
XFILLER_15_380 VPWR VGND sg13g2_fill_1
X_2953_ FrameData[13] FrameStrobe[7] Inst_RegFile_ConfigMem.Inst_frame7_bit13.Q VPWR
+ VGND sg13g2_dlhq_1
X_2884_ FrameData[8] FrameStrobe[9] Inst_RegFile_ConfigMem.Inst_frame9_bit8.Q VPWR
+ VGND sg13g2_dlhq_1
X_3436_ Inst_RegFile_switch_matrix.EE4BEG0 net36 VPWR VGND sg13g2_buf_1
X_1766_ BD3 Inst_RegFile_ConfigMem.Inst_frame2_bit16.Q _0396_ VPWR VGND sg13g2_nor2b_1
X_1697_ VGND VPWR Inst_RegFile_32x4.mem\[21\]\[3\] A_ADR0 _0331_ _0330_ sg13g2_a21oi_1
X_3505_ N2MID[1] net114 VPWR VGND sg13g2_buf_1
X_2318_ _1151_ _0914_ _0915_ VPWR VGND sg13g2_nor2_1
X_2249_ Inst_RegFile_ConfigMem.Inst_frame3_bit0.Q BD0 _0850_ VPWR VGND sg13g2_nor2b_1
X_3367_ VPWR VGND _1349_ sg13g2_tiehi
X_3298_ VPWR VGND _1280_ sg13g2_tiehi
Xoutput88 net88 FrameStrobe_O[16] VPWR VGND sg13g2_buf_1
Xoutput99 net99 FrameStrobe_O[8] VPWR VGND sg13g2_buf_1
Xoutput33 net33 EE4BEG[0] VPWR VGND sg13g2_buf_1
Xoutput55 net55 FrameData_O[15] VPWR VGND sg13g2_buf_1
Xoutput66 net66 FrameData_O[25] VPWR VGND sg13g2_buf_1
Xoutput22 net22 E6BEG[10] VPWR VGND sg13g2_buf_1
Xoutput9 net9 E2BEG[4] VPWR VGND sg13g2_buf_1
Xoutput44 net44 EE4BEG[5] VPWR VGND sg13g2_buf_1
Xoutput77 net77 FrameData_O[6] VPWR VGND sg13g2_buf_1
Xoutput11 net11 E2BEG[6] VPWR VGND sg13g2_buf_1
XFILLER_31_169 VPWR VGND sg13g2_fill_1
XFILLER_31_158 VPWR VGND sg13g2_decap_8
XFILLER_8_321 VPWR VGND sg13g2_fill_1
XFILLER_12_350 VPWR VGND sg13g2_fill_1
X_1551_ _0193_ Inst_RegFile_ConfigMem.Inst_frame4_bit20.Q AD2 VPWR VGND sg13g2_nand2_1
X_1620_ _0259_ VPWR _0260_ VGND _1210_ _0256_ sg13g2_o21ai_1
X_1482_ Inst_RegFile_ConfigMem.Inst_frame2_bit13.Q _1235_ _1236_ _1237_ VPWR VGND
+ sg13g2_nor3_1
X_3152_ FrameData[20] FrameStrobe[1] Inst_RegFile_ConfigMem.Inst_frame1_bit20.Q VPWR
+ VGND sg13g2_dlhq_1
X_3221_ _1262_ VGND VPWR _0093_ Inst_RegFile_32x4.mem\[4\]\[1\] clknet_5_23__leaf_UserCLK_regs
+ sg13g2_dfrbpq_1
X_2103_ _0712_ VPWR _0713_ VGND Inst_RegFile_ConfigMem.Inst_frame1_bit5.Q _0711_ sg13g2_o21ai_1
X_3083_ FrameData[15] FrameStrobe[3] Inst_RegFile_ConfigMem.Inst_frame3_bit15.Q VPWR
+ VGND sg13g2_dlhq_1
X_2034_ _0648_ _1147_ _0647_ VPWR VGND sg13g2_nand2b_1
X_1818_ Inst_RegFile_ConfigMem.Inst_frame1_bit24.Q WW4END[1] AD0 AD1 AD2 Inst_RegFile_ConfigMem.Inst_frame1_bit25.Q
+ _0446_ VPWR VGND sg13g2_mux4_1
X_2798_ FrameData[18] FrameStrobe[12] Inst_RegFile_ConfigMem.Inst_frame12_bit18.Q
+ VPWR VGND sg13g2_dlhq_1
XFILLER_7_90 VPWR VGND sg13g2_fill_2
X_2936_ FrameData[28] FrameStrobe[8] Inst_RegFile_ConfigMem.Inst_frame8_bit28.Q VPWR
+ VGND sg13g2_dlhq_1
X_2867_ FrameData[23] FrameStrobe[10] Inst_RegFile_ConfigMem.Inst_frame10_bit23.Q
+ VPWR VGND sg13g2_dlhq_1
X_1749_ Inst_RegFile_ConfigMem.Inst_frame2_bit27.Q VPWR _0380_ VGND _0376_ _0379_
+ sg13g2_o21ai_1
X_3419_ E6END[9] net30 VPWR VGND sg13g2_buf_1
XFILLER_9_107 VPWR VGND sg13g2_fill_1
XFILLER_42_98 VPWR VGND sg13g2_fill_2
X_2721_ _1348_ VGND VPWR _0015_ Inst_RegFile_32x4.mem\[27\]\[3\] clknet_5_6__leaf_UserCLK_regs
+ sg13g2_dfrbpq_1
X_2652_ _1067_ Inst_RegFile_32x4.mem\[31\]\[1\] _1120_ _0085_ VPWR VGND sg13g2_mux2_1
X_1603_ A_ADR0 Inst_RegFile_32x4.mem\[4\]\[0\] _0243_ VPWR VGND sg13g2_nor2b_1
X_1534_ _0177_ _0176_ Inst_RegFile_ConfigMem.Inst_frame1_bit22.Q VPWR VGND sg13g2_nand2b_1
X_1465_ _1220_ Inst_RegFile_ConfigMem.Inst_frame2_bit21.Q _1142_ _1221_ VPWR VGND
+ sg13g2_a21o_1
X_2583_ Inst_RegFile_32x4.mem\[13\]\[0\] _1065_ _1104_ _0032_ VPWR VGND sg13g2_mux2_1
X_3204_ _1279_ VGND VPWR _0076_ Inst_RegFile_32x4.mem\[19\]\[0\] clknet_5_2__leaf_UserCLK_regs
+ sg13g2_dfrbpq_1
X_3066_ FrameData[30] FrameStrobe[4] Inst_RegFile_ConfigMem.Inst_frame4_bit30.Q VPWR
+ VGND sg13g2_dlhq_1
X_1396_ VPWR _1154_ Inst_RegFile_ConfigMem.Inst_frame10_bit18.Q VGND sg13g2_inv_1
X_3135_ FrameData[3] FrameStrobe[1] Inst_RegFile_ConfigMem.Inst_frame1_bit3.Q VPWR
+ VGND sg13g2_dlhq_1
X_2017_ Inst_RegFile_ConfigMem.Inst_frame4_bit12.Q N2END[4] N4END[0] E1END[2] E2END[4]
+ Inst_RegFile_ConfigMem.Inst_frame4_bit13.Q _0633_ VPWR VGND sg13g2_mux4_1
X_2919_ FrameData[11] FrameStrobe[8] Inst_RegFile_ConfigMem.Inst_frame8_bit11.Q VPWR
+ VGND sg13g2_dlhq_1
XFILLER_1_382 VPWR VGND sg13g2_fill_1
XFILLER_32_297 VPWR VGND sg13g2_fill_1
X_2704_ _1069_ Inst_RegFile_32x4.mem\[12\]\[2\] _1131_ _0126_ VPWR VGND sg13g2_mux2_1
Xoutput234 net234 W6BEG[6] VPWR VGND sg13g2_buf_1
Xoutput223 net223 W2BEGb[5] VPWR VGND sg13g2_buf_1
Xoutput212 net212 W2BEG[2] VPWR VGND sg13g2_buf_1
X_2635_ _1117_ _1088_ _1108_ VPWR VGND sg13g2_nand2_1
Xoutput201 net201 SS4BEG[6] VPWR VGND sg13g2_buf_1
X_1448_ VGND VPWR E2END[2] Inst_RegFile_ConfigMem.Inst_frame0_bit18.Q _1204_ _1203_
+ sg13g2_a21oi_1
X_2566_ Inst_RegFile_32x4.mem\[2\]\[1\] _1067_ _1098_ _0021_ VPWR VGND sg13g2_mux2_1
Xoutput245 net245 WW4BEG[1] VPWR VGND sg13g2_buf_1
X_2497_ Inst_RegFile_ConfigMem.Inst_frame8_bit7.Q _0432_ _1051_ VPWR VGND sg13g2_nor2_1
X_1517_ _0160_ VPWR Inst_RegFile_switch_matrix.JW2BEG3 VGND _0149_ _0156_ sg13g2_o21ai_1
X_3118_ FrameData[18] FrameStrobe[2] Inst_RegFile_ConfigMem.Inst_frame2_bit18.Q VPWR
+ VGND sg13g2_dlhq_1
X_3049_ FrameData[13] FrameStrobe[4] Inst_RegFile_ConfigMem.Inst_frame4_bit13.Q VPWR
+ VGND sg13g2_dlhq_1
X_1379_ VPWR _1137_ Inst_RegFile_ConfigMem.Inst_frame7_bit30.Q VGND sg13g2_inv_1
XFILLER_15_209 VPWR VGND sg13g2_fill_2
XFILLER_7_419 VPWR VGND sg13g2_fill_1
XFILLER_11_448 VPWR VGND sg13g2_fill_1
X_2420_ VGND VPWR Inst_RegFile_ConfigMem.Inst_frame12_bit26.Q _1182_ _1001_ _1000_
+ sg13g2_a21oi_1
X_2351_ Inst_RegFile_ConfigMem.Inst_frame10_bit20.Q VPWR _0942_ VGND Inst_RegFile_ConfigMem.Inst_frame10_bit19.Q
+ _0941_ sg13g2_o21ai_1
X_2282_ VGND VPWR Inst_RegFile_ConfigMem.Inst_frame4_bit1.Q _0878_ _0881_ Inst_RegFile_ConfigMem.Inst_frame4_bit2.Q
+ sg13g2_a21oi_1
XFILLER_52_315 VPWR VGND sg13g2_fill_2
XFILLER_37_356 VPWR VGND sg13g2_fill_2
X_1997_ VGND VPWR Inst_RegFile_ConfigMem.Inst_frame6_bit25.Q _0612_ _0614_ _0613_
+ sg13g2_a21oi_1
X_3598_ Inst_RegFile_switch_matrix.W1BEG1 net207 VPWR VGND sg13g2_buf_1
X_2618_ _1069_ Inst_RegFile_32x4.mem\[16\]\[2\] _1113_ _0058_ VPWR VGND sg13g2_mux2_1
X_2549_ _1087_ Inst_RegFile_32x4.mem\[26\]\[3\] _1091_ _0011_ VPWR VGND sg13g2_mux2_1
XFILLER_11_223 VPWR VGND sg13g2_fill_2
X_1851_ Inst_RegFile_ConfigMem.Inst_frame4_bit24.Q E2END[7] _0478_ VPWR VGND sg13g2_nor2b_1
X_1920_ VGND VPWR _0409_ _0541_ _0542_ _0460_ sg13g2_a21oi_1
X_3452_ FrameData[12] net52 VPWR VGND sg13g2_buf_1
X_1782_ VGND VPWR Inst_RegFile_32x4.mem\[9\]\[0\] B_ADR0 _0411_ _0410_ sg13g2_a21oi_1
X_3383_ VPWR VGND _1365_ sg13g2_tiehi
X_2403_ Inst_RegFile_ConfigMem.Inst_frame11_bit14.Q N1END[0] E1END[0] S1END[0] AD3
+ Inst_RegFile_ConfigMem.Inst_frame11_bit15.Q _0988_ VPWR VGND sg13g2_mux4_1
X_3521_ N4END[13] net136 VPWR VGND sg13g2_buf_1
X_2265_ _0864_ VPWR _0865_ VGND Inst_RegFile_ConfigMem.Inst_frame4_bit28.Q _1164_
+ sg13g2_o21ai_1
X_2196_ _0800_ VPWR _0801_ VGND Inst_RegFile_ConfigMem.Inst_frame1_bit2.Q _0797_ sg13g2_o21ai_1
X_2334_ Inst_RegFile_ConfigMem.Inst_frame9_bit6.Q N1END[0] S1END[0] W1END[0] AD3 Inst_RegFile_ConfigMem.Inst_frame9_bit7.Q
+ _0929_ VPWR VGND sg13g2_mux4_1
XANTENNA_8 VPWR VGND EE4END[8] sg13g2_antennanp
XFILLER_6_26 VPWR VGND sg13g2_fill_2
X_2050_ Inst_RegFile_ConfigMem.Inst_frame2_bit9.Q VPWR _0663_ VGND Inst_RegFile_ConfigMem.Inst_frame2_bit8.Q
+ BD2 sg13g2_o21ai_1
Xclkbuf_4_2_0_UserCLK_regs clknet_0_UserCLK_regs clknet_4_2_0_UserCLK_regs VPWR VGND
+ sg13g2_buf_8
X_2952_ FrameData[12] FrameStrobe[7] Inst_RegFile_ConfigMem.Inst_frame7_bit12.Q VPWR
+ VGND sg13g2_dlhq_1
X_1765_ _0393_ _0394_ _0395_ VPWR VGND sg13g2_nor2b_1
X_1834_ B_ADR0 Inst_RegFile_32x4.mem\[12\]\[0\] Inst_RegFile_32x4.mem\[13\]\[0\] Inst_RegFile_32x4.mem\[14\]\[0\]
+ Inst_RegFile_32x4.mem\[15\]\[0\] _0368_ _0461_ VPWR VGND sg13g2_mux4_1
X_1903_ B_ADR0 Inst_RegFile_32x4.mem\[0\]\[1\] Inst_RegFile_32x4.mem\[1\]\[1\] Inst_RegFile_32x4.mem\[2\]\[1\]
+ Inst_RegFile_32x4.mem\[3\]\[1\] _0368_ _0527_ VPWR VGND sg13g2_mux4_1
XFILLER_30_362 VPWR VGND sg13g2_fill_2
X_2883_ FrameData[7] FrameStrobe[9] Inst_RegFile_ConfigMem.Inst_frame9_bit7.Q VPWR
+ VGND sg13g2_dlhq_1
X_3435_ EE4END[15] net35 VPWR VGND sg13g2_buf_1
X_3504_ N2MID[0] net113 VPWR VGND sg13g2_buf_1
X_1696_ A_ADR0 Inst_RegFile_32x4.mem\[20\]\[3\] _0330_ VPWR VGND sg13g2_nor2b_1
X_3366_ VPWR VGND _1348_ sg13g2_tiehi
X_2317_ VGND VPWR Inst_RegFile_ConfigMem.Inst_frame9_bit12.Q _0338_ _0914_ _0913_
+ sg13g2_a21oi_1
X_3297_ VPWR VGND _1279_ sg13g2_tiehi
X_2179_ _0784_ _0783_ Inst_RegFile_ConfigMem.Inst_frame1_bit30.Q _0785_ VPWR VGND
+ sg13g2_mux2_1
X_2248_ Inst_RegFile_ConfigMem.Inst_frame3_bit1.Q W6END[1] AD2 AD1 AD3 Inst_RegFile_ConfigMem.Inst_frame3_bit0.Q
+ _0849_ VPWR VGND sg13g2_mux4_1
Xoutput34 net34 EE4BEG[10] VPWR VGND sg13g2_buf_1
Xoutput23 net23 E6BEG[11] VPWR VGND sg13g2_buf_1
XFILLER_31_56 VPWR VGND sg13g2_fill_2
Xoutput12 net12 E2BEG[7] VPWR VGND sg13g2_buf_1
Xoutput89 net89 FrameStrobe_O[17] VPWR VGND sg13g2_buf_1
Xoutput56 net56 FrameData_O[16] VPWR VGND sg13g2_buf_1
Xoutput67 net67 FrameData_O[26] VPWR VGND sg13g2_buf_1
Xoutput45 net45 EE4BEG[6] VPWR VGND sg13g2_buf_1
Xoutput78 net78 FrameData_O[7] VPWR VGND sg13g2_buf_1
X_3220_ _1263_ VGND VPWR _0092_ Inst_RegFile_32x4.mem\[4\]\[0\] clknet_5_29__leaf_UserCLK_regs
+ sg13g2_dfrbpq_1
X_1550_ _0192_ _0191_ _0144_ VPWR VGND sg13g2_nand2b_1
X_1481_ BD1 Inst_RegFile_ConfigMem.Inst_frame2_bit12.Q _1236_ VPWR VGND sg13g2_nor2b_1
X_2033_ Inst_RegFile_ConfigMem.Inst_frame1_bit8.Q W6END[1] AD0 AD1 AD3 Inst_RegFile_ConfigMem.Inst_frame1_bit9.Q
+ _0647_ VPWR VGND sg13g2_mux4_1
X_3151_ FrameData[19] FrameStrobe[1] Inst_RegFile_ConfigMem.Inst_frame1_bit19.Q VPWR
+ VGND sg13g2_dlhq_1
X_2102_ VGND VPWR Inst_RegFile_ConfigMem.Inst_frame1_bit5.Q _0709_ _0712_ Inst_RegFile_ConfigMem.Inst_frame1_bit6.Q
+ sg13g2_a21oi_1
X_3082_ FrameData[14] FrameStrobe[3] Inst_RegFile_ConfigMem.Inst_frame3_bit14.Q VPWR
+ VGND sg13g2_dlhq_1
X_2935_ FrameData[27] FrameStrobe[8] Inst_RegFile_ConfigMem.Inst_frame8_bit27.Q VPWR
+ VGND sg13g2_dlhq_1
X_1817_ _0441_ _0444_ Inst_RegFile_ConfigMem.Inst_frame1_bit26.Q _0445_ VPWR VGND
+ sg13g2_nand3_1
X_1748_ _0378_ Inst_RegFile_ConfigMem.Inst_frame2_bit25.Q _1136_ _0379_ VPWR VGND
+ sg13g2_a21o_1
X_2797_ FrameData[17] FrameStrobe[12] Inst_RegFile_ConfigMem.Inst_frame12_bit17.Q
+ VPWR VGND sg13g2_dlhq_1
X_2866_ FrameData[22] FrameStrobe[10] Inst_RegFile_ConfigMem.Inst_frame10_bit22.Q
+ VPWR VGND sg13g2_dlhq_1
X_3349_ VPWR VGND _1331_ sg13g2_tiehi
X_1679_ A_ADR0 Inst_RegFile_32x4.mem\[10\]\[3\] Inst_RegFile_32x4.mem\[11\]\[3\] Inst_RegFile_32x4.mem\[8\]\[3\]
+ Inst_RegFile_32x4.mem\[9\]\[3\] _1210_ _0313_ VPWR VGND sg13g2_mux4_1
X_3418_ E6END[8] net29 VPWR VGND sg13g2_buf_1
XFILLER_26_421 VPWR VGND sg13g2_fill_2
X_1602_ Inst_RegFile_32x4.mem\[6\]\[0\] Inst_RegFile_32x4.mem\[7\]\[0\] A_ADR0 _0242_
+ VPWR VGND sg13g2_mux2_1
X_2582_ _1088_ _1103_ _1104_ VPWR VGND sg13g2_and2_1
XFILLER_8_141 VPWR VGND sg13g2_fill_2
X_2651_ _1065_ Inst_RegFile_32x4.mem\[31\]\[0\] _1120_ _0084_ VPWR VGND sg13g2_mux2_1
X_2720_ _1349_ VGND VPWR _0014_ Inst_RegFile_32x4.mem\[27\]\[2\] clknet_5_7__leaf_UserCLK_regs
+ sg13g2_dfrbpq_1
X_1464_ BD2 BD3 Inst_RegFile_ConfigMem.Inst_frame2_bit20.Q _1220_ VPWR VGND sg13g2_mux2_1
X_1533_ Inst_RegFile_ConfigMem.Inst_frame1_bit20.Q N1END[2] N2END[6] E1END[2] E2END[6]
+ Inst_RegFile_ConfigMem.Inst_frame1_bit21.Q _0176_ VPWR VGND sg13g2_mux4_1
X_1395_ VPWR _1153_ Inst_RegFile_ConfigMem.Inst_frame9_bit6.Q VGND sg13g2_inv_1
X_3203_ _1280_ VGND VPWR Inst_RegFile_32x4.AD_comb\[3\] Inst_RegFile_32x4.AD_reg\[3\]
+ clknet_5_7__leaf_UserCLK_regs sg13g2_dfrbpq_1
X_3065_ FrameData[29] FrameStrobe[4] Inst_RegFile_ConfigMem.Inst_frame4_bit29.Q VPWR
+ VGND sg13g2_dlhq_1
X_2016_ VGND VPWR Inst_RegFile_ConfigMem.Inst_frame4_bit13.Q _0630_ _0632_ _0631_
+ sg13g2_a21oi_1
X_3134_ FrameData[2] FrameStrobe[1] Inst_RegFile_ConfigMem.Inst_frame1_bit2.Q VPWR
+ VGND sg13g2_dlhq_1
X_2918_ FrameData[10] FrameStrobe[8] Inst_RegFile_ConfigMem.Inst_frame8_bit10.Q VPWR
+ VGND sg13g2_dlhq_1
X_2849_ FrameData[5] FrameStrobe[10] Inst_RegFile_ConfigMem.Inst_frame10_bit5.Q VPWR
+ VGND sg13g2_dlhq_1
XFILLER_32_232 VPWR VGND sg13g2_fill_1
X_2565_ Inst_RegFile_32x4.mem\[2\]\[0\] _1065_ _1098_ _0020_ VPWR VGND sg13g2_mux2_1
X_2703_ _1067_ Inst_RegFile_32x4.mem\[12\]\[1\] _1131_ _0125_ VPWR VGND sg13g2_mux2_1
Xoutput224 net224 W2BEGb[6] VPWR VGND sg13g2_buf_1
Xoutput235 net235 W6BEG[7] VPWR VGND sg13g2_buf_1
X_2634_ _1087_ Inst_RegFile_32x4.mem\[20\]\[3\] _1116_ _0071_ VPWR VGND sg13g2_mux2_1
Xoutput246 net246 WW4BEG[2] VPWR VGND sg13g2_buf_1
Xoutput213 net213 W2BEG[3] VPWR VGND sg13g2_buf_1
Xoutput202 net202 SS4BEG[7] VPWR VGND sg13g2_buf_1
X_1516_ _0160_ _0159_ Inst_RegFile_ConfigMem.Inst_frame1_bit15.Q VPWR VGND sg13g2_nand2b_1
X_1378_ VPWR _1136_ Inst_RegFile_ConfigMem.Inst_frame2_bit26.Q VGND sg13g2_inv_1
X_3117_ FrameData[17] FrameStrobe[2] Inst_RegFile_ConfigMem.Inst_frame2_bit17.Q VPWR
+ VGND sg13g2_dlhq_1
X_1447_ Inst_RegFile_ConfigMem.Inst_frame0_bit18.Q NN4END[2] _1203_ VPWR VGND sg13g2_nor2b_1
X_2496_ VGND VPWR _1163_ Inst_RegFile_switch_matrix.JS2BEG0 _1050_ _1049_ sg13g2_a21oi_1
X_3048_ FrameData[12] FrameStrobe[4] Inst_RegFile_ConfigMem.Inst_frame4_bit12.Q VPWR
+ VGND sg13g2_dlhq_1
XFILLER_2_169 VPWR VGND sg13g2_fill_1
XFILLER_9_26 VPWR VGND sg13g2_fill_2
XFILLER_37_324 VPWR VGND sg13g2_fill_1
X_2350_ VGND VPWR Inst_RegFile_ConfigMem.Inst_frame10_bit18.Q _1182_ _0941_ _0940_
+ sg13g2_a21oi_1
X_2281_ VGND VPWR Inst_RegFile_ConfigMem.Inst_frame4_bit0.Q AD1 _0880_ _0879_ sg13g2_a21oi_1
X_1996_ Inst_RegFile_ConfigMem.Inst_frame8_bit21.Q VPWR _0613_ VGND Inst_RegFile_ConfigMem.Inst_frame6_bit25.Q
+ _0611_ sg13g2_o21ai_1
X_3597_ Inst_RegFile_switch_matrix.W1BEG0 net206 VPWR VGND sg13g2_buf_1
X_2617_ _1067_ Inst_RegFile_32x4.mem\[16\]\[1\] _1113_ _0057_ VPWR VGND sg13g2_mux2_1
X_2548_ _1069_ Inst_RegFile_32x4.mem\[26\]\[2\] _1091_ _0010_ VPWR VGND sg13g2_mux2_1
X_2479_ Inst_RegFile_ConfigMem.Inst_frame8_bit1.Q _0895_ _0922_ _1031_ _1032_ Inst_RegFile_ConfigMem.Inst_frame8_bit0.Q
+ _1033_ VPWR VGND sg13g2_mux4_1
XFILLER_34_56 VPWR VGND sg13g2_fill_1
Xclkload0 VPWR clkload0/Y clknet_5_1__leaf_UserCLK_regs VGND sg13g2_inv_1
Xclkbuf_4_10_0_UserCLK_regs clknet_0_UserCLK_regs clknet_4_10_0_UserCLK_regs VPWR
+ VGND sg13g2_buf_8
XFILLER_46_154 VPWR VGND sg13g2_fill_1
X_1850_ S2END[7] W1END[1] Inst_RegFile_ConfigMem.Inst_frame4_bit24.Q _0477_ VPWR VGND
+ sg13g2_mux2_1
X_1781_ B_ADR0 Inst_RegFile_32x4.mem\[8\]\[0\] _0410_ VPWR VGND sg13g2_nor2b_1
X_3520_ N4END[12] net135 VPWR VGND sg13g2_buf_1
X_3451_ FrameData[11] net51 VPWR VGND sg13g2_buf_1
X_2402_ _0983_ _0986_ _0987_ VPWR VGND sg13g2_nor2_1
X_3382_ VPWR VGND _1364_ sg13g2_tiehi
X_2333_ _0924_ _0927_ _0928_ VPWR VGND sg13g2_nor2_1
X_2264_ _0864_ Inst_RegFile_ConfigMem.Inst_frame4_bit28.Q BD2 VPWR VGND sg13g2_nand2_1
X_2195_ VGND VPWR Inst_RegFile_ConfigMem.Inst_frame1_bit2.Q _0799_ _0800_ Inst_RegFile_ConfigMem.Inst_frame1_bit3.Q
+ sg13g2_a21oi_1
XFILLER_25_327 VPWR VGND sg13g2_fill_1
X_1979_ VGND VPWR Inst_RegFile_ConfigMem.Inst_frame4_bit18.Q _0594_ _0597_ _0596_
+ sg13g2_a21oi_1
XFILLER_29_56 VPWR VGND sg13g2_fill_1
XFILLER_45_66 VPWR VGND sg13g2_fill_1
XFILLER_28_154 VPWR VGND sg13g2_decap_8
XFILLER_24_371 VPWR VGND sg13g2_fill_2
XANTENNA_9 VPWR VGND EE4END[9] sg13g2_antennanp
XFILLER_3_286 VPWR VGND sg13g2_fill_2
XFILLER_6_38 VPWR VGND sg13g2_fill_2
XFILLER_19_143 VPWR VGND sg13g2_fill_2
XFILLER_34_157 VPWR VGND sg13g2_fill_2
X_1902_ VGND VPWR _0409_ _0525_ _0526_ _0459_ sg13g2_a21oi_1
X_2951_ FrameData[11] FrameStrobe[7] Inst_RegFile_ConfigMem.Inst_frame7_bit11.Q VPWR
+ VGND sg13g2_dlhq_1
X_3503_ Inst_RegFile_switch_matrix.JN2BEG7 net112 VPWR VGND sg13g2_buf_1
X_1764_ VGND VPWR Inst_RegFile_ConfigMem.Inst_frame2_bit17.Q _0390_ _0394_ Inst_RegFile_ConfigMem.Inst_frame2_bit18.Q
+ sg13g2_a21oi_1
X_1833_ _0460_ _0434_ _0458_ VPWR VGND sg13g2_nand2_1
X_2882_ FrameData[6] FrameStrobe[9] Inst_RegFile_ConfigMem.Inst_frame9_bit6.Q VPWR
+ VGND sg13g2_dlhq_1
X_2316_ Inst_RegFile_ConfigMem.Inst_frame9_bit13.Q VPWR _0913_ VGND Inst_RegFile_ConfigMem.Inst_frame9_bit12.Q
+ _1183_ sg13g2_o21ai_1
X_3434_ EE4END[14] net34 VPWR VGND sg13g2_buf_1
X_1695_ A_ADR0 Inst_RegFile_32x4.mem\[18\]\[3\] Inst_RegFile_32x4.mem\[19\]\[3\] Inst_RegFile_32x4.mem\[16\]\[3\]
+ Inst_RegFile_32x4.mem\[17\]\[3\] _1210_ _0329_ VPWR VGND sg13g2_mux4_1
X_3296_ VPWR VGND _1278_ sg13g2_tiehi
X_3365_ VPWR VGND _1347_ sg13g2_tiehi
X_2247_ _0848_ VPWR Inst_RegFile_switch_matrix.E2BEG7 VGND _0842_ _0843_ sg13g2_o21ai_1
X_2178_ Inst_RegFile_ConfigMem.Inst_frame1_bit29.Q N1END[0] E1END[0] N2END[0] E2END[0]
+ Inst_RegFile_ConfigMem.Inst_frame1_bit28.Q _0784_ VPWR VGND sg13g2_mux4_1
XFILLER_15_69 VPWR VGND sg13g2_fill_1
Xoutput57 net57 FrameData_O[17] VPWR VGND sg13g2_buf_1
Xoutput35 net35 EE4BEG[11] VPWR VGND sg13g2_buf_1
XFILLER_31_79 VPWR VGND sg13g2_fill_2
Xoutput46 net46 EE4BEG[7] VPWR VGND sg13g2_buf_1
Xoutput13 net13 E2BEGb[0] VPWR VGND sg13g2_buf_1
Xoutput24 net24 E6BEG[1] VPWR VGND sg13g2_buf_1
Xoutput68 net68 FrameData_O[27] VPWR VGND sg13g2_buf_1
Xoutput79 net79 FrameData_O[8] VPWR VGND sg13g2_buf_1
X_3150_ FrameData[18] FrameStrobe[1] Inst_RegFile_ConfigMem.Inst_frame1_bit18.Q VPWR
+ VGND sg13g2_dlhq_1
X_1480_ Inst_RegFile_ConfigMem.Inst_frame2_bit12.Q BD0 _1235_ VPWR VGND sg13g2_nor2_1
X_2032_ A_ADR0 _0644_ _0646_ _0642_ Inst_RegFile_ConfigMem.Inst_frame8_bit11.Q VPWR
+ VGND sg13g2_a22oi_1
X_2101_ VGND VPWR Inst_RegFile_ConfigMem.Inst_frame1_bit4.Q AD0 _0711_ _0710_ sg13g2_a21oi_1
X_3081_ FrameData[13] FrameStrobe[3] Inst_RegFile_ConfigMem.Inst_frame3_bit13.Q VPWR
+ VGND sg13g2_dlhq_1
X_2865_ FrameData[21] FrameStrobe[10] Inst_RegFile_ConfigMem.Inst_frame10_bit21.Q
+ VPWR VGND sg13g2_dlhq_1
X_2934_ FrameData[26] FrameStrobe[8] Inst_RegFile_ConfigMem.Inst_frame8_bit26.Q VPWR
+ VGND sg13g2_dlhq_1
X_1747_ _0377_ VPWR _0378_ VGND Inst_RegFile_ConfigMem.Inst_frame2_bit24.Q _1164_
+ sg13g2_o21ai_1
X_1816_ Inst_RegFile_ConfigMem.Inst_frame1_bit25.Q VPWR _0444_ VGND _0442_ _0443_
+ sg13g2_o21ai_1
X_2796_ FrameData[16] FrameStrobe[12] Inst_RegFile_ConfigMem.Inst_frame12_bit16.Q
+ VPWR VGND sg13g2_dlhq_1
X_1678_ Inst_RegFile_32x4.AD_comb\[2\] Inst_RegFile_32x4.AD_reg\[2\] Inst_RegFile_ConfigMem.Inst_frame12_bit2.Q
+ AD2 VPWR VGND sg13g2_mux2_1
XFILLER_7_92 VPWR VGND sg13g2_fill_1
X_3348_ VPWR VGND _1330_ sg13g2_tiehi
X_3279_ VPWR VGND _1261_ sg13g2_tiehi
X_3417_ E6END[7] net28 VPWR VGND sg13g2_buf_1
XFILLER_5_315 VPWR VGND sg13g2_fill_1
XFILLER_3_17 VPWR VGND sg13g2_fill_1
X_1532_ Inst_RegFile_ConfigMem.Inst_frame1_bit23.Q _0169_ _0175_ VPWR VGND sg13g2_and2_1
X_1601_ VPWR VGND _0240_ _0142_ _0239_ _1210_ _0241_ _0238_ sg13g2_a221oi_1
X_2581_ _1100_ _1033_ _1103_ VPWR VGND sg13g2_nor2b_1
XFILLER_8_197 VPWR VGND sg13g2_fill_1
X_2650_ _1120_ _1092_ _1094_ VPWR VGND sg13g2_nand2_1
X_1463_ Inst_RegFile_ConfigMem.Inst_frame2_bit21.Q _1217_ _1218_ _1219_ VPWR VGND
+ sg13g2_nor3_1
X_1394_ VPWR _1152_ Inst_RegFile_ConfigMem.Inst_frame9_bit15.Q VGND sg13g2_inv_1
X_3202_ _1363_ VGND VPWR Inst_RegFile_32x4.AD_comb\[2\] Inst_RegFile_32x4.AD_reg\[2\]
+ clknet_5_16__leaf_UserCLK_regs sg13g2_dfrbpq_1
X_3133_ FrameData[1] FrameStrobe[1] Inst_RegFile_ConfigMem.Inst_frame1_bit1.Q VPWR
+ VGND sg13g2_dlhq_1
X_3064_ FrameData[28] FrameStrobe[4] Inst_RegFile_ConfigMem.Inst_frame4_bit28.Q VPWR
+ VGND sg13g2_dlhq_1
X_2015_ Inst_RegFile_ConfigMem.Inst_frame4_bit14.Q VPWR _0631_ VGND Inst_RegFile_ConfigMem.Inst_frame4_bit13.Q
+ _0629_ sg13g2_o21ai_1
X_2848_ FrameData[4] FrameStrobe[10] Inst_RegFile_ConfigMem.Inst_frame10_bit4.Q VPWR
+ VGND sg13g2_dlhq_1
XFILLER_12_48 VPWR VGND sg13g2_fill_2
X_2917_ FrameData[9] FrameStrobe[8] Inst_RegFile_ConfigMem.Inst_frame8_bit9.Q VPWR
+ VGND sg13g2_dlhq_1
X_2779_ _1282_ VGND VPWR _0073_ Inst_RegFile_32x4.mem\[21\]\[1\] clknet_5_10__leaf_UserCLK_regs
+ sg13g2_dfrbpq_1
XFILLER_53_88 VPWR VGND sg13g2_fill_1
XFILLER_41_266 VPWR VGND sg13g2_fill_2
X_2702_ _1065_ Inst_RegFile_32x4.mem\[12\]\[0\] _1131_ _0124_ VPWR VGND sg13g2_mux2_1
X_2564_ _1090_ _1097_ _1098_ VPWR VGND sg13g2_and2_1
X_2633_ _1069_ Inst_RegFile_32x4.mem\[20\]\[2\] _1116_ _0070_ VPWR VGND sg13g2_mux2_1
Xoutput214 net214 W2BEG[4] VPWR VGND sg13g2_buf_1
Xoutput236 net236 W6BEG[8] VPWR VGND sg13g2_buf_1
Xoutput203 net203 SS4BEG[8] VPWR VGND sg13g2_buf_1
Xoutput225 net225 W2BEGb[7] VPWR VGND sg13g2_buf_1
Xoutput247 net247 WW4BEG[3] VPWR VGND sg13g2_buf_1
X_2495_ Inst_RegFile_ConfigMem.Inst_frame8_bit7.Q Inst_RegFile_switch_matrix.JW2BEG0
+ _1049_ VPWR VGND sg13g2_and2_1
X_1515_ _0157_ _0158_ Inst_RegFile_ConfigMem.Inst_frame1_bit14.Q _0159_ VPWR VGND
+ sg13g2_mux2_1
X_3116_ FrameData[16] FrameStrobe[2] Inst_RegFile_ConfigMem.Inst_frame2_bit16.Q VPWR
+ VGND sg13g2_dlhq_1
X_1377_ VPWR _1135_ Inst_RegFile_ConfigMem.Inst_frame3_bit19.Q VGND sg13g2_inv_1
X_1446_ S4END[2] Inst_RegFile_switch_matrix.E2BEG3 Inst_RegFile_ConfigMem.Inst_frame0_bit18.Q
+ _1202_ VPWR VGND sg13g2_mux2_1
X_3047_ FrameData[11] FrameStrobe[4] Inst_RegFile_ConfigMem.Inst_frame4_bit11.Q VPWR
+ VGND sg13g2_dlhq_1
XFILLER_49_185 VPWR VGND sg13g2_fill_2
XFILLER_1_170 VPWR VGND sg13g2_fill_2
X_2280_ Inst_RegFile_ConfigMem.Inst_frame4_bit0.Q W6END[1] _0879_ VPWR VGND sg13g2_nor2b_1
X_1995_ S2MID[7] W2MID[7] Inst_RegFile_ConfigMem.Inst_frame6_bit24.Q _0612_ VPWR VGND
+ sg13g2_mux2_1
X_2616_ _1065_ Inst_RegFile_32x4.mem\[16\]\[0\] _1113_ _0056_ VPWR VGND sg13g2_mux2_1
X_3596_ clknet_1_0__leaf_UserCLK net205 VPWR VGND sg13g2_buf_1
X_2478_ Inst_RegFile_ConfigMem.Inst_frame0_bit12.Q NN4END[1] EE4END[1] S4END[1] Inst_RegFile_switch_matrix.JS2BEG2
+ Inst_RegFile_ConfigMem.Inst_frame0_bit13.Q _1032_ VPWR VGND sg13g2_mux4_1
X_2547_ _1067_ Inst_RegFile_32x4.mem\[26\]\[1\] _1091_ _0009_ VPWR VGND sg13g2_mux2_1
X_1429_ _1185_ VPWR _1186_ VGND Inst_RegFile_ConfigMem.Inst_frame3_bit12.Q _1167_
+ sg13g2_o21ai_1
XFILLER_11_225 VPWR VGND sg13g2_fill_1
XFILLER_11_247 VPWR VGND sg13g2_fill_2
Xclkload1 VPWR clkload1/Y clknet_5_5__leaf_UserCLK_regs VGND sg13g2_inv_1
XFILLER_50_45 VPWR VGND sg13g2_fill_1
X_1780_ Inst_RegFile_ConfigMem.Inst_frame8_bit26.Q _0388_ _0408_ _0229_ _0407_ Inst_RegFile_ConfigMem.Inst_frame8_bit25.Q
+ _0409_ VPWR VGND sg13g2_mux4_1
X_3450_ FrameData[10] net50 VPWR VGND sg13g2_buf_1
X_2401_ Inst_RegFile_ConfigMem.Inst_frame11_bit16.Q VPWR _0986_ VGND Inst_RegFile_ConfigMem.Inst_frame11_bit15.Q
+ _0985_ sg13g2_o21ai_1
X_3381_ VPWR VGND _1363_ sg13g2_tiehi
X_2332_ Inst_RegFile_ConfigMem.Inst_frame9_bit8.Q VPWR _0927_ VGND Inst_RegFile_ConfigMem.Inst_frame9_bit7.Q
+ _0926_ sg13g2_o21ai_1
X_2194_ VPWR _0799_ _0798_ VGND sg13g2_inv_1
X_2263_ _0856_ VPWR Inst_RegFile_switch_matrix.E2BEG0 VGND Inst_RegFile_ConfigMem.Inst_frame3_bit3.Q
+ _0863_ sg13g2_o21ai_1
X_1978_ Inst_RegFile_ConfigMem.Inst_frame4_bit18.Q _0595_ _0596_ VPWR VGND sg13g2_nor2b_1
X_3579_ Inst_RegFile_switch_matrix.S4BEG3 net179 VPWR VGND sg13g2_buf_1
XFILLER_28_188 VPWR VGND sg13g2_fill_1
XFILLER_51_191 VPWR VGND sg13g2_fill_2
XFILLER_30_364 VPWR VGND sg13g2_fill_1
X_1901_ B_ADR0 Inst_RegFile_32x4.mem\[12\]\[1\] Inst_RegFile_32x4.mem\[13\]\[1\] Inst_RegFile_32x4.mem\[14\]\[1\]
+ Inst_RegFile_32x4.mem\[15\]\[1\] _0368_ _0525_ VPWR VGND sg13g2_mux4_1
X_1832_ _0434_ _0458_ _0459_ VPWR VGND sg13g2_and2_1
X_2881_ FrameData[5] FrameStrobe[9] Inst_RegFile_ConfigMem.Inst_frame9_bit5.Q VPWR
+ VGND sg13g2_dlhq_1
X_2950_ FrameData[10] FrameStrobe[7] Inst_RegFile_ConfigMem.Inst_frame7_bit10.Q VPWR
+ VGND sg13g2_dlhq_1
X_3502_ Inst_RegFile_switch_matrix.JN2BEG6 net111 VPWR VGND sg13g2_buf_1
X_1763_ Inst_RegFile_ConfigMem.Inst_frame2_bit17.Q _0391_ _0392_ _0393_ VPWR VGND
+ sg13g2_nor3_1
X_3433_ EE4END[13] net48 VPWR VGND sg13g2_buf_1
X_1694_ VGND VPWR _0142_ _0327_ _0328_ _0186_ sg13g2_a21oi_1
XFILLER_38_420 VPWR VGND sg13g2_fill_2
X_2315_ _0911_ _0910_ Inst_RegFile_ConfigMem.Inst_frame9_bit12.Q _0912_ VPWR VGND
+ sg13g2_mux2_1
X_3364_ VPWR VGND _1346_ sg13g2_tiehi
X_2246_ _0847_ VPWR _0848_ VGND Inst_RegFile_ConfigMem.Inst_frame3_bit30.Q _0844_
+ sg13g2_o21ai_1
X_3295_ VPWR VGND _1277_ sg13g2_tiehi
XFILLER_38_453 VPWR VGND sg13g2_fill_2
X_2177_ Inst_RegFile_ConfigMem.Inst_frame1_bit29.Q S1END[0] S2END[0] S1END[2] W1END[0]
+ Inst_RegFile_ConfigMem.Inst_frame1_bit28.Q _0783_ VPWR VGND sg13g2_mux4_1
XFILLER_31_36 VPWR VGND sg13g2_fill_2
Xoutput58 net58 FrameData_O[18] VPWR VGND sg13g2_buf_1
Xoutput69 net69 FrameData_O[28] VPWR VGND sg13g2_buf_1
Xoutput36 net36 EE4BEG[12] VPWR VGND sg13g2_buf_1
Xoutput47 net47 EE4BEG[8] VPWR VGND sg13g2_buf_1
Xoutput25 net25 E6BEG[2] VPWR VGND sg13g2_buf_1
Xoutput14 net14 E2BEGb[1] VPWR VGND sg13g2_buf_1
XFILLER_0_279 VPWR VGND sg13g2_fill_1
X_3080_ FrameData[12] FrameStrobe[3] Inst_RegFile_ConfigMem.Inst_frame3_bit12.Q VPWR
+ VGND sg13g2_dlhq_1
X_2100_ Inst_RegFile_ConfigMem.Inst_frame1_bit4.Q W6END[0] _0710_ VPWR VGND sg13g2_nor2b_1
X_2031_ VGND VPWR Inst_RegFile_ConfigMem.Inst_frame8_bit10.Q _0645_ _0646_ Inst_RegFile_ConfigMem.Inst_frame8_bit11.Q
+ sg13g2_a21oi_1
Xclkbuf_5_7__f_UserCLK_regs clknet_4_3_0_UserCLK_regs clknet_5_7__leaf_UserCLK_regs
+ VPWR VGND sg13g2_buf_8
X_1815_ Inst_RegFile_ConfigMem.Inst_frame1_bit24.Q BD1 _0443_ VPWR VGND sg13g2_nor2_1
X_2795_ FrameData[15] FrameStrobe[12] Inst_RegFile_ConfigMem.Inst_frame12_bit15.Q
+ VPWR VGND sg13g2_dlhq_1
X_2864_ FrameData[20] FrameStrobe[10] Inst_RegFile_ConfigMem.Inst_frame10_bit20.Q
+ VPWR VGND sg13g2_dlhq_1
X_2933_ FrameData[25] FrameStrobe[8] Inst_RegFile_ConfigMem.Inst_frame8_bit25.Q VPWR
+ VGND sg13g2_dlhq_1
XFILLER_22_139 VPWR VGND sg13g2_fill_2
X_1746_ _0377_ Inst_RegFile_ConfigMem.Inst_frame2_bit24.Q BD3 VPWR VGND sg13g2_nand2_1
X_1677_ VGND VPWR Inst_RegFile_32x4.AD_comb\[2\] _0312_ _0299_ sg13g2_or2_1
X_3416_ E6END[6] net27 VPWR VGND sg13g2_buf_1
X_3278_ VPWR VGND _1260_ sg13g2_tiehi
X_3347_ VPWR VGND _1329_ sg13g2_tiehi
X_2229_ Inst_RegFile_ConfigMem.Inst_frame2_bit2.Q VPWR _0832_ VGND Inst_RegFile_ConfigMem.Inst_frame2_bit1.Q
+ _0831_ sg13g2_o21ai_1
XFILLER_53_275 VPWR VGND sg13g2_fill_1
XFILLER_41_404 VPWR VGND sg13g2_fill_2
X_1531_ _0171_ Inst_RegFile_ConfigMem.Inst_frame1_bit21.Q _0173_ _0174_ VPWR VGND
+ sg13g2_a21o_1
X_1462_ BD0 Inst_RegFile_ConfigMem.Inst_frame2_bit20.Q _1218_ VPWR VGND sg13g2_nor2b_1
X_2580_ _1087_ Inst_RegFile_32x4.mem\[9\]\[3\] _1102_ _0031_ VPWR VGND sg13g2_mux2_1
X_1600_ VGND VPWR Inst_RegFile_32x4.mem\[3\]\[0\] A_ADR0 _0240_ _1210_ sg13g2_a21oi_1
X_3063_ FrameData[27] FrameStrobe[4] Inst_RegFile_ConfigMem.Inst_frame4_bit27.Q VPWR
+ VGND sg13g2_dlhq_1
X_1393_ VPWR _1151_ Inst_RegFile_ConfigMem.Inst_frame9_bit14.Q VGND sg13g2_inv_1
X_3201_ _1321_ VGND VPWR Inst_RegFile_32x4.AD_comb\[1\] Inst_RegFile_32x4.AD_reg\[1\]
+ clknet_5_16__leaf_UserCLK_regs sg13g2_dfrbpq_1
X_3132_ FrameData[0] FrameStrobe[1] Inst_RegFile_ConfigMem.Inst_frame1_bit0.Q VPWR
+ VGND sg13g2_dlhq_1
X_2014_ W2END[4] WW4END[3] Inst_RegFile_ConfigMem.Inst_frame4_bit12.Q _0630_ VPWR
+ VGND sg13g2_mux2_1
XFILLER_31_470 VPWR VGND sg13g2_fill_1
X_2847_ FrameData[3] FrameStrobe[10] Inst_RegFile_ConfigMem.Inst_frame10_bit3.Q VPWR
+ VGND sg13g2_dlhq_1
X_2778_ _1283_ VGND VPWR _0072_ Inst_RegFile_32x4.mem\[21\]\[0\] clknet_5_10__leaf_UserCLK_regs
+ sg13g2_dfrbpq_1
X_2916_ FrameData[8] FrameStrobe[8] Inst_RegFile_ConfigMem.Inst_frame8_bit8.Q VPWR
+ VGND sg13g2_dlhq_1
X_1729_ VGND VPWR SS4END[2] Inst_RegFile_ConfigMem.Inst_frame0_bit26.Q _0360_ _0359_
+ sg13g2_a21oi_1
XFILLER_26_275 VPWR VGND sg13g2_fill_2
X_2701_ _1131_ _1061_ _1103_ VPWR VGND sg13g2_nand2_1
X_2632_ _1067_ Inst_RegFile_32x4.mem\[20\]\[1\] _1116_ _0069_ VPWR VGND sg13g2_mux2_1
X_2563_ _1026_ _1029_ _1033_ _1097_ VPWR VGND sg13g2_nor3_1
X_2494_ _1048_ _1041_ _1046_ VPWR VGND sg13g2_nand2_1
Xoutput226 net226 W6BEG[0] VPWR VGND sg13g2_buf_1
Xoutput248 net248 WW4BEG[4] VPWR VGND sg13g2_buf_1
Xoutput215 net215 W2BEG[5] VPWR VGND sg13g2_buf_1
Xoutput237 net237 W6BEG[9] VPWR VGND sg13g2_buf_1
Xoutput204 net204 SS4BEG[9] VPWR VGND sg13g2_buf_1
X_1514_ Inst_RegFile_ConfigMem.Inst_frame1_bit12.Q E6END[0] S2END[4] S4END[0] W2END[4]
+ Inst_RegFile_ConfigMem.Inst_frame1_bit13.Q _0158_ VPWR VGND sg13g2_mux4_1
X_1445_ _1201_ VPWR Inst_RegFile_switch_matrix.E2BEG3 VGND _1189_ _1196_ sg13g2_o21ai_1
X_3046_ FrameData[10] FrameStrobe[4] Inst_RegFile_ConfigMem.Inst_frame4_bit10.Q VPWR
+ VGND sg13g2_dlhq_1
X_1376_ VPWR _1134_ Inst_RegFile_ConfigMem.Inst_frame3_bit18.Q VGND sg13g2_inv_1
X_3115_ FrameData[15] FrameStrobe[2] Inst_RegFile_ConfigMem.Inst_frame2_bit15.Q VPWR
+ VGND sg13g2_dlhq_1
XFILLER_23_48 VPWR VGND sg13g2_fill_1
XFILLER_48_89 VPWR VGND sg13g2_fill_2
XFILLER_54_392 VPWR VGND sg13g2_fill_2
XFILLER_10_484 VPWR VGND sg13g2_fill_2
XFILLER_1_160 VPWR VGND sg13g2_fill_2
X_1994_ _0610_ VPWR _0611_ VGND N2MID[7] Inst_RegFile_ConfigMem.Inst_frame6_bit24.Q
+ sg13g2_o21ai_1
X_3595_ Inst_RegFile_switch_matrix.SS4BEG3 net195 VPWR VGND sg13g2_buf_1
X_2615_ _1113_ _1061_ _1106_ VPWR VGND sg13g2_nand2_1
XFILLER_20_259 VPWR VGND sg13g2_fill_1
X_1428_ _1185_ Inst_RegFile_ConfigMem.Inst_frame3_bit12.Q AD2 VPWR VGND sg13g2_nand2_1
X_2477_ Inst_RegFile_ConfigMem.Inst_frame6_bit12.Q N2MID[5] E2MID[5] S2MID[5] W2MID[5]
+ Inst_RegFile_ConfigMem.Inst_frame6_bit13.Q _1031_ VPWR VGND sg13g2_mux4_1
X_2546_ _1065_ Inst_RegFile_32x4.mem\[26\]\[0\] _1091_ _0008_ VPWR VGND sg13g2_mux2_1
X_3029_ FrameData[25] FrameStrobe[5] Inst_RegFile_ConfigMem.Inst_frame5_bit25.Q VPWR
+ VGND sg13g2_dlhq_1
Xclkload2 VPWR clkload2/Y clknet_5_9__leaf_UserCLK_regs VGND sg13g2_inv_1
X_2400_ VGND VPWR Inst_RegFile_ConfigMem.Inst_frame11_bit14.Q _1182_ _0985_ _0984_
+ sg13g2_a21oi_1
XFILLER_6_296 VPWR VGND sg13g2_fill_1
X_3380_ VPWR VGND _1362_ sg13g2_tiehi
X_2262_ _0861_ VPWR _0863_ VGND Inst_RegFile_ConfigMem.Inst_frame3_bit2.Q _0862_ sg13g2_o21ai_1
X_2331_ VGND VPWR Inst_RegFile_ConfigMem.Inst_frame9_bit6.Q _1182_ _0926_ _0925_ sg13g2_a21oi_1
X_2193_ Inst_RegFile_ConfigMem.Inst_frame1_bit0.Q S2END[1] S4END[1] SS4END[0] W2END[1]
+ Inst_RegFile_ConfigMem.Inst_frame1_bit1.Q _0798_ VPWR VGND sg13g2_mux4_1
X_1977_ Inst_RegFile_ConfigMem.Inst_frame4_bit16.Q N1END[1] N2END[5] NN4END[3] E1END[1]
+ Inst_RegFile_ConfigMem.Inst_frame4_bit17.Q _0595_ VPWR VGND sg13g2_mux4_1
X_3578_ Inst_RegFile_switch_matrix.S4BEG2 net178 VPWR VGND sg13g2_buf_1
X_2529_ VPWR VGND _1079_ Inst_RegFile_ConfigMem.Inst_frame9_bit26.Q _1077_ Inst_RegFile_ConfigMem.Inst_frame7_bit7.Q
+ _1080_ _1076_ sg13g2_a221oi_1
X_1900_ _0524_ _0523_ _0409_ VPWR VGND sg13g2_nand2b_1
XFILLER_30_332 VPWR VGND sg13g2_fill_2
X_1831_ _1139_ VPWR _0458_ VGND _0439_ _0457_ sg13g2_o21ai_1
X_2880_ FrameData[4] FrameStrobe[9] Inst_RegFile_ConfigMem.Inst_frame9_bit4.Q VPWR
+ VGND sg13g2_dlhq_1
X_3501_ Inst_RegFile_switch_matrix.JN2BEG5 net110 VPWR VGND sg13g2_buf_1
X_3432_ EE4END[12] net47 VPWR VGND sg13g2_buf_1
X_1762_ AD0 Inst_RegFile_ConfigMem.Inst_frame2_bit16.Q _0392_ VPWR VGND sg13g2_nor2b_1
X_3363_ VPWR VGND _1345_ sg13g2_tiehi
X_1693_ A_ADR0 Inst_RegFile_32x4.mem\[30\]\[3\] Inst_RegFile_32x4.mem\[31\]\[3\] Inst_RegFile_32x4.mem\[28\]\[3\]
+ Inst_RegFile_32x4.mem\[29\]\[3\] _1210_ _0327_ VPWR VGND sg13g2_mux4_1
X_2245_ VGND VPWR Inst_RegFile_ConfigMem.Inst_frame3_bit30.Q _0846_ _0847_ Inst_RegFile_ConfigMem.Inst_frame3_bit31.Q
+ sg13g2_a21oi_1
X_2176_ Inst_RegFile_ConfigMem.Inst_frame1_bit31.Q VPWR _0782_ VGND _0778_ _0781_
+ sg13g2_o21ai_1
X_2314_ Inst_RegFile_ConfigMem.Inst_frame6_bit2.Q N2MID[3] E2MID[3] S2MID[3] W2MID[3]
+ Inst_RegFile_ConfigMem.Inst_frame6_bit3.Q _0911_ VPWR VGND sg13g2_mux4_1
X_3294_ VPWR VGND _1276_ sg13g2_tiehi
XFILLER_25_0 VPWR VGND sg13g2_fill_2
XFILLER_53_446 VPWR VGND sg13g2_fill_1
Xoutput48 net48 EE4BEG[9] VPWR VGND sg13g2_buf_1
Xoutput26 net26 E6BEG[3] VPWR VGND sg13g2_buf_1
Xoutput59 net59 FrameData_O[19] VPWR VGND sg13g2_buf_1
Xoutput15 net15 E2BEGb[2] VPWR VGND sg13g2_buf_1
Xoutput37 net37 EE4BEG[13] VPWR VGND sg13g2_buf_1
X_2030_ Inst_RegFile_ConfigMem.Inst_frame6_bit16.Q N2MID[7] E2MID[7] S2MID[7] W2MID[7]
+ Inst_RegFile_ConfigMem.Inst_frame6_bit17.Q _0645_ VPWR VGND sg13g2_mux4_1
X_2932_ FrameData[24] FrameStrobe[8] Inst_RegFile_ConfigMem.Inst_frame8_bit24.Q VPWR
+ VGND sg13g2_dlhq_1
X_1814_ BD3 Inst_RegFile_ConfigMem.Inst_frame1_bit24.Q _0442_ VPWR VGND sg13g2_nor2b_1
X_1745_ Inst_RegFile_ConfigMem.Inst_frame2_bit25.Q _0374_ _0375_ _0376_ VPWR VGND
+ sg13g2_nor3_1
X_2794_ FrameData[14] FrameStrobe[12] Inst_RegFile_ConfigMem.Inst_frame12_bit14.Q
+ VPWR VGND sg13g2_dlhq_1
XFILLER_30_184 VPWR VGND sg13g2_fill_2
X_2863_ FrameData[19] FrameStrobe[10] Inst_RegFile_ConfigMem.Inst_frame10_bit19.Q
+ VPWR VGND sg13g2_dlhq_1
X_3415_ E6END[5] net26 VPWR VGND sg13g2_buf_1
X_3346_ VPWR VGND _1328_ sg13g2_tiehi
X_1676_ VPWR VGND _0186_ _0235_ _0311_ _0302_ _0312_ _0303_ sg13g2_a221oi_1
X_3277_ VPWR VGND _1259_ sg13g2_tiehi
X_2228_ VGND VPWR S4END[1] Inst_RegFile_ConfigMem.Inst_frame2_bit0.Q _0831_ _0830_
+ sg13g2_a21oi_1
X_2159_ Inst_RegFile_ConfigMem.Inst_frame4_bit5.Q N2END[2] E1END[0] N4END[2] E2END[2]
+ Inst_RegFile_ConfigMem.Inst_frame4_bit4.Q _0766_ VPWR VGND sg13g2_mux4_1
XFILLER_26_457 VPWR VGND sg13g2_fill_2
XFILLER_13_129 VPWR VGND sg13g2_fill_2
XFILLER_32_416 VPWR VGND sg13g2_fill_2
XFILLER_17_457 VPWR VGND sg13g2_fill_2
X_1461_ Inst_RegFile_ConfigMem.Inst_frame2_bit20.Q AD3 _1217_ VPWR VGND sg13g2_nor2_1
X_1530_ Inst_RegFile_ConfigMem.Inst_frame1_bit22.Q VPWR _0173_ VGND Inst_RegFile_ConfigMem.Inst_frame1_bit21.Q
+ _0172_ sg13g2_o21ai_1
X_3200_ _1320_ VGND VPWR Inst_RegFile_32x4.AD_comb\[0\] Inst_RegFile_32x4.AD_reg\[0\]
+ clknet_5_18__leaf_UserCLK_regs sg13g2_dfrbpq_1
X_1392_ VPWR _1150_ Inst_RegFile_ConfigMem.Inst_frame2_bit30.Q VGND sg13g2_inv_1
X_3062_ FrameData[26] FrameStrobe[4] Inst_RegFile_ConfigMem.Inst_frame4_bit26.Q VPWR
+ VGND sg13g2_dlhq_1
X_2013_ VGND VPWR S2END[4] Inst_RegFile_ConfigMem.Inst_frame4_bit12.Q _0629_ _0628_
+ sg13g2_a21oi_1
X_3131_ FrameData[31] FrameStrobe[2] Inst_RegFile_ConfigMem.Inst_frame2_bit31.Q VPWR
+ VGND sg13g2_dlhq_1
XFILLER_35_287 VPWR VGND sg13g2_fill_1
X_2915_ FrameData[7] FrameStrobe[8] Inst_RegFile_ConfigMem.Inst_frame8_bit7.Q VPWR
+ VGND sg13g2_dlhq_1
X_1728_ Inst_RegFile_ConfigMem.Inst_frame0_bit26.Q N4END[2] _0359_ VPWR VGND sg13g2_nor2b_1
X_2777_ _1284_ VGND VPWR _0071_ Inst_RegFile_32x4.mem\[20\]\[3\] clknet_5_8__leaf_UserCLK_regs
+ sg13g2_dfrbpq_1
X_2846_ FrameData[2] FrameStrobe[10] Inst_RegFile_ConfigMem.Inst_frame10_bit2.Q VPWR
+ VGND sg13g2_dlhq_1
X_1659_ VGND VPWR Inst_RegFile_32x4.mem\[7\]\[2\] A_ADR0 _0295_ _0294_ sg13g2_a21oi_1
X_3329_ VPWR VGND _1311_ sg13g2_tiehi
Xoutput205 net205 UserCLKo VPWR VGND sg13g2_buf_1
X_2700_ _1087_ Inst_RegFile_32x4.mem\[11\]\[3\] _1130_ _0123_ VPWR VGND sg13g2_mux2_1
X_2562_ _1026_ _1029_ _1096_ VPWR VGND sg13g2_nor2_1
Xoutput216 net216 W2BEG[6] VPWR VGND sg13g2_buf_1
X_2631_ _1065_ Inst_RegFile_32x4.mem\[20\]\[0\] _1116_ _0068_ VPWR VGND sg13g2_mux2_1
X_1375_ VPWR _1133_ Inst_RegFile_ConfigMem.Inst_frame3_bit17.Q VGND sg13g2_inv_1
X_2493_ _1041_ _1046_ _1047_ VPWR VGND sg13g2_and2_1
Xoutput249 net249 WW4BEG[5] VPWR VGND sg13g2_buf_1
Xoutput238 net238 WW4BEG[0] VPWR VGND sg13g2_buf_1
Xoutput227 net227 W6BEG[10] VPWR VGND sg13g2_buf_1
X_1513_ Inst_RegFile_ConfigMem.Inst_frame1_bit12.Q N1END[2] N2END[4] NN4END[3] E2END[4]
+ Inst_RegFile_ConfigMem.Inst_frame1_bit13.Q _0157_ VPWR VGND sg13g2_mux4_1
X_1444_ _1200_ _1199_ Inst_RegFile_ConfigMem.Inst_frame3_bit15.Q _1201_ VPWR VGND
+ sg13g2_a21o_1
X_3045_ FrameData[9] FrameStrobe[4] Inst_RegFile_ConfigMem.Inst_frame4_bit9.Q VPWR
+ VGND sg13g2_dlhq_1
X_3114_ FrameData[14] FrameStrobe[2] Inst_RegFile_ConfigMem.Inst_frame2_bit14.Q VPWR
+ VGND sg13g2_dlhq_1
XFILLER_31_290 VPWR VGND sg13g2_fill_2
X_2829_ FrameData[17] FrameStrobe[11] Inst_RegFile_ConfigMem.Inst_frame11_bit17.Q
+ VPWR VGND sg13g2_dlhq_1
X_1993_ _0610_ Inst_RegFile_ConfigMem.Inst_frame6_bit24.Q E2MID[7] VPWR VGND sg13g2_nand2b_1
XFILLER_20_249 VPWR VGND sg13g2_fill_2
X_2614_ Inst_RegFile_32x4.mem\[15\]\[3\] _1087_ _1112_ _0055_ VPWR VGND sg13g2_mux2_1
X_3594_ Inst_RegFile_switch_matrix.SS4BEG2 net194 VPWR VGND sg13g2_buf_1
X_2545_ _1091_ _1034_ _1090_ VPWR VGND sg13g2_nand2_1
X_1427_ VGND VPWR Inst_RegFile_ConfigMem.Inst_frame8_bit12.Q _1183_ _1184_ Inst_RegFile_ConfigMem.Inst_frame8_bit13.Q
+ sg13g2_a21oi_1
X_2476_ _1030_ _1026_ _1029_ VPWR VGND sg13g2_nand2_1
X_3028_ FrameData[24] FrameStrobe[5] Inst_RegFile_ConfigMem.Inst_frame5_bit24.Q VPWR
+ VGND sg13g2_dlhq_1
XFILLER_43_319 VPWR VGND sg13g2_fill_2
Xclkload3 VPWR clkload3/Y clknet_5_13__leaf_UserCLK_regs VGND sg13g2_inv_1
XFILLER_6_242 VPWR VGND sg13g2_fill_1
XFILLER_37_124 VPWR VGND sg13g2_fill_1
XFILLER_37_102 VPWR VGND sg13g2_fill_1
X_2330_ Inst_RegFile_ConfigMem.Inst_frame9_bit6.Q _1165_ _0925_ VPWR VGND sg13g2_nor2_1
X_2192_ Inst_RegFile_ConfigMem.Inst_frame1_bit0.Q N1END[3] N2END[1] E2END[1] E6END[1]
+ Inst_RegFile_ConfigMem.Inst_frame1_bit1.Q _0797_ VPWR VGND sg13g2_mux4_1
X_2261_ Inst_RegFile_ConfigMem.Inst_frame3_bit0.Q N1END[3] N2END[1] N4END[1] NN4END[0]
+ Inst_RegFile_ConfigMem.Inst_frame3_bit1.Q _0862_ VPWR VGND sg13g2_mux4_1
XFILLER_52_105 VPWR VGND sg13g2_fill_2
X_1976_ Inst_RegFile_ConfigMem.Inst_frame4_bit16.Q E2END[5] S1END[1] S2END[5] W1END[1]
+ Inst_RegFile_ConfigMem.Inst_frame4_bit17.Q _0594_ VPWR VGND sg13g2_mux4_1
X_3577_ Inst_RegFile_switch_matrix.S4BEG1 net177 VPWR VGND sg13g2_buf_1
X_2528_ Inst_RegFile_ConfigMem.Inst_frame7_bit7.Q _1078_ _1079_ VPWR VGND sg13g2_nor2_1
X_2459_ Inst_RegFile_ConfigMem.Inst_frame12_bit14.Q N2END[3] N4END[2] E6END[0] BD1
+ Inst_RegFile_ConfigMem.Inst_frame12_bit15.Q Inst_RegFile_switch_matrix.N4BEG1 VPWR
+ VGND sg13g2_mux4_1
Xclkbuf_5_2__f_UserCLK_regs clknet_4_1_0_UserCLK_regs clknet_5_2__leaf_UserCLK_regs
+ VPWR VGND sg13g2_buf_8
XFILLER_51_160 VPWR VGND sg13g2_fill_2
XFILLER_47_422 VPWR VGND sg13g2_fill_2
X_3500_ Inst_RegFile_switch_matrix.JN2BEG4 net109 VPWR VGND sg13g2_buf_1
X_1761_ W1END[3] Inst_RegFile_ConfigMem.Inst_frame2_bit16.Q _0391_ VPWR VGND sg13g2_nor2_1
X_1830_ VPWR VGND _0456_ Inst_RegFile_ConfigMem.Inst_frame8_bit27.Q _0455_ Inst_RegFile_ConfigMem.Inst_frame7_bit31.Q
+ _0457_ _0454_ sg13g2_a221oi_1
X_3431_ EE4END[11] net46 VPWR VGND sg13g2_buf_1
X_1692_ _0325_ VPWR _0326_ VGND _1210_ _0322_ sg13g2_o21ai_1
X_3362_ VPWR VGND _1344_ sg13g2_tiehi
X_2313_ Inst_RegFile_ConfigMem.Inst_frame6_bit10.Q N2MID[3] E2MID[3] S2MID[3] W2MID[3]
+ Inst_RegFile_ConfigMem.Inst_frame6_bit11.Q _0910_ VPWR VGND sg13g2_mux4_1
X_2244_ VPWR _0846_ _0845_ VGND sg13g2_inv_1
X_2175_ Inst_RegFile_ConfigMem.Inst_frame1_bit30.Q VPWR _0781_ VGND _0779_ _0780_
+ sg13g2_o21ai_1
X_3293_ VPWR VGND _1275_ sg13g2_tiehi
XFILLER_18_0 VPWR VGND sg13g2_fill_2
XFILLER_25_105 VPWR VGND sg13g2_fill_2
X_1959_ B_ADR0 Inst_RegFile_32x4.mem\[4\]\[2\] Inst_RegFile_32x4.mem\[5\]\[2\] Inst_RegFile_32x4.mem\[6\]\[2\]
+ Inst_RegFile_32x4.mem\[7\]\[2\] _0368_ _0579_ VPWR VGND sg13g2_mux4_1
Xclkbuf_5_17__f_UserCLK_regs clknet_4_8_0_UserCLK_regs clknet_5_17__leaf_UserCLK_regs
+ VPWR VGND sg13g2_buf_8
X_3629_ WW4END[4] net238 VPWR VGND sg13g2_buf_1
Xoutput27 net27 E6BEG[4] VPWR VGND sg13g2_buf_1
Xoutput38 net38 EE4BEG[14] VPWR VGND sg13g2_buf_1
Xoutput49 net49 FrameData_O[0] VPWR VGND sg13g2_buf_1
Xoutput16 net16 E2BEGb[3] VPWR VGND sg13g2_buf_1
XFILLER_16_127 VPWR VGND sg13g2_fill_1
X_2931_ FrameData[23] FrameStrobe[8] Inst_RegFile_ConfigMem.Inst_frame8_bit23.Q VPWR
+ VGND sg13g2_dlhq_1
X_1744_ BD0 Inst_RegFile_ConfigMem.Inst_frame2_bit24.Q _0375_ VPWR VGND sg13g2_nor2b_1
X_1813_ VGND VPWR _0441_ _0440_ Inst_RegFile_ConfigMem.Inst_frame1_bit25.Q sg13g2_or2_1
X_2862_ FrameData[18] FrameStrobe[10] Inst_RegFile_ConfigMem.Inst_frame10_bit18.Q
+ VPWR VGND sg13g2_dlhq_1
X_2793_ FrameData[13] FrameStrobe[12] Inst_RegFile_ConfigMem.Inst_frame12_bit13.Q
+ VPWR VGND sg13g2_dlhq_1
X_3276_ VPWR VGND _1258_ sg13g2_tiehi
X_3414_ E6END[4] net25 VPWR VGND sg13g2_buf_1
X_3345_ VPWR VGND _1327_ sg13g2_tiehi
X_1675_ _0311_ _0309_ _0310_ _0304_ _0143_ VPWR VGND sg13g2_a22oi_1
XFILLER_41_406 VPWR VGND sg13g2_fill_1
X_2089_ _0699_ VPWR _0700_ VGND Inst_RegFile_ConfigMem.Inst_frame4_bit9.Q _0698_ sg13g2_o21ai_1
X_2227_ Inst_RegFile_ConfigMem.Inst_frame2_bit0.Q S2END[1] _0830_ VPWR VGND sg13g2_nor2b_1
X_2158_ Inst_RegFile_ConfigMem.Inst_frame4_bit7.Q VPWR _0765_ VGND _0763_ _0764_ sg13g2_o21ai_1
XFILLER_26_49 VPWR VGND sg13g2_fill_1
XFILLER_32_428 VPWR VGND sg13g2_fill_1
X_1460_ Inst_RegFile_ConfigMem.Inst_frame2_bit22.Q _1215_ _1216_ VPWR VGND sg13g2_nor2_1
X_3130_ FrameData[30] FrameStrobe[2] Inst_RegFile_ConfigMem.Inst_frame2_bit30.Q VPWR
+ VGND sg13g2_dlhq_1
X_1391_ VPWR _1149_ Inst_RegFile_ConfigMem.Inst_frame2_bit29.Q VGND sg13g2_inv_1
X_3061_ FrameData[25] FrameStrobe[4] Inst_RegFile_ConfigMem.Inst_frame4_bit25.Q VPWR
+ VGND sg13g2_dlhq_1
X_2012_ Inst_RegFile_ConfigMem.Inst_frame4_bit12.Q E6END[0] _0628_ VPWR VGND sg13g2_nor2b_1
XFILLER_50_225 VPWR VGND sg13g2_fill_1
X_2845_ FrameData[1] FrameStrobe[10] Inst_RegFile_ConfigMem.Inst_frame10_bit1.Q VPWR
+ VGND sg13g2_dlhq_1
X_2914_ FrameData[6] FrameStrobe[8] Inst_RegFile_ConfigMem.Inst_frame8_bit6.Q VPWR
+ VGND sg13g2_dlhq_1
X_1658_ A_ADR0 Inst_RegFile_32x4.mem\[6\]\[2\] _0294_ VPWR VGND sg13g2_nor2b_1
X_1727_ VGND VPWR Inst_RegFile_ConfigMem.Inst_frame0_bit26.Q _0356_ _0358_ _0357_
+ sg13g2_a21oi_1
X_2776_ _1285_ VGND VPWR _0070_ Inst_RegFile_32x4.mem\[20\]\[2\] clknet_5_2__leaf_UserCLK_regs
+ sg13g2_dfrbpq_1
X_3259_ VPWR VGND _1241_ sg13g2_tiehi
X_3328_ VPWR VGND _1310_ sg13g2_tiehi
X_1589_ Inst_RegFile_ConfigMem.Inst_frame6_bit28.Q N2MID[5] E2MID[5] S2MID[5] W2MID[5]
+ Inst_RegFile_ConfigMem.Inst_frame6_bit29.Q _0229_ VPWR VGND sg13g2_mux4_1
XFILLER_5_137 VPWR VGND sg13g2_fill_2
XFILLER_49_303 VPWR VGND sg13g2_fill_1
X_2492_ _1045_ VPWR _1046_ VGND Inst_RegFile_ConfigMem.Inst_frame9_bit28.Q _1042_
+ sg13g2_o21ai_1
Xoutput239 net239 WW4BEG[10] VPWR VGND sg13g2_buf_1
Xoutput228 net228 W6BEG[11] VPWR VGND sg13g2_buf_1
Xoutput206 net206 W1BEG[0] VPWR VGND sg13g2_buf_1
X_2561_ _1087_ Inst_RegFile_32x4.mem\[28\]\[3\] _1095_ _0019_ VPWR VGND sg13g2_mux2_1
Xoutput217 net217 W2BEG[7] VPWR VGND sg13g2_buf_1
X_2630_ _1116_ _1061_ _1108_ VPWR VGND sg13g2_nand2_1
X_1512_ Inst_RegFile_ConfigMem.Inst_frame1_bit15.Q VPWR _0156_ VGND _0152_ _0155_
+ sg13g2_o21ai_1
X_1374_ VPWR _1132_ Inst_RegFile_ConfigMem.Inst_frame4_bit26.Q VGND sg13g2_inv_1
XFILLER_4_192 VPWR VGND sg13g2_fill_2
XFILLER_4_170 VPWR VGND sg13g2_fill_1
X_3113_ FrameData[13] FrameStrobe[2] Inst_RegFile_ConfigMem.Inst_frame2_bit13.Q VPWR
+ VGND sg13g2_dlhq_1
X_1443_ _1200_ Inst_RegFile_ConfigMem.Inst_frame3_bit14.Q _1198_ VPWR VGND sg13g2_nand2_1
X_3044_ FrameData[8] FrameStrobe[4] Inst_RegFile_ConfigMem.Inst_frame4_bit8.Q VPWR
+ VGND sg13g2_dlhq_1
X_2828_ FrameData[16] FrameStrobe[11] Inst_RegFile_ConfigMem.Inst_frame11_bit16.Q
+ VPWR VGND sg13g2_dlhq_1
X_2759_ _1302_ VGND VPWR _0053_ Inst_RegFile_32x4.mem\[15\]\[1\] clknet_5_26__leaf_UserCLK_regs
+ sg13g2_dfrbpq_1
X_1992_ VPWR VGND _0608_ Inst_RegFile_ConfigMem.Inst_frame8_bit21.Q _0606_ Inst_RegFile_ConfigMem.Inst_frame7_bit25.Q
+ _0609_ _0605_ sg13g2_a221oi_1
XFILLER_48_0 VPWR VGND sg13g2_fill_2
X_2613_ Inst_RegFile_32x4.mem\[15\]\[2\] _1069_ _1112_ _0054_ VPWR VGND sg13g2_mux2_1
X_2544_ _1048_ _1058_ _1060_ _1090_ VPWR VGND sg13g2_nor3_1
X_2475_ Inst_RegFile_ConfigMem.Inst_frame8_bit2.Q _1028_ _1018_ _0209_ _1027_ Inst_RegFile_ConfigMem.Inst_frame8_bit3.Q
+ _1029_ VPWR VGND sg13g2_mux4_1
X_3593_ Inst_RegFile_switch_matrix.SS4BEG1 net193 VPWR VGND sg13g2_buf_1
X_1426_ VPWR _1183_ _1182_ VGND sg13g2_inv_1
XFILLER_51_320 VPWR VGND sg13g2_fill_2
X_3027_ FrameData[23] FrameStrobe[5] Inst_RegFile_ConfigMem.Inst_frame5_bit23.Q VPWR
+ VGND sg13g2_dlhq_1
Xclkload4 VPWR clkload4/Y clknet_5_17__leaf_UserCLK_regs VGND sg13g2_inv_1
XFILLER_24_93 VPWR VGND sg13g2_fill_1
XFILLER_37_147 VPWR VGND sg13g2_fill_2
X_2191_ Inst_RegFile_ConfigMem.Inst_frame1_bit3.Q VPWR _0796_ VGND _0794_ _0795_ sg13g2_o21ai_1
X_2260_ _0859_ Inst_RegFile_ConfigMem.Inst_frame3_bit1.Q _0860_ _0861_ VPWR VGND sg13g2_a21o_1
Xclkbuf_5_25__f_UserCLK_regs clknet_4_12_0_UserCLK_regs clknet_5_25__leaf_UserCLK_regs
+ VPWR VGND sg13g2_buf_8
X_1975_ _0586_ _0592_ Inst_RegFile_ConfigMem.Inst_frame4_bit19.Q _0593_ VPWR VGND
+ sg13g2_nand3_1
X_1409_ VPWR _1167_ AD1 VGND sg13g2_inv_1
X_2458_ Inst_RegFile_ConfigMem.Inst_frame12_bit17.Q N2END[0] W6END[1] N4END[3] BD2
+ Inst_RegFile_ConfigMem.Inst_frame12_bit16.Q Inst_RegFile_switch_matrix.N4BEG2 VPWR
+ VGND sg13g2_mux4_1
X_3576_ Inst_RegFile_switch_matrix.S4BEG0 net176 VPWR VGND sg13g2_buf_1
X_2527_ N2MID[0] Inst_RegFile_ConfigMem.Inst_frame7_bit6.Q _1078_ VPWR VGND sg13g2_nor2_1
X_2389_ Inst_RegFile_ConfigMem.Inst_frame11_bit21.Q BD0 BD2 BD1 BD3 Inst_RegFile_ConfigMem.Inst_frame11_bit20.Q
+ _0976_ VPWR VGND sg13g2_mux4_1
X_1760_ _0389_ VPWR _0390_ VGND Inst_RegFile_ConfigMem.Inst_frame2_bit16.Q _1167_
+ sg13g2_o21ai_1
XFILLER_30_334 VPWR VGND sg13g2_fill_1
X_1691_ VGND VPWR _1210_ _0324_ _0325_ _0142_ sg13g2_a21oi_1
X_3430_ EE4END[10] net45 VPWR VGND sg13g2_buf_1
X_3361_ VPWR VGND _1343_ sg13g2_tiehi
X_2312_ VGND VPWR _0907_ _0908_ _0909_ _0903_ sg13g2_a21oi_1
XFILLER_2_290 VPWR VGND sg13g2_fill_1
X_3292_ VPWR VGND _1274_ sg13g2_tiehi
X_2243_ Inst_RegFile_ConfigMem.Inst_frame3_bit29.Q EE4END[0] S1END[2] S1END[0] S2END[0]
+ Inst_RegFile_ConfigMem.Inst_frame3_bit28.Q _0845_ VPWR VGND sg13g2_mux4_1
X_2174_ Inst_RegFile_ConfigMem.Inst_frame1_bit29.Q VPWR _0780_ VGND Inst_RegFile_ConfigMem.Inst_frame1_bit28.Q
+ BD1 sg13g2_o21ai_1
XFILLER_25_128 VPWR VGND sg13g2_fill_2
X_1958_ _0578_ _0577_ _0409_ VPWR VGND sg13g2_nand2b_1
Xoutput17 net17 E2BEGb[4] VPWR VGND sg13g2_buf_1
Xoutput39 net39 EE4BEG[15] VPWR VGND sg13g2_buf_1
Xoutput28 net28 E6BEG[5] VPWR VGND sg13g2_buf_1
X_3628_ Inst_RegFile_switch_matrix.W6BEG1 net228 VPWR VGND sg13g2_buf_1
X_1889_ VGND VPWR _0368_ _0512_ _0513_ _0409_ sg13g2_a21oi_1
Xclkbuf_4_9_0_UserCLK_regs clknet_0_UserCLK_regs clknet_4_9_0_UserCLK_regs VPWR VGND
+ sg13g2_buf_8
X_3559_ S2MID[3] net168 VPWR VGND sg13g2_buf_1
XFILLER_8_349 VPWR VGND sg13g2_fill_2
X_2930_ FrameData[22] FrameStrobe[8] Inst_RegFile_ConfigMem.Inst_frame8_bit22.Q VPWR
+ VGND sg13g2_dlhq_1
X_2861_ FrameData[17] FrameStrobe[10] Inst_RegFile_ConfigMem.Inst_frame10_bit17.Q
+ VPWR VGND sg13g2_dlhq_1
XFILLER_22_109 VPWR VGND sg13g2_fill_1
X_1743_ Inst_RegFile_ConfigMem.Inst_frame2_bit24.Q AD3 _0374_ VPWR VGND sg13g2_nor2_1
X_1812_ AD3 BD0 Inst_RegFile_ConfigMem.Inst_frame1_bit24.Q _0440_ VPWR VGND sg13g2_mux2_1
X_3413_ E6END[3] net24 VPWR VGND sg13g2_buf_1
X_1674_ VGND VPWR _1210_ _0306_ _0310_ _0143_ sg13g2_a21oi_1
X_2792_ FrameData[12] FrameStrobe[12] Inst_RegFile_ConfigMem.Inst_frame12_bit12.Q
+ VPWR VGND sg13g2_dlhq_1
X_3275_ VPWR VGND _1257_ sg13g2_tiehi
X_3344_ VPWR VGND _1326_ sg13g2_tiehi
X_2226_ W2END[1] WW4END[0] Inst_RegFile_ConfigMem.Inst_frame2_bit0.Q _0829_ VPWR VGND
+ sg13g2_mux2_1
X_2088_ VGND VPWR Inst_RegFile_ConfigMem.Inst_frame4_bit9.Q _0696_ _0699_ Inst_RegFile_ConfigMem.Inst_frame4_bit10.Q
+ sg13g2_a21oi_1
X_2157_ _0764_ Inst_RegFile_ConfigMem.Inst_frame4_bit6.Q _0761_ VPWR VGND sg13g2_nand2_1
XFILLER_21_186 VPWR VGND sg13g2_fill_2
X_3060_ FrameData[24] FrameStrobe[4] Inst_RegFile_ConfigMem.Inst_frame4_bit24.Q VPWR
+ VGND sg13g2_dlhq_1
X_1390_ VPWR _1148_ Inst_RegFile_ConfigMem.Inst_frame4_bit10.Q VGND sg13g2_inv_1
X_2011_ _0627_ Inst_RegFile_ConfigMem.Inst_frame4_bit15.Q _0621_ VPWR VGND sg13g2_nand2_1
XFILLER_23_407 VPWR VGND sg13g2_fill_1
XFILLER_31_484 VPWR VGND sg13g2_fill_2
X_2913_ FrameData[5] FrameStrobe[8] Inst_RegFile_ConfigMem.Inst_frame8_bit5.Q VPWR
+ VGND sg13g2_dlhq_1
X_2844_ FrameData[0] FrameStrobe[10] Inst_RegFile_ConfigMem.Inst_frame10_bit0.Q VPWR
+ VGND sg13g2_dlhq_1
X_1657_ VGND VPWR Inst_RegFile_32x4.mem\[5\]\[2\] A_ADR0 _0293_ _0292_ sg13g2_a21oi_1
X_1726_ Inst_RegFile_ConfigMem.Inst_frame0_bit27.Q VPWR _0357_ VGND Inst_RegFile_ConfigMem.Inst_frame0_bit26.Q
+ W2END[2] sg13g2_o21ai_1
X_1588_ Inst_RegFile_ConfigMem.Inst_frame7_bit26.Q N2MID[2] S2MID[2] W2MID[2] Inst_RegFile_switch_matrix.E2BEG6
+ Inst_RegFile_ConfigMem.Inst_frame7_bit27.Q _0228_ VPWR VGND sg13g2_mux4_1
X_2775_ _1286_ VGND VPWR _0069_ Inst_RegFile_32x4.mem\[20\]\[1\] clknet_5_9__leaf_UserCLK_regs
+ sg13g2_dfrbpq_1
X_3258_ VPWR VGND _1240_ sg13g2_tiehi
X_3189_ FrameData[25] FrameStrobe[0] Inst_RegFile_ConfigMem.Inst_frame0_bit25.Q VPWR
+ VGND sg13g2_dlhq_1
X_2209_ Inst_RegFile_ConfigMem.Inst_frame2_bit29.Q N1END[0] E1END[0] N2END[0] E2END[0]
+ Inst_RegFile_ConfigMem.Inst_frame2_bit28.Q _0813_ VPWR VGND sg13g2_mux4_1
X_3327_ VPWR VGND _1309_ sg13g2_tiehi
X_2491_ VGND VPWR Inst_RegFile_ConfigMem.Inst_frame9_bit28.Q _1044_ _1045_ Inst_RegFile_ConfigMem.Inst_frame9_bit29.Q
+ sg13g2_a21oi_1
X_1442_ _1199_ _1197_ Inst_RegFile_ConfigMem.Inst_frame3_bit14.Q VPWR VGND sg13g2_nand2b_1
Xoutput218 net218 W2BEGb[0] VPWR VGND sg13g2_buf_1
Xoutput229 net229 W6BEG[1] VPWR VGND sg13g2_buf_1
X_2560_ _1069_ Inst_RegFile_32x4.mem\[28\]\[2\] _1095_ _0018_ VPWR VGND sg13g2_mux2_1
Xoutput207 net207 W1BEG[1] VPWR VGND sg13g2_buf_1
X_1511_ Inst_RegFile_ConfigMem.Inst_frame1_bit14.Q VPWR _0155_ VGND _0153_ _0154_
+ sg13g2_o21ai_1
X_3112_ FrameData[12] FrameStrobe[2] Inst_RegFile_ConfigMem.Inst_frame2_bit12.Q VPWR
+ VGND sg13g2_dlhq_1
X_3043_ FrameData[7] FrameStrobe[4] Inst_RegFile_ConfigMem.Inst_frame4_bit7.Q VPWR
+ VGND sg13g2_dlhq_1
XFILLER_23_215 VPWR VGND sg13g2_fill_1
X_2827_ FrameData[15] FrameStrobe[11] Inst_RegFile_ConfigMem.Inst_frame11_bit15.Q
+ VPWR VGND sg13g2_dlhq_1
X_2758_ _1303_ VGND VPWR _0052_ Inst_RegFile_32x4.mem\[15\]\[0\] clknet_5_26__leaf_UserCLK_regs
+ sg13g2_dfrbpq_1
X_2689_ Inst_RegFile_32x4.mem\[0\]\[2\] _1069_ _1128_ _0114_ VPWR VGND sg13g2_mux2_1
X_1709_ _0340_ VPWR _0341_ VGND Inst_RegFile_ConfigMem.Inst_frame8_bit23.Q _0228_
+ sg13g2_o21ai_1
XFILLER_38_70 VPWR VGND sg13g2_fill_2
X_1991_ Inst_RegFile_ConfigMem.Inst_frame7_bit25.Q _0607_ _0608_ VPWR VGND sg13g2_nor2_1
X_3592_ Inst_RegFile_switch_matrix.SS4BEG0 net192 VPWR VGND sg13g2_buf_1
X_2612_ Inst_RegFile_32x4.mem\[15\]\[1\] _1067_ _1112_ _0053_ VPWR VGND sg13g2_mux2_1
X_1425_ Inst_RegFile_ConfigMem.Inst_frame6_bit18.Q N2MID[3] E2MID[3] S2MID[3] W2MID[3]
+ Inst_RegFile_ConfigMem.Inst_frame6_bit19.Q _1182_ VPWR VGND sg13g2_mux4_1
X_2474_ Inst_RegFile_ConfigMem.Inst_frame7_bit15.Q N2MID[0] W2MID[0] S2MID[0] Inst_RegFile_switch_matrix.JW2BEG4
+ Inst_RegFile_ConfigMem.Inst_frame7_bit14.Q _1028_ VPWR VGND sg13g2_mux4_1
X_2543_ _1087_ Inst_RegFile_32x4.mem\[25\]\[3\] _1089_ _0007_ VPWR VGND sg13g2_mux2_1
XFILLER_28_329 VPWR VGND sg13g2_fill_1
X_3026_ FrameData[22] FrameStrobe[5] Inst_RegFile_ConfigMem.Inst_frame5_bit22.Q VPWR
+ VGND sg13g2_dlhq_1
Xclkload5 VPWR clkload5/Y clknet_5_21__leaf_UserCLK_regs VGND sg13g2_inv_1
XFILLER_19_329 VPWR VGND sg13g2_fill_1
XFILLER_54_170 VPWR VGND sg13g2_fill_1
XFILLER_10_240 VPWR VGND sg13g2_fill_1
XFILLER_10_262 VPWR VGND sg13g2_fill_2
Xclkbuf_5_12__f_UserCLK_regs clknet_4_6_0_UserCLK_regs clknet_5_12__leaf_UserCLK_regs
+ VPWR VGND sg13g2_buf_8
X_2190_ _0795_ Inst_RegFile_ConfigMem.Inst_frame1_bit2.Q _0792_ VPWR VGND sg13g2_nand2_1
X_1974_ _0591_ VPWR _0592_ VGND Inst_RegFile_ConfigMem.Inst_frame4_bit17.Q _0590_
+ sg13g2_o21ai_1
X_3575_ S4END[15] net175 VPWR VGND sg13g2_buf_1
X_3644_ Inst_RegFile_switch_matrix.WW4BEG3 net244 VPWR VGND sg13g2_buf_1
XFILLER_20_19 VPWR VGND sg13g2_fill_1
X_1408_ VPWR _1166_ AD0 VGND sg13g2_inv_1
X_2388_ _0974_ VPWR _0975_ VGND Inst_RegFile_ConfigMem.Inst_frame11_bit21.Q _0971_
+ sg13g2_o21ai_1
X_2457_ Inst_RegFile_ConfigMem.Inst_frame12_bit18.Q N2END[1] N4END[0] W6END[0] BD3
+ Inst_RegFile_ConfigMem.Inst_frame12_bit19.Q Inst_RegFile_switch_matrix.N4BEG3 VPWR
+ VGND sg13g2_mux4_1
X_2526_ _1077_ Inst_RegFile_ConfigMem.Inst_frame7_bit6.Q E2MID[0] VPWR VGND sg13g2_nand2b_1
X_3009_ FrameData[5] FrameStrobe[5] Inst_RegFile_ConfigMem.Inst_frame5_bit5.Q VPWR
+ VGND sg13g2_dlhq_1
XFILLER_51_162 VPWR VGND sg13g2_fill_1
XFILLER_10_52 VPWR VGND sg13g2_fill_1
XFILLER_10_41 VPWR VGND sg13g2_fill_1
XFILLER_27_181 VPWR VGND sg13g2_decap_4
XFILLER_51_92 VPWR VGND sg13g2_fill_2
X_1690_ VGND VPWR Inst_RegFile_32x4.mem\[25\]\[3\] A_ADR0 _0324_ _0323_ sg13g2_a21oi_1
X_3360_ VPWR VGND _1342_ sg13g2_tiehi
X_2311_ VGND VPWR Inst_RegFile_ConfigMem.Inst_frame9_bit13.Q _0905_ _0908_ _1151_
+ sg13g2_a21oi_1
X_2242_ Inst_RegFile_ConfigMem.Inst_frame3_bit29.Q N1END[0] E1END[0] N2END[0] E2END[0]
+ Inst_RegFile_ConfigMem.Inst_frame3_bit28.Q _0844_ VPWR VGND sg13g2_mux4_1
X_3291_ VPWR VGND _1273_ sg13g2_tiehi
X_2173_ BD2 Inst_RegFile_ConfigMem.Inst_frame1_bit28.Q _0779_ VPWR VGND sg13g2_nor2b_1
XFILLER_25_107 VPWR VGND sg13g2_fill_1
X_1957_ B_ADR0 Inst_RegFile_32x4.mem\[0\]\[2\] Inst_RegFile_32x4.mem\[1\]\[2\] Inst_RegFile_32x4.mem\[2\]\[2\]
+ Inst_RegFile_32x4.mem\[3\]\[2\] _0368_ _0577_ VPWR VGND sg13g2_mux4_1
XFILLER_21_379 VPWR VGND sg13g2_fill_1
Xoutput29 net29 E6BEG[6] VPWR VGND sg13g2_buf_1
X_2509_ Inst_RegFile_ConfigMem.Inst_frame7_bit0.Q N2MID[6] S2MID[6] W2MID[6] Inst_RegFile_switch_matrix.JN2BEG3
+ Inst_RegFile_ConfigMem.Inst_frame7_bit1.Q _1063_ VPWR VGND sg13g2_mux4_1
Xoutput18 net18 E2BEGb[5] VPWR VGND sg13g2_buf_1
X_3558_ S2MID[2] net167 VPWR VGND sg13g2_buf_1
X_1888_ _0511_ VPWR _0512_ VGND Inst_RegFile_32x4.mem\[26\]\[1\] B_ADR0 sg13g2_o21ai_1
X_3627_ Inst_RegFile_switch_matrix.W6BEG0 net227 VPWR VGND sg13g2_buf_1
X_3489_ FrameStrobe[17] net89 VPWR VGND sg13g2_buf_1
XANTENNA_80 VPWR VGND N2MID[7] sg13g2_antennanp
X_2791_ FrameData[11] FrameStrobe[12] Inst_RegFile_ConfigMem.Inst_frame12_bit11.Q
+ VPWR VGND sg13g2_dlhq_1
X_1811_ VGND VPWR Inst_RegFile_ConfigMem.Inst_frame6_bit31.Q _0436_ _0439_ _0438_
+ sg13g2_a21oi_1
XFILLER_15_140 VPWR VGND sg13g2_fill_2
X_2860_ FrameData[16] FrameStrobe[10] Inst_RegFile_ConfigMem.Inst_frame10_bit16.Q
+ VPWR VGND sg13g2_dlhq_1
X_1742_ Inst_RegFile_ConfigMem.Inst_frame2_bit26.Q _0372_ _0373_ VPWR VGND sg13g2_nor2_1
X_3412_ E6END[2] net21 VPWR VGND sg13g2_buf_1
X_1673_ _0309_ _0308_ _1210_ VPWR VGND sg13g2_nand2b_1
X_3274_ VPWR VGND _1256_ sg13g2_tiehi
X_2225_ Inst_RegFile_ConfigMem.Inst_frame2_bit1.Q N2END[1] E2END[1] E1END[3] E6END[1]
+ Inst_RegFile_ConfigMem.Inst_frame2_bit0.Q _0828_ VPWR VGND sg13g2_mux4_1
X_3343_ VPWR VGND _1325_ sg13g2_tiehi
XFILLER_23_0 VPWR VGND sg13g2_fill_2
X_2087_ VGND VPWR Inst_RegFile_ConfigMem.Inst_frame4_bit8.Q AD0 _0698_ _0697_ sg13g2_a21oi_1
XFILLER_38_287 VPWR VGND sg13g2_fill_2
X_2156_ VGND VPWR Inst_RegFile_ConfigMem.Inst_frame4_bit4.Q _1165_ _0763_ _0762_ sg13g2_a21oi_1
X_2989_ FrameData[17] FrameStrobe[6] Inst_RegFile_ConfigMem.Inst_frame6_bit17.Q VPWR
+ VGND sg13g2_dlhq_1
XFILLER_29_221 VPWR VGND sg13g2_fill_2
XFILLER_17_405 VPWR VGND sg13g2_fill_1
XFILLER_4_353 VPWR VGND sg13g2_fill_2
XFILLER_8_169 VPWR VGND sg13g2_fill_2
X_2010_ VGND VPWR Inst_RegFile_ConfigMem.Inst_frame4_bit13.Q _0624_ _0626_ _0625_
+ sg13g2_a21oi_1
XFILLER_35_268 VPWR VGND sg13g2_fill_2
X_2912_ FrameData[4] FrameStrobe[8] Inst_RegFile_ConfigMem.Inst_frame8_bit4.Q VPWR
+ VGND sg13g2_dlhq_1
X_1725_ VPWR Inst_RegFile_switch_matrix.E2BEG4 _0356_ VGND sg13g2_inv_1
X_2843_ FrameData[31] FrameStrobe[11] Inst_RegFile_ConfigMem.Inst_frame11_bit31.Q
+ VPWR VGND sg13g2_dlhq_1
X_2774_ _1287_ VGND VPWR _0068_ Inst_RegFile_32x4.mem\[20\]\[0\] clknet_5_9__leaf_UserCLK_regs
+ sg13g2_dfrbpq_1
X_1656_ A_ADR0 Inst_RegFile_32x4.mem\[4\]\[2\] _0292_ VPWR VGND sg13g2_nor2b_1
X_1587_ _0227_ VPWR Inst_RegFile_switch_matrix.E2BEG6 VGND _0216_ _0223_ sg13g2_o21ai_1
X_3326_ VPWR VGND _1308_ sg13g2_tiehi
X_3257_ VPWR VGND _1239_ sg13g2_tiehi
X_3188_ FrameData[24] FrameStrobe[0] Inst_RegFile_ConfigMem.Inst_frame0_bit24.Q VPWR
+ VGND sg13g2_dlhq_1
X_2208_ _0806_ _0811_ Inst_RegFile_ConfigMem.Inst_frame2_bit31.Q _0812_ VPWR VGND
+ sg13g2_nand3_1
X_2139_ Inst_RegFile_ConfigMem.Inst_frame3_bit4.Q E2END[2] _0747_ VPWR VGND sg13g2_nor2b_1
XFILLER_41_227 VPWR VGND sg13g2_fill_1
XFILLER_34_290 VPWR VGND sg13g2_fill_2
XFILLER_22_485 VPWR VGND sg13g2_fill_1
XFILLER_5_139 VPWR VGND sg13g2_fill_1
XFILLER_9_456 VPWR VGND sg13g2_fill_2
X_2490_ VPWR _1044_ _1043_ VGND sg13g2_inv_1
X_1441_ Inst_RegFile_ConfigMem.Inst_frame3_bit12.Q E6END[0] S2END[4] SS4END[3] W2END[4]
+ Inst_RegFile_ConfigMem.Inst_frame3_bit13.Q _1198_ VPWR VGND sg13g2_mux4_1
X_1510_ Inst_RegFile_ConfigMem.Inst_frame1_bit13.Q VPWR _0154_ VGND Inst_RegFile_ConfigMem.Inst_frame1_bit12.Q
+ BD2 sg13g2_o21ai_1
Xoutput219 net219 W2BEGb[1] VPWR VGND sg13g2_buf_1
Xoutput208 net208 W1BEG[2] VPWR VGND sg13g2_buf_1
X_3111_ FrameData[11] FrameStrobe[2] Inst_RegFile_ConfigMem.Inst_frame2_bit11.Q VPWR
+ VGND sg13g2_dlhq_1
X_3042_ FrameData[6] FrameStrobe[4] Inst_RegFile_ConfigMem.Inst_frame4_bit6.Q VPWR
+ VGND sg13g2_dlhq_1
X_1708_ VGND VPWR Inst_RegFile_ConfigMem.Inst_frame8_bit23.Q _0339_ _0340_ Inst_RegFile_ConfigMem.Inst_frame8_bit24.Q
+ sg13g2_a21oi_1
X_2826_ FrameData[14] FrameStrobe[11] Inst_RegFile_ConfigMem.Inst_frame11_bit14.Q
+ VPWR VGND sg13g2_dlhq_1
X_2688_ Inst_RegFile_32x4.mem\[0\]\[1\] _1067_ _1128_ _0113_ VPWR VGND sg13g2_mux2_1
X_2757_ _1304_ VGND VPWR _0051_ Inst_RegFile_32x4.mem\[14\]\[3\] clknet_5_24__leaf_UserCLK_regs
+ sg13g2_dfrbpq_1
X_3309_ VPWR VGND _1291_ sg13g2_tiehi
X_1639_ VGND VPWR _0142_ _0276_ _0277_ _0186_ sg13g2_a21oi_1
Xclkbuf_5_20__f_UserCLK_regs clknet_4_10_0_UserCLK_regs clknet_5_20__leaf_UserCLK_regs
+ VPWR VGND sg13g2_buf_8
XFILLER_14_216 VPWR VGND sg13g2_fill_1
XFILLER_22_260 VPWR VGND sg13g2_fill_1
XFILLER_1_142 VPWR VGND sg13g2_fill_1
X_1990_ N2MID[6] Inst_RegFile_ConfigMem.Inst_frame7_bit24.Q _0607_ VPWR VGND sg13g2_nor2_1
X_3591_ SS4END[15] net191 VPWR VGND sg13g2_buf_1
X_2611_ Inst_RegFile_32x4.mem\[15\]\[0\] _1065_ _1112_ _0052_ VPWR VGND sg13g2_mux2_1
X_2542_ _1069_ Inst_RegFile_32x4.mem\[25\]\[2\] _1089_ _0006_ VPWR VGND sg13g2_mux2_1
X_1424_ VGND VPWR _1181_ _1180_ Inst_RegFile_ConfigMem.Inst_frame8_bit12.Q sg13g2_or2_1
X_2473_ Inst_RegFile_ConfigMem.Inst_frame0_bit15.Q N4END[0] W6END[0] SS4END[0] Inst_RegFile_switch_matrix.JW2BEG2
+ Inst_RegFile_ConfigMem.Inst_frame0_bit14.Q _1027_ VPWR VGND sg13g2_mux4_1
X_3025_ FrameData[21] FrameStrobe[5] Inst_RegFile_ConfigMem.Inst_frame5_bit21.Q VPWR
+ VGND sg13g2_dlhq_1
Xclkload6 VPWR clkload6/Y clknet_5_25__leaf_UserCLK_regs VGND sg13g2_inv_1
X_2809_ FrameData[29] FrameStrobe[12] Inst_RegFile_ConfigMem.Inst_frame12_bit29.Q
+ VPWR VGND sg13g2_dlhq_1
X_1973_ VGND VPWR Inst_RegFile_ConfigMem.Inst_frame4_bit17.Q _0588_ _0591_ Inst_RegFile_ConfigMem.Inst_frame4_bit18.Q
+ sg13g2_a21oi_1
X_3574_ S4END[14] net174 VPWR VGND sg13g2_buf_1
XFILLER_53_0 VPWR VGND sg13g2_fill_2
X_2525_ S2MID[0] Inst_RegFile_switch_matrix.JW2BEG3 Inst_RegFile_ConfigMem.Inst_frame7_bit6.Q
+ _1076_ VPWR VGND sg13g2_mux2_1
X_3643_ Inst_RegFile_switch_matrix.WW4BEG2 net243 VPWR VGND sg13g2_buf_1
X_1407_ VPWR _1165_ BD3 VGND sg13g2_inv_1
X_2387_ _1156_ _0973_ _0974_ VPWR VGND sg13g2_nor2_1
X_2456_ Inst_RegFile_ConfigMem.Inst_frame11_bit1.Q AD3 Inst_RegFile_switch_matrix.JN2BEG3
+ _1018_ _1017_ Inst_RegFile_ConfigMem.Inst_frame11_bit0.Q Inst_RegFile_switch_matrix.E1BEG0
+ VPWR VGND sg13g2_mux4_1
X_3008_ FrameData[4] FrameStrobe[5] Inst_RegFile_ConfigMem.Inst_frame5_bit4.Q VPWR
+ VGND sg13g2_dlhq_1
XFILLER_51_82 VPWR VGND sg13g2_fill_2
X_2310_ _0906_ VPWR _0907_ VGND Inst_RegFile_ConfigMem.Inst_frame9_bit12.Q _1166_
+ sg13g2_o21ai_1
X_2241_ Inst_RegFile_ConfigMem.Inst_frame3_bit31.Q VPWR _0843_ VGND Inst_RegFile_ConfigMem.Inst_frame3_bit30.Q
+ _0836_ sg13g2_o21ai_1
X_2172_ VGND VPWR _0776_ _0777_ _0778_ Inst_RegFile_ConfigMem.Inst_frame1_bit29.Q
+ sg13g2_a21oi_1
X_3290_ VPWR VGND _1272_ sg13g2_tiehi
X_1956_ _0576_ _0575_ _0409_ _0574_ _0571_ VPWR VGND sg13g2_a22oi_1
X_1887_ _0511_ B_ADR0 Inst_RegFile_32x4.mem\[27\]\[1\] VPWR VGND sg13g2_nand2b_1
X_3488_ FrameStrobe[16] net88 VPWR VGND sg13g2_buf_1
Xoutput19 net19 E2BEGb[6] VPWR VGND sg13g2_buf_1
X_3557_ S2MID[1] net166 VPWR VGND sg13g2_buf_1
X_2508_ _1062_ _1034_ _1061_ VPWR VGND sg13g2_nand2_1
X_3626_ W6END[11] net237 VPWR VGND sg13g2_buf_1
X_2439_ Inst_RegFile_ConfigMem.Inst_frame10_bit30.Q AD0 _0486_ Inst_RegFile_switch_matrix.JS2BEG2
+ _1016_ Inst_RegFile_ConfigMem.Inst_frame10_bit31.Q Inst_RegFile_switch_matrix.W1BEG3
+ VPWR VGND sg13g2_mux4_1
XFILLER_24_185 VPWR VGND sg13g2_fill_2
XANTENNA_70 VPWR VGND N2MID[7] sg13g2_antennanp
XANTENNA_81 VPWR VGND N2MID[7] sg13g2_antennanp
XFILLER_20_380 VPWR VGND sg13g2_fill_1
X_1741_ Inst_RegFile_ConfigMem.Inst_frame2_bit24.Q W1END[3] AD0 AD1 AD2 Inst_RegFile_ConfigMem.Inst_frame2_bit25.Q
+ _0372_ VPWR VGND sg13g2_mux4_1
X_2790_ FrameData[10] FrameStrobe[12] Inst_RegFile_ConfigMem.Inst_frame12_bit10.Q
+ VPWR VGND sg13g2_dlhq_1
XFILLER_30_144 VPWR VGND sg13g2_fill_2
XFILLER_30_100 VPWR VGND sg13g2_fill_1
X_1810_ Inst_RegFile_ConfigMem.Inst_frame8_bit27.Q VPWR _0438_ VGND Inst_RegFile_ConfigMem.Inst_frame6_bit31.Q
+ _0437_ sg13g2_o21ai_1
X_3411_ E2MID[7] net20 VPWR VGND sg13g2_buf_1
X_1672_ VGND VPWR Inst_RegFile_32x4.mem\[23\]\[2\] A_ADR0 _0308_ _0307_ sg13g2_a21oi_1
X_3342_ VPWR VGND _1324_ sg13g2_tiehi
X_3273_ VPWR VGND _1255_ sg13g2_tiehi
X_2224_ Inst_RegFile_ConfigMem.Inst_frame2_bit3.Q VPWR _0827_ VGND _0821_ _0824_ sg13g2_o21ai_1
X_2155_ Inst_RegFile_ConfigMem.Inst_frame4_bit5.Q VPWR _0762_ VGND Inst_RegFile_ConfigMem.Inst_frame4_bit4.Q
+ BD2 sg13g2_o21ai_1
X_2086_ Inst_RegFile_ConfigMem.Inst_frame4_bit8.Q W6END[1] _0697_ VPWR VGND sg13g2_nor2b_1
X_2988_ FrameData[16] FrameStrobe[6] Inst_RegFile_ConfigMem.Inst_frame6_bit16.Q VPWR
+ VGND sg13g2_dlhq_1
X_3609_ W2MID[0] net218 VPWR VGND sg13g2_buf_1
XFILLER_21_155 VPWR VGND sg13g2_fill_2
XFILLER_21_188 VPWR VGND sg13g2_fill_1
X_1939_ Inst_RegFile_32x4.mem\[26\]\[2\] Inst_RegFile_32x4.mem\[27\]\[2\] B_ADR0 _0559_
+ VPWR VGND sg13g2_mux2_1
XFILLER_52_280 VPWR VGND sg13g2_fill_1
XFILLER_40_464 VPWR VGND sg13g2_fill_2
Xclkbuf_4_5_0_UserCLK_regs clknet_0_UserCLK_regs clknet_4_5_0_UserCLK_regs VPWR VGND
+ sg13g2_buf_8
XFILLER_25_483 VPWR VGND sg13g2_fill_2
X_2911_ FrameData[3] FrameStrobe[8] Inst_RegFile_ConfigMem.Inst_frame8_bit3.Q VPWR
+ VGND sg13g2_dlhq_1
X_1724_ _0350_ _0355_ _0356_ VPWR VGND sg13g2_nor2_1
X_2773_ _1288_ VGND VPWR _0067_ Inst_RegFile_32x4.mem\[1\]\[3\] clknet_5_19__leaf_UserCLK_regs
+ sg13g2_dfrbpq_1
X_2842_ FrameData[30] FrameStrobe[11] Inst_RegFile_ConfigMem.Inst_frame11_bit30.Q
+ VPWR VGND sg13g2_dlhq_1
X_3325_ VPWR VGND _1307_ sg13g2_tiehi
X_3256_ VPWR VGND _1238_ sg13g2_tiehi
X_1655_ A_ADR0 Inst_RegFile_32x4.mem\[2\]\[2\] Inst_RegFile_32x4.mem\[3\]\[2\] Inst_RegFile_32x4.mem\[0\]\[2\]
+ Inst_RegFile_32x4.mem\[1\]\[2\] _1210_ _0291_ VPWR VGND sg13g2_mux4_1
X_1586_ _0227_ _0226_ Inst_RegFile_ConfigMem.Inst_frame3_bit27.Q VPWR VGND sg13g2_nand2b_1
X_2069_ VGND VPWR Inst_RegFile_ConfigMem.Inst_frame3_bit8.Q BD1 _0681_ _0680_ sg13g2_a21oi_1
X_2207_ _0810_ VPWR _0811_ VGND Inst_RegFile_ConfigMem.Inst_frame2_bit29.Q _0809_
+ sg13g2_o21ai_1
X_2138_ _0740_ _0745_ Inst_RegFile_ConfigMem.Inst_frame3_bit7.Q _0746_ VPWR VGND sg13g2_nand3_1
X_3187_ FrameData[23] FrameStrobe[0] Inst_RegFile_ConfigMem.Inst_frame0_bit23.Q VPWR
+ VGND sg13g2_dlhq_1
XFILLER_27_40 VPWR VGND sg13g2_fill_1
X_3110_ FrameData[10] FrameStrobe[2] Inst_RegFile_ConfigMem.Inst_frame2_bit10.Q VPWR
+ VGND sg13g2_dlhq_1
Xoutput209 net209 W1BEG[3] VPWR VGND sg13g2_buf_1
X_1440_ Inst_RegFile_ConfigMem.Inst_frame3_bit12.Q N1END[2] N2END[4] N4END[0] E2END[4]
+ Inst_RegFile_ConfigMem.Inst_frame3_bit13.Q _1197_ VPWR VGND sg13g2_mux4_1
X_3041_ FrameData[5] FrameStrobe[4] Inst_RegFile_ConfigMem.Inst_frame4_bit5.Q VPWR
+ VGND sg13g2_dlhq_1
X_2825_ FrameData[13] FrameStrobe[11] Inst_RegFile_ConfigMem.Inst_frame11_bit13.Q
+ VPWR VGND sg13g2_dlhq_1
X_2687_ Inst_RegFile_32x4.mem\[0\]\[0\] _1065_ _1128_ _0112_ VPWR VGND sg13g2_mux2_1
X_1707_ VPWR _0339_ _0338_ VGND sg13g2_inv_1
X_2756_ _1305_ VGND VPWR _0050_ Inst_RegFile_32x4.mem\[14\]\[2\] clknet_5_18__leaf_UserCLK_regs
+ sg13g2_dfrbpq_1
X_1638_ A_ADR0 Inst_RegFile_32x4.mem\[30\]\[1\] Inst_RegFile_32x4.mem\[31\]\[1\] Inst_RegFile_32x4.mem\[28\]\[1\]
+ Inst_RegFile_32x4.mem\[29\]\[1\] _1210_ _0276_ VPWR VGND sg13g2_mux4_1
X_3239_ _1244_ VGND VPWR _0111_ Inst_RegFile_32x4.mem\[8\]\[3\] clknet_5_20__leaf_UserCLK_regs
+ sg13g2_dfrbpq_1
X_3308_ VPWR VGND _1290_ sg13g2_tiehi
X_1569_ Inst_RegFile_ConfigMem.Inst_frame8_bit18.Q Inst_RegFile_switch_matrix.JS2BEG5
+ Inst_RegFile_switch_matrix.JW2BEG5 _0209_ Inst_RegFile_switch_matrix.JN2BEG5 _1146_
+ _0210_ VPWR VGND sg13g2_mux4_1
XFILLER_13_86 VPWR VGND sg13g2_fill_1
XFILLER_54_82 VPWR VGND sg13g2_fill_1
X_3590_ SS4END[14] net190 VPWR VGND sg13g2_buf_1
X_2610_ _1092_ _1103_ _1112_ VPWR VGND sg13g2_and2_1
X_2472_ _1020_ _1025_ _1026_ VPWR VGND sg13g2_and2_1
X_2541_ _1067_ Inst_RegFile_32x4.mem\[25\]\[1\] _1089_ _0005_ VPWR VGND sg13g2_mux2_1
X_1423_ Inst_RegFile_ConfigMem.Inst_frame7_bit19.Q N2MID[2] S2MID[2] E2MID[2] Inst_RegFile_switch_matrix.E2BEG5
+ Inst_RegFile_ConfigMem.Inst_frame7_bit18.Q _1180_ VPWR VGND sg13g2_mux4_1
X_3024_ FrameData[20] FrameStrobe[5] Inst_RegFile_ConfigMem.Inst_frame5_bit20.Q VPWR
+ VGND sg13g2_dlhq_1
Xclkload7 VPWR clkload7/Y clknet_5_29__leaf_UserCLK_regs VGND sg13g2_inv_1
X_2808_ FrameData[28] FrameStrobe[12] Inst_RegFile_ConfigMem.Inst_frame12_bit28.Q
+ VPWR VGND sg13g2_dlhq_1
X_2739_ _1330_ VGND VPWR _0033_ Inst_RegFile_32x4.mem\[13\]\[1\] clknet_5_15__leaf_UserCLK_regs
+ sg13g2_dfrbpq_1
XFILLER_3_419 VPWR VGND sg13g2_fill_1
XFILLER_46_117 VPWR VGND sg13g2_fill_2
XFILLER_39_191 VPWR VGND sg13g2_fill_2
XFILLER_6_224 VPWR VGND sg13g2_fill_1
X_1972_ VGND VPWR Inst_RegFile_ConfigMem.Inst_frame4_bit16.Q AD0 _0590_ _0589_ sg13g2_a21oi_1
X_3642_ Inst_RegFile_switch_matrix.WW4BEG1 net242 VPWR VGND sg13g2_buf_1
X_3573_ S4END[13] net188 VPWR VGND sg13g2_buf_1
XFILLER_46_0 VPWR VGND sg13g2_fill_1
X_2524_ Inst_RegFile_ConfigMem.Inst_frame9_bit27.Q VPWR _1075_ VGND Inst_RegFile_ConfigMem.Inst_frame9_bit26.Q
+ _0935_ sg13g2_o21ai_1
X_2455_ Inst_RegFile_ConfigMem.Inst_frame11_bit2.Q BD0 _0645_ Inst_RegFile_switch_matrix.JN2BEG0
+ _0137_ Inst_RegFile_ConfigMem.Inst_frame11_bit3.Q Inst_RegFile_switch_matrix.E1BEG1
+ VPWR VGND sg13g2_mux4_1
X_1406_ VPWR _1164_ BD1 VGND sg13g2_inv_1
X_2386_ VGND VPWR Inst_RegFile_ConfigMem.Inst_frame11_bit20.Q _0338_ _0973_ _0972_
+ sg13g2_a21oi_1
XFILLER_36_172 VPWR VGND sg13g2_fill_2
X_3007_ FrameData[3] FrameStrobe[5] Inst_RegFile_ConfigMem.Inst_frame5_bit3.Q VPWR
+ VGND sg13g2_dlhq_1
XFILLER_38_404 VPWR VGND sg13g2_fill_1
X_2240_ VGND VPWR Inst_RegFile_ConfigMem.Inst_frame3_bit29.Q _0838_ _0842_ _0841_
+ sg13g2_a21oi_1
X_2171_ _0777_ AD3 Inst_RegFile_ConfigMem.Inst_frame1_bit28.Q VPWR VGND sg13g2_nand2b_1
X_1955_ B_ADR0 Inst_RegFile_32x4.mem\[12\]\[2\] Inst_RegFile_32x4.mem\[13\]\[2\] Inst_RegFile_32x4.mem\[14\]\[2\]
+ Inst_RegFile_32x4.mem\[15\]\[2\] _0368_ _0575_ VPWR VGND sg13g2_mux4_1
X_1886_ Inst_RegFile_32x4.mem\[24\]\[1\] Inst_RegFile_32x4.mem\[25\]\[1\] B_ADR0 _0510_
+ VPWR VGND sg13g2_mux2_1
X_3625_ W6END[10] net236 VPWR VGND sg13g2_buf_1
X_3487_ FrameStrobe[15] net87 VPWR VGND sg13g2_buf_1
X_2438_ Inst_RegFile_ConfigMem.Inst_frame0_bit0.Q NN4END[3] S4END[3] WW4END[0] Inst_RegFile_switch_matrix.JN2BEG1
+ Inst_RegFile_ConfigMem.Inst_frame0_bit1.Q _1016_ VPWR VGND sg13g2_mux4_1
X_2507_ _1048_ _1058_ _1059_ _1061_ VPWR VGND sg13g2_nor3_1
X_3556_ S2MID[0] net165 VPWR VGND sg13g2_buf_1
X_2369_ Inst_RegFile_ConfigMem.Inst_frame11_bit25.Q AD0 AD2 AD1 AD3 Inst_RegFile_ConfigMem.Inst_frame11_bit24.Q
+ _0957_ VPWR VGND sg13g2_mux4_1
Xclkbuf_4_13_0_UserCLK_regs clknet_0_UserCLK_regs clknet_4_13_0_UserCLK_regs VPWR
+ VGND sg13g2_buf_8
XFILLER_12_326 VPWR VGND sg13g2_fill_1
XANTENNA_60 VPWR VGND N2MID[7] sg13g2_antennanp
XANTENNA_71 VPWR VGND N2MID[7] sg13g2_antennanp
XANTENNA_82 VPWR VGND N2MID[7] sg13g2_antennanp
X_1740_ _0371_ _0368_ _0370_ VPWR VGND sg13g2_nand2_1
X_1671_ A_ADR0 Inst_RegFile_32x4.mem\[22\]\[2\] _0307_ VPWR VGND sg13g2_nor2b_1
X_3272_ VPWR VGND _1254_ sg13g2_tiehi
X_3410_ E2MID[6] net19 VPWR VGND sg13g2_buf_1
X_3341_ VPWR VGND _1323_ sg13g2_tiehi
X_2085_ AD1 AD3 Inst_RegFile_ConfigMem.Inst_frame4_bit8.Q _0696_ VPWR VGND sg13g2_mux2_1
XFILLER_38_234 VPWR VGND sg13g2_fill_2
X_2223_ Inst_RegFile_ConfigMem.Inst_frame2_bit2.Q _0825_ _0826_ VPWR VGND sg13g2_nor2_1
X_2154_ _0760_ VPWR _0761_ VGND Inst_RegFile_ConfigMem.Inst_frame4_bit4.Q BD0 sg13g2_o21ai_1
X_2987_ FrameData[15] FrameStrobe[6] Inst_RegFile_ConfigMem.Inst_frame6_bit15.Q VPWR
+ VGND sg13g2_dlhq_1
X_1869_ B_ADR0 Inst_RegFile_32x4.mem\[4\]\[0\] Inst_RegFile_32x4.mem\[5\]\[0\] Inst_RegFile_32x4.mem\[6\]\[0\]
+ Inst_RegFile_32x4.mem\[7\]\[0\] _0368_ _0495_ VPWR VGND sg13g2_mux4_1
X_3608_ Inst_RegFile_switch_matrix.JW2BEG7 net217 VPWR VGND sg13g2_buf_1
X_1938_ VGND VPWR Inst_RegFile_32x4.mem\[25\]\[2\] B_ADR0 _0558_ _0557_ sg13g2_a21oi_1
X_3539_ NN4END[15] net139 VPWR VGND sg13g2_buf_1
XFILLER_8_105 VPWR VGND sg13g2_fill_2
X_2910_ FrameData[2] FrameStrobe[8] Inst_RegFile_ConfigMem.Inst_frame8_bit2.Q VPWR
+ VGND sg13g2_dlhq_1
X_2841_ FrameData[29] FrameStrobe[11] Inst_RegFile_ConfigMem.Inst_frame11_bit29.Q
+ VPWR VGND sg13g2_dlhq_1
X_1723_ _0352_ _0354_ _0355_ VPWR VGND sg13g2_nor2_1
X_2772_ _1289_ VGND VPWR _0066_ Inst_RegFile_32x4.mem\[1\]\[2\] clknet_5_30__leaf_UserCLK_regs
+ sg13g2_dfrbpq_1
X_1654_ VGND VPWR _0142_ _0289_ _0290_ _0186_ sg13g2_a21oi_1
X_1585_ _0224_ _0225_ Inst_RegFile_ConfigMem.Inst_frame3_bit26.Q _0226_ VPWR VGND
+ sg13g2_mux2_1
X_3255_ _1364_ VGND VPWR _0127_ Inst_RegFile_32x4.mem\[12\]\[3\] clknet_5_24__leaf_UserCLK_regs
+ sg13g2_dfrbpq_1
X_2206_ VGND VPWR Inst_RegFile_ConfigMem.Inst_frame2_bit29.Q _0807_ _0810_ Inst_RegFile_ConfigMem.Inst_frame2_bit30.Q
+ sg13g2_a21oi_1
X_3324_ VPWR VGND _1306_ sg13g2_tiehi
XFILLER_53_18 VPWR VGND sg13g2_fill_1
XFILLER_41_207 VPWR VGND sg13g2_fill_2
X_2068_ Inst_RegFile_ConfigMem.Inst_frame3_bit8.Q BD0 _0680_ VPWR VGND sg13g2_nor2b_1
X_2137_ _0742_ _0744_ Inst_RegFile_ConfigMem.Inst_frame3_bit6.Q _0745_ VPWR VGND sg13g2_nand3_1
X_3186_ FrameData[22] FrameStrobe[0] Inst_RegFile_ConfigMem.Inst_frame0_bit22.Q VPWR
+ VGND sg13g2_dlhq_1
XFILLER_22_410 VPWR VGND sg13g2_fill_1
XFILLER_40_273 VPWR VGND sg13g2_fill_2
XFILLER_9_458 VPWR VGND sg13g2_fill_1
XFILLER_4_78 VPWR VGND sg13g2_fill_1
X_3040_ FrameData[4] FrameStrobe[4] Inst_RegFile_ConfigMem.Inst_frame4_bit4.Q VPWR
+ VGND sg13g2_dlhq_1
X_2824_ FrameData[12] FrameStrobe[11] Inst_RegFile_ConfigMem.Inst_frame11_bit12.Q
+ VPWR VGND sg13g2_dlhq_1
XFILLER_31_295 VPWR VGND sg13g2_fill_2
X_2686_ _1061_ _1097_ _1128_ VPWR VGND sg13g2_and2_1
X_2755_ _1306_ VGND VPWR _0049_ Inst_RegFile_32x4.mem\[14\]\[1\] clknet_5_24__leaf_UserCLK_regs
+ sg13g2_dfrbpq_1
X_1637_ _0274_ VPWR _0275_ VGND _1210_ _0273_ sg13g2_o21ai_1
X_1706_ Inst_RegFile_ConfigMem.Inst_frame6_bit26.Q N2MID[3] E2MID[3] S2MID[3] W2MID[3]
+ Inst_RegFile_ConfigMem.Inst_frame6_bit27.Q _0338_ VPWR VGND sg13g2_mux4_1
XFILLER_54_321 VPWR VGND sg13g2_fill_2
X_3238_ _1245_ VGND VPWR _0110_ Inst_RegFile_32x4.mem\[8\]\[2\] clknet_5_22__leaf_UserCLK_regs
+ sg13g2_dfrbpq_1
X_3307_ VPWR VGND _1289_ sg13g2_tiehi
X_3169_ FrameData[5] FrameStrobe[0] Inst_RegFile_ConfigMem.Inst_frame0_bit5.Q VPWR
+ VGND sg13g2_dlhq_1
X_1568_ Inst_RegFile_ConfigMem.Inst_frame5_bit15.Q N2END[0] S2END[0] EE4END[1] W2END[0]
+ Inst_RegFile_ConfigMem.Inst_frame5_bit14.Q _0209_ VPWR VGND sg13g2_mux4_1
X_1499_ _1232_ _1230_ _0141_ _0143_ VPWR VGND sg13g2_a21o_1
X_1422_ _1179_ VPWR Inst_RegFile_switch_matrix.E2BEG5 VGND _1173_ _1175_ sg13g2_o21ai_1
X_2471_ _1024_ VPWR _1025_ VGND _1021_ _1022_ sg13g2_o21ai_1
X_2540_ _1065_ Inst_RegFile_32x4.mem\[25\]\[0\] _1089_ _0004_ VPWR VGND sg13g2_mux2_1
X_3023_ FrameData[19] FrameStrobe[5] Inst_RegFile_ConfigMem.Inst_frame5_bit19.Q VPWR
+ VGND sg13g2_dlhq_1
X_2738_ _1331_ VGND VPWR _0032_ Inst_RegFile_32x4.mem\[13\]\[0\] clknet_5_27__leaf_UserCLK_regs
+ sg13g2_dfrbpq_1
X_2807_ FrameData[27] FrameStrobe[12] Inst_RegFile_ConfigMem.Inst_frame12_bit27.Q
+ VPWR VGND sg13g2_dlhq_1
X_2669_ _1069_ Inst_RegFile_32x4.mem\[5\]\[2\] _1124_ _0098_ VPWR VGND sg13g2_mux2_1
X_3572_ S4END[12] net187 VPWR VGND sg13g2_buf_1
X_1971_ Inst_RegFile_ConfigMem.Inst_frame4_bit16.Q W1END[3] _0589_ VPWR VGND sg13g2_nor2b_1
X_3641_ Inst_RegFile_switch_matrix.WW4BEG0 net241 VPWR VGND sg13g2_buf_1
XFILLER_39_0 VPWR VGND sg13g2_fill_2
X_2385_ Inst_RegFile_ConfigMem.Inst_frame11_bit21.Q VPWR _0972_ VGND Inst_RegFile_ConfigMem.Inst_frame11_bit20.Q
+ _1183_ sg13g2_o21ai_1
X_2523_ VGND VPWR Inst_RegFile_ConfigMem.Inst_frame0_bit7.Q _1070_ _1074_ _1073_ sg13g2_a21oi_1
X_1405_ VPWR _1163_ Inst_RegFile_ConfigMem.Inst_frame8_bit7.Q VGND sg13g2_inv_1
X_2454_ Inst_RegFile_ConfigMem.Inst_frame11_bit4.Q BD1 _0338_ Inst_RegFile_switch_matrix.JN2BEG1
+ _0429_ Inst_RegFile_ConfigMem.Inst_frame11_bit5.Q Inst_RegFile_switch_matrix.E1BEG2
+ VPWR VGND sg13g2_mux4_1
X_3006_ FrameData[2] FrameStrobe[5] Inst_RegFile_ConfigMem.Inst_frame5_bit2.Q VPWR
+ VGND sg13g2_dlhq_1
XFILLER_51_121 VPWR VGND sg13g2_fill_2
XFILLER_15_302 VPWR VGND sg13g2_fill_1
Xclkbuf_5_8__f_UserCLK_regs clknet_4_4_0_UserCLK_regs clknet_5_8__leaf_UserCLK_regs
+ VPWR VGND sg13g2_buf_8
X_2170_ _0776_ Inst_RegFile_ConfigMem.Inst_frame1_bit28.Q BD0 VPWR VGND sg13g2_nand2_1
X_1954_ VGND VPWR _0367_ _0573_ _0574_ _0409_ sg13g2_a21oi_1
X_3555_ Inst_RegFile_switch_matrix.JS2BEG7 net164 VPWR VGND sg13g2_buf_1
X_1885_ Inst_RegFile_32x4.BD_comb\[0\] Inst_RegFile_32x4.BD_reg\[0\] Inst_RegFile_ConfigMem.Inst_frame12_bit3.Q
+ BD0 VPWR VGND sg13g2_mux2_1
X_3624_ W6END[9] net235 VPWR VGND sg13g2_buf_1
X_3486_ FrameStrobe[14] net86 VPWR VGND sg13g2_buf_1
X_2368_ Inst_RegFile_ConfigMem.Inst_frame11_bit25.Q NN4END[3] SS4END[3] E1END[2] W1END[2]
+ Inst_RegFile_ConfigMem.Inst_frame11_bit24.Q _0956_ VPWR VGND sg13g2_mux4_1
X_2437_ VGND VPWR _1009_ _1013_ Inst_RegFile_switch_matrix.NN4BEG0 _1015_ sg13g2_a21oi_1
XFILLER_29_416 VPWR VGND sg13g2_fill_2
X_2506_ VPWR _1060_ _1059_ VGND sg13g2_inv_1
X_2299_ Inst_RegFile_ConfigMem.Inst_frame9_bit16.Q _0896_ _0895_ _1229_ _0388_ Inst_RegFile_ConfigMem.Inst_frame9_bit17.Q
+ _0897_ VPWR VGND sg13g2_mux4_1
XANTENNA_83 VPWR VGND N2MID[7] sg13g2_antennanp
XANTENNA_72 VPWR VGND N2MID[7] sg13g2_antennanp
XANTENNA_61 VPWR VGND N2MID[7] sg13g2_antennanp
XANTENNA_50 VPWR VGND WW4END[6] sg13g2_antennanp
Xoutput190 net190 SS4BEG[10] VPWR VGND sg13g2_buf_1
Xclkbuf_1_0__f_UserCLK clknet_0_UserCLK clknet_1_0__leaf_UserCLK VPWR VGND sg13g2_buf_8
X_1670_ VGND VPWR Inst_RegFile_32x4.mem\[21\]\[2\] A_ADR0 _0306_ _0305_ sg13g2_a21oi_1
X_3271_ VPWR VGND _1253_ sg13g2_tiehi
X_2222_ Inst_RegFile_ConfigMem.Inst_frame2_bit1.Q W6END[1] AD2 AD1 AD3 Inst_RegFile_ConfigMem.Inst_frame2_bit0.Q
+ _0825_ VPWR VGND sg13g2_mux4_1
X_3340_ VPWR VGND _1322_ sg13g2_tiehi
X_2084_ VGND VPWR Inst_RegFile_ConfigMem.Inst_frame4_bit9.Q _0691_ _0695_ _0694_ sg13g2_a21oi_1
X_2153_ VGND VPWR Inst_RegFile_ConfigMem.Inst_frame4_bit4.Q _1164_ _0760_ Inst_RegFile_ConfigMem.Inst_frame4_bit5.Q
+ sg13g2_a21oi_1
X_1937_ B_ADR0 Inst_RegFile_32x4.mem\[24\]\[2\] _0557_ VPWR VGND sg13g2_nor2b_1
X_2986_ FrameData[14] FrameStrobe[6] Inst_RegFile_ConfigMem.Inst_frame6_bit14.Q VPWR
+ VGND sg13g2_dlhq_1
X_1868_ _0494_ _0493_ _0409_ VPWR VGND sg13g2_nand2b_1
X_1799_ _0428_ _0427_ Inst_RegFile_ConfigMem.Inst_frame1_bit19.Q VPWR VGND sg13g2_nand2b_1
X_3607_ Inst_RegFile_switch_matrix.JW2BEG6 net216 VPWR VGND sg13g2_buf_1
X_3538_ NN4END[14] net138 VPWR VGND sg13g2_buf_1
X_3469_ FrameData[29] net70 VPWR VGND sg13g2_buf_1
XFILLER_29_279 VPWR VGND sg13g2_fill_2
XFILLER_25_485 VPWR VGND sg13g2_fill_1
X_2771_ _1290_ VGND VPWR _0065_ Inst_RegFile_32x4.mem\[1\]\[1\] clknet_5_17__leaf_UserCLK_regs
+ sg13g2_dfrbpq_1
XFILLER_31_400 VPWR VGND sg13g2_fill_2
X_2840_ FrameData[28] FrameStrobe[11] Inst_RegFile_ConfigMem.Inst_frame11_bit28.Q
+ VPWR VGND sg13g2_dlhq_1
X_1722_ _1135_ VPWR _0354_ VGND _1134_ _0353_ sg13g2_o21ai_1
X_1653_ A_ADR0 Inst_RegFile_32x4.mem\[14\]\[2\] Inst_RegFile_32x4.mem\[15\]\[2\] Inst_RegFile_32x4.mem\[12\]\[2\]
+ Inst_RegFile_32x4.mem\[13\]\[2\] _1210_ _0289_ VPWR VGND sg13g2_mux4_1
X_1584_ Inst_RegFile_ConfigMem.Inst_frame3_bit24.Q EE4END[1] S1END[1] S1END[3] S2END[7]
+ Inst_RegFile_ConfigMem.Inst_frame3_bit25.Q _0225_ VPWR VGND sg13g2_mux4_1
X_3254_ _1365_ VGND VPWR _0126_ Inst_RegFile_32x4.mem\[12\]\[2\] clknet_5_16__leaf_UserCLK_regs
+ sg13g2_dfrbpq_1
X_3323_ VPWR VGND _1305_ sg13g2_tiehi
X_2205_ VGND VPWR Inst_RegFile_ConfigMem.Inst_frame2_bit28.Q AD0 _0809_ _0808_ sg13g2_a21oi_1
X_3185_ FrameData[21] FrameStrobe[0] Inst_RegFile_ConfigMem.Inst_frame0_bit21.Q VPWR
+ VGND sg13g2_dlhq_1
XFILLER_21_0 VPWR VGND sg13g2_fill_2
X_2067_ VGND VPWR Inst_RegFile_ConfigMem.Inst_frame3_bit8.Q _1165_ _0679_ _0678_ sg13g2_a21oi_1
X_2136_ _1165_ Inst_RegFile_ConfigMem.Inst_frame3_bit4.Q _0743_ _0744_ VPWR VGND sg13g2_a21o_1
X_2969_ FrameData[29] FrameStrobe[7] Inst_RegFile_ConfigMem.Inst_frame7_bit29.Q VPWR
+ VGND sg13g2_dlhq_1
XFILLER_1_315 VPWR VGND sg13g2_fill_1
Xclkbuf_4_1_0_UserCLK_regs clknet_0_UserCLK_regs clknet_4_1_0_UserCLK_regs VPWR VGND
+ sg13g2_buf_8
X_2823_ FrameData[11] FrameStrobe[11] Inst_RegFile_ConfigMem.Inst_frame11_bit11.Q
+ VPWR VGND sg13g2_dlhq_1
X_2754_ _1307_ VGND VPWR _0048_ Inst_RegFile_32x4.mem\[14\]\[0\] clknet_5_24__leaf_UserCLK_regs
+ sg13g2_dfrbpq_1
X_1705_ Inst_RegFile_32x4.AD_comb\[3\] Inst_RegFile_32x4.AD_reg\[3\] Inst_RegFile_ConfigMem.Inst_frame12_bit2.Q
+ AD3 VPWR VGND sg13g2_mux2_1
X_1567_ _0208_ VPWR Inst_RegFile_switch_matrix.JN2BEG5 VGND _0197_ _0204_ sg13g2_o21ai_1
X_2685_ Inst_RegFile_32x4.mem\[8\]\[3\] _1087_ _1127_ _0111_ VPWR VGND sg13g2_mux2_1
X_3306_ VPWR VGND _1288_ sg13g2_tiehi
X_1636_ VGND VPWR _1210_ _0272_ _0274_ _0142_ sg13g2_a21oi_1
X_3237_ _1246_ VGND VPWR _0109_ Inst_RegFile_32x4.mem\[8\]\[1\] clknet_5_21__leaf_UserCLK_regs
+ sg13g2_dfrbpq_1
X_2119_ Inst_RegFile_ConfigMem.Inst_frame2_bit5.Q VPWR _0728_ VGND Inst_RegFile_ConfigMem.Inst_frame2_bit4.Q
+ BD2 sg13g2_o21ai_1
X_3168_ FrameData[4] FrameStrobe[0] Inst_RegFile_ConfigMem.Inst_frame0_bit4.Q VPWR
+ VGND sg13g2_dlhq_1
X_1498_ VGND VPWR _1230_ _1232_ _0142_ _0141_ sg13g2_a21oi_1
X_3099_ FrameData[31] FrameStrobe[3] Inst_RegFile_ConfigMem.Inst_frame3_bit31.Q VPWR
+ VGND sg13g2_dlhq_1
XFILLER_6_418 VPWR VGND sg13g2_fill_1
XFILLER_49_138 VPWR VGND sg13g2_fill_1
XFILLER_9_212 VPWR VGND sg13g2_fill_1
X_1421_ _1179_ _1178_ Inst_RegFile_ConfigMem.Inst_frame3_bit23.Q VPWR VGND sg13g2_nand2b_1
X_2470_ VGND VPWR _1162_ _1023_ _1024_ Inst_RegFile_ConfigMem.Inst_frame8_bit6.Q sg13g2_a21oi_1
X_3022_ FrameData[18] FrameStrobe[5] Inst_RegFile_ConfigMem.Inst_frame5_bit18.Q VPWR
+ VGND sg13g2_dlhq_1
X_2668_ _1067_ Inst_RegFile_32x4.mem\[5\]\[1\] _1124_ _0097_ VPWR VGND sg13g2_mux2_1
X_2737_ _1332_ VGND VPWR _0031_ Inst_RegFile_32x4.mem\[9\]\[3\] clknet_5_20__leaf_UserCLK_regs
+ sg13g2_dfrbpq_1
X_2806_ FrameData[26] FrameStrobe[12] Inst_RegFile_ConfigMem.Inst_frame12_bit26.Q
+ VPWR VGND sg13g2_dlhq_1
X_2599_ _1087_ Inst_RegFile_32x4.mem\[22\]\[3\] _1109_ _0043_ VPWR VGND sg13g2_mux2_1
X_1619_ VGND VPWR _1210_ _0258_ _0259_ _0143_ sg13g2_a21oi_1
XFILLER_46_119 VPWR VGND sg13g2_fill_1
XFILLER_39_193 VPWR VGND sg13g2_fill_1
X_1970_ _0587_ VPWR _0588_ VGND Inst_RegFile_ConfigMem.Inst_frame4_bit16.Q _1167_
+ sg13g2_o21ai_1
X_3571_ S4END[11] net186 VPWR VGND sg13g2_buf_1
X_3640_ WW4END[15] net240 VPWR VGND sg13g2_buf_1
X_2522_ Inst_RegFile_ConfigMem.Inst_frame9_bit26.Q VPWR _1073_ VGND Inst_RegFile_ConfigMem.Inst_frame0_bit7.Q
+ _1072_ sg13g2_o21ai_1
X_2384_ _0911_ _0910_ Inst_RegFile_ConfigMem.Inst_frame11_bit20.Q _0971_ VPWR VGND
+ sg13g2_mux2_1
X_2453_ Inst_RegFile_ConfigMem.Inst_frame11_bit6.Q BD2 _0486_ Inst_RegFile_switch_matrix.JN2BEG2
+ _1016_ Inst_RegFile_ConfigMem.Inst_frame11_bit7.Q Inst_RegFile_switch_matrix.E1BEG3
+ VPWR VGND sg13g2_mux4_1
XFILLER_5_270 VPWR VGND sg13g2_fill_1
X_1404_ VPWR _1162_ Inst_RegFile_ConfigMem.Inst_frame8_bit5.Q VGND sg13g2_inv_1
X_3005_ FrameData[1] FrameStrobe[5] Inst_RegFile_ConfigMem.Inst_frame5_bit1.Q VPWR
+ VGND sg13g2_dlhq_1
XFILLER_28_119 VPWR VGND sg13g2_fill_2
XFILLER_42_133 VPWR VGND sg13g2_fill_1
XFILLER_15_325 VPWR VGND sg13g2_fill_1
X_1953_ VGND VPWR Inst_RegFile_32x4.mem\[9\]\[2\] B_ADR0 _0573_ _0572_ sg13g2_a21oi_1
XFILLER_33_177 VPWR VGND sg13g2_fill_2
X_1884_ _0497_ _0491_ _0509_ Inst_RegFile_32x4.BD_comb\[0\] VPWR VGND sg13g2_a21o_1
XFILLER_51_0 VPWR VGND sg13g2_fill_2
X_3485_ FrameStrobe[13] net85 VPWR VGND sg13g2_buf_1
X_3554_ Inst_RegFile_switch_matrix.JS2BEG6 net163 VPWR VGND sg13g2_buf_1
X_3623_ W6END[8] net234 VPWR VGND sg13g2_buf_1
X_2505_ Inst_RegFile_ConfigMem.Inst_frame9_bit31.Q _1053_ _0997_ _0910_ _1017_ Inst_RegFile_ConfigMem.Inst_frame9_bit30.Q
+ _1059_ VPWR VGND sg13g2_mux4_1
X_2436_ Inst_RegFile_ConfigMem.Inst_frame12_bit22.Q _1014_ _1015_ VPWR VGND sg13g2_nor2_1
X_2298_ Inst_RegFile_ConfigMem.Inst_frame7_bit5.Q N2MID[4] W2MID[4] E2MID[4] Inst_RegFile_switch_matrix.JS2BEG3
+ Inst_RegFile_ConfigMem.Inst_frame7_bit4.Q _0896_ VPWR VGND sg13g2_mux4_1
X_2367_ VGND VPWR _0949_ _0953_ Inst_RegFile_switch_matrix.SS4BEG0 _0955_ sg13g2_a21oi_1
XFILLER_52_464 VPWR VGND sg13g2_fill_1
XANTENNA_84 VPWR VGND N2MID[7] sg13g2_antennanp
XANTENNA_73 VPWR VGND N2MID[7] sg13g2_antennanp
XANTENNA_62 VPWR VGND N2MID[7] sg13g2_antennanp
XANTENNA_51 VPWR VGND WW4END[7] sg13g2_antennanp
XANTENNA_40 VPWR VGND WW4END[10] sg13g2_antennanp
XFILLER_20_361 VPWR VGND sg13g2_fill_1
Xoutput180 net180 S4BEG[1] VPWR VGND sg13g2_buf_1
Xoutput191 net191 SS4BEG[11] VPWR VGND sg13g2_buf_1
XFILLER_11_350 VPWR VGND sg13g2_fill_2
XFILLER_15_177 VPWR VGND sg13g2_fill_2
XFILLER_7_398 VPWR VGND sg13g2_fill_1
X_3270_ VPWR VGND _1252_ sg13g2_tiehi
X_2221_ _0824_ Inst_RegFile_ConfigMem.Inst_frame2_bit2.Q _0823_ VPWR VGND sg13g2_nand2_1
X_2152_ VPWR VGND _0758_ Inst_RegFile_ConfigMem.Inst_frame4_bit6.Q _0757_ Inst_RegFile_ConfigMem.Inst_frame4_bit5.Q
+ _0759_ _0756_ sg13g2_a221oi_1
X_2083_ Inst_RegFile_ConfigMem.Inst_frame4_bit10.Q VPWR _0694_ VGND Inst_RegFile_ConfigMem.Inst_frame4_bit9.Q
+ _0693_ sg13g2_o21ai_1
X_1867_ B_ADR0 Inst_RegFile_32x4.mem\[0\]\[0\] Inst_RegFile_32x4.mem\[1\]\[0\] Inst_RegFile_32x4.mem\[2\]\[0\]
+ Inst_RegFile_32x4.mem\[3\]\[0\] _0368_ _0493_ VPWR VGND sg13g2_mux4_1
X_1936_ Inst_RegFile_32x4.BD_comb\[3\] Inst_RegFile_32x4.BD_reg\[3\] Inst_RegFile_ConfigMem.Inst_frame12_bit3.Q
+ BD3 VPWR VGND sg13g2_mux2_1
X_2985_ FrameData[13] FrameStrobe[6] Inst_RegFile_ConfigMem.Inst_frame6_bit13.Q VPWR
+ VGND sg13g2_dlhq_1
X_3468_ FrameData[28] net69 VPWR VGND sg13g2_buf_1
X_1798_ _0425_ _0426_ Inst_RegFile_ConfigMem.Inst_frame1_bit18.Q _0427_ VPWR VGND
+ sg13g2_mux2_1
X_3537_ NN4END[13] net152 VPWR VGND sg13g2_buf_1
X_3606_ Inst_RegFile_switch_matrix.JW2BEG5 net215 VPWR VGND sg13g2_buf_1
X_2419_ Inst_RegFile_ConfigMem.Inst_frame12_bit26.Q _1165_ _1000_ VPWR VGND sg13g2_nor2_1
XFILLER_29_214 VPWR VGND sg13g2_fill_2
X_3399_ Inst_RegFile_switch_matrix.E2BEG3 net8 VPWR VGND sg13g2_buf_1
XFILLER_52_250 VPWR VGND sg13g2_fill_2
XFILLER_32_21 VPWR VGND sg13g2_fill_2
XFILLER_16_88 VPWR VGND sg13g2_fill_1
X_1721_ Inst_RegFile_ConfigMem.Inst_frame3_bit16.Q EE4END[3] S1END[1] S1END[3] S2END[5]
+ Inst_RegFile_ConfigMem.Inst_frame3_bit17.Q _0353_ VPWR VGND sg13g2_mux4_1
X_2770_ _1291_ VGND VPWR _0064_ Inst_RegFile_32x4.mem\[1\]\[0\] clknet_5_27__leaf_UserCLK_regs
+ sg13g2_dfrbpq_1
X_1652_ _0288_ _0143_ _0287_ VPWR VGND sg13g2_nand2_1
X_1583_ Inst_RegFile_ConfigMem.Inst_frame3_bit24.Q N1END[3] N2END[7] E1END[3] E2END[7]
+ Inst_RegFile_ConfigMem.Inst_frame3_bit25.Q _0224_ VPWR VGND sg13g2_mux4_1
X_3322_ VPWR VGND _1304_ sg13g2_tiehi
X_3253_ _1366_ VGND VPWR _0125_ Inst_RegFile_32x4.mem\[12\]\[1\] clknet_5_24__leaf_UserCLK_regs
+ sg13g2_dfrbpq_1
X_2204_ Inst_RegFile_ConfigMem.Inst_frame2_bit28.Q W1END[2] _0808_ VPWR VGND sg13g2_nor2b_1
X_2135_ Inst_RegFile_ConfigMem.Inst_frame3_bit5.Q VPWR _0743_ VGND Inst_RegFile_ConfigMem.Inst_frame3_bit4.Q
+ BD2 sg13g2_o21ai_1
X_3184_ FrameData[20] FrameStrobe[0] Inst_RegFile_ConfigMem.Inst_frame0_bit20.Q VPWR
+ VGND sg13g2_dlhq_1
XFILLER_14_0 VPWR VGND sg13g2_fill_1
XFILLER_41_209 VPWR VGND sg13g2_fill_1
X_2066_ Inst_RegFile_ConfigMem.Inst_frame3_bit9.Q VPWR _0678_ VGND Inst_RegFile_ConfigMem.Inst_frame3_bit8.Q
+ BD2 sg13g2_o21ai_1
X_2899_ FrameData[23] FrameStrobe[9] Inst_RegFile_ConfigMem.Inst_frame9_bit23.Q VPWR
+ VGND sg13g2_dlhq_1
X_1919_ B_ADR0 Inst_RegFile_32x4.mem\[20\]\[3\] Inst_RegFile_32x4.mem\[21\]\[3\] Inst_RegFile_32x4.mem\[22\]\[3\]
+ Inst_RegFile_32x4.mem\[23\]\[3\] _0368_ _0541_ VPWR VGND sg13g2_mux4_1
X_2968_ FrameData[28] FrameStrobe[7] Inst_RegFile_ConfigMem.Inst_frame7_bit28.Q VPWR
+ VGND sg13g2_dlhq_1
XFILLER_40_275 VPWR VGND sg13g2_fill_1
XFILLER_40_220 VPWR VGND sg13g2_fill_2
XFILLER_48_364 VPWR VGND sg13g2_fill_2
XFILLER_16_272 VPWR VGND sg13g2_fill_2
X_2684_ Inst_RegFile_32x4.mem\[8\]\[2\] _1069_ _1127_ _0110_ VPWR VGND sg13g2_mux2_1
X_2822_ FrameData[10] FrameStrobe[11] Inst_RegFile_ConfigMem.Inst_frame11_bit10.Q
+ VPWR VGND sg13g2_dlhq_1
XFILLER_31_297 VPWR VGND sg13g2_fill_1
X_1704_ _0337_ _0236_ _0321_ Inst_RegFile_32x4.AD_comb\[3\] VPWR VGND sg13g2_a21o_1
X_2753_ _1308_ VGND VPWR _0047_ Inst_RegFile_32x4.mem\[23\]\[3\] clknet_5_10__leaf_UserCLK_regs
+ sg13g2_dfrbpq_1
X_1566_ _0208_ _0207_ Inst_RegFile_ConfigMem.Inst_frame4_bit23.Q VPWR VGND sg13g2_nand2b_1
X_1497_ VGND VPWR Inst_RegFile_ConfigMem.Inst_frame8_bit14.Q _0137_ _0141_ _0140_
+ sg13g2_a21oi_1
X_1635_ Inst_RegFile_32x4.mem\[26\]\[1\] Inst_RegFile_32x4.mem\[27\]\[1\] A_ADR0 _0273_
+ VPWR VGND sg13g2_mux2_1
X_3305_ VPWR VGND _1287_ sg13g2_tiehi
XFILLER_54_367 VPWR VGND sg13g2_fill_2
X_3236_ _1247_ VGND VPWR _0108_ Inst_RegFile_32x4.mem\[8\]\[0\] clknet_5_22__leaf_UserCLK_regs
+ sg13g2_dfrbpq_1
X_2049_ BD3 Inst_RegFile_ConfigMem.Inst_frame2_bit8.Q _0662_ VPWR VGND sg13g2_nor2b_1
X_3167_ FrameData[3] FrameStrobe[0] Inst_RegFile_ConfigMem.Inst_frame0_bit3.Q VPWR
+ VGND sg13g2_dlhq_1
X_3098_ FrameData[30] FrameStrobe[3] Inst_RegFile_ConfigMem.Inst_frame3_bit30.Q VPWR
+ VGND sg13g2_dlhq_1
X_2118_ VPWR VGND _0726_ Inst_RegFile_ConfigMem.Inst_frame2_bit6.Q _0725_ Inst_RegFile_ConfigMem.Inst_frame2_bit5.Q
+ _0727_ _0724_ sg13g2_a221oi_1
XFILLER_13_23 VPWR VGND sg13g2_fill_1
X_1420_ _1176_ _1177_ _1141_ _1178_ VPWR VGND sg13g2_mux2_1
X_3021_ FrameData[17] FrameStrobe[5] Inst_RegFile_ConfigMem.Inst_frame5_bit17.Q VPWR
+ VGND sg13g2_dlhq_1
X_2805_ FrameData[25] FrameStrobe[12] Inst_RegFile_ConfigMem.Inst_frame12_bit25.Q
+ VPWR VGND sg13g2_dlhq_1
X_2667_ _1065_ Inst_RegFile_32x4.mem\[5\]\[0\] _1124_ _0096_ VPWR VGND sg13g2_mux2_1
X_2736_ _1333_ VGND VPWR _0030_ Inst_RegFile_32x4.mem\[9\]\[2\] clknet_5_28__leaf_UserCLK_regs
+ sg13g2_dfrbpq_1
X_1618_ VGND VPWR Inst_RegFile_32x4.mem\[21\]\[0\] A_ADR0 _0258_ _0257_ sg13g2_a21oi_1
X_3219_ _1264_ VGND VPWR _0091_ Inst_RegFile_32x4.mem\[3\]\[3\] clknet_5_27__leaf_UserCLK_regs
+ sg13g2_dfrbpq_1
X_1549_ _0190_ VPWR _0191_ VGND _1210_ _0187_ sg13g2_o21ai_1
XFILLER_5_90 VPWR VGND sg13g2_fill_2
Xclkbuf_5_3__f_UserCLK_regs clknet_4_1_0_UserCLK_regs clknet_5_3__leaf_UserCLK_regs
+ VPWR VGND sg13g2_buf_8
X_2598_ _1069_ Inst_RegFile_32x4.mem\[22\]\[2\] _1109_ _0042_ VPWR VGND sg13g2_mux2_1
XFILLER_2_477 VPWR VGND sg13g2_fill_1
Xclkbuf_regs_0_UserCLK UserCLK UserCLK_regs VPWR VGND sg13g2_buf_8
X_3570_ S4END[10] net185 VPWR VGND sg13g2_buf_1
X_2521_ VGND VPWR E6END[0] Inst_RegFile_ConfigMem.Inst_frame0_bit6.Q _1072_ _1071_
+ sg13g2_a21oi_1
X_2383_ VGND VPWR _0968_ _0969_ _0970_ _0964_ sg13g2_a21oi_1
X_1403_ VPWR _1161_ Inst_RegFile_ConfigMem.Inst_frame8_bit4.Q VGND sg13g2_inv_1
X_2452_ Inst_RegFile_ConfigMem.Inst_frame11_bit29.Q BD0 Inst_RegFile_switch_matrix.E2BEG3
+ _1018_ _1017_ Inst_RegFile_ConfigMem.Inst_frame11_bit28.Q Inst_RegFile_switch_matrix.S1BEG0
+ VPWR VGND sg13g2_mux4_1
X_3004_ FrameData[0] FrameStrobe[5] Inst_RegFile_ConfigMem.Inst_frame5_bit0.Q VPWR
+ VGND sg13g2_dlhq_1
Xclkbuf_5_18__f_UserCLK_regs clknet_4_9_0_UserCLK_regs clknet_5_18__leaf_UserCLK_regs
+ VPWR VGND sg13g2_buf_8
X_2719_ _1350_ VGND VPWR _0013_ Inst_RegFile_32x4.mem\[27\]\[1\] clknet_5_4__leaf_UserCLK_regs
+ sg13g2_dfrbpq_1
XFILLER_42_189 VPWR VGND sg13g2_fill_2
XFILLER_46_484 VPWR VGND sg13g2_fill_2
XFILLER_33_101 VPWR VGND sg13g2_fill_1
X_1952_ B_ADR0 Inst_RegFile_32x4.mem\[8\]\[2\] _0572_ VPWR VGND sg13g2_nor2b_1
X_3622_ W6END[7] net233 VPWR VGND sg13g2_buf_1
X_1883_ VPWR VGND _0508_ _0491_ _0506_ _0502_ _0509_ _0504_ sg13g2_a221oi_1
XFILLER_21_307 VPWR VGND sg13g2_fill_1
X_3484_ FrameStrobe[12] net84 VPWR VGND sg13g2_buf_1
X_2435_ Inst_RegFile_ConfigMem.Inst_frame12_bit20.Q N1END[2] E1END[2] W1END[2] AD1
+ Inst_RegFile_ConfigMem.Inst_frame12_bit21.Q _1014_ VPWR VGND sg13g2_mux4_1
XFILLER_44_0 VPWR VGND sg13g2_fill_2
X_3553_ Inst_RegFile_switch_matrix.JS2BEG5 net162 VPWR VGND sg13g2_buf_1
X_2504_ Inst_RegFile_ConfigMem.Inst_frame8_bit8.Q _1057_ _1055_ _1052_ _1050_ Inst_RegFile_ConfigMem.Inst_frame8_bit9.Q
+ _1058_ VPWR VGND sg13g2_mux4_1
X_2366_ Inst_RegFile_ConfigMem.Inst_frame10_bit14.Q _0954_ _0955_ VPWR VGND sg13g2_nor2_1
X_2297_ Inst_RegFile_ConfigMem.Inst_frame7_bit13.Q N2MID[4] S2MID[4] E2MID[4] Inst_RegFile_switch_matrix.JS2BEG4
+ Inst_RegFile_ConfigMem.Inst_frame7_bit12.Q _0895_ VPWR VGND sg13g2_mux4_1
XFILLER_24_145 VPWR VGND sg13g2_fill_2
XANTENNA_74 VPWR VGND N2MID[7] sg13g2_antennanp
XANTENNA_63 VPWR VGND N2MID[7] sg13g2_antennanp
XANTENNA_52 VPWR VGND WW4END[8] sg13g2_antennanp
XANTENNA_85 VPWR VGND S4END[5] sg13g2_antennanp
XANTENNA_41 VPWR VGND WW4END[12] sg13g2_antennanp
XANTENNA_30 VPWR VGND W6END[10] sg13g2_antennanp
XFILLER_21_45 VPWR VGND sg13g2_fill_2
Xoutput181 net181 S4BEG[2] VPWR VGND sg13g2_buf_1
Xoutput170 net170 S2BEGb[5] VPWR VGND sg13g2_buf_1
Xoutput192 net192 SS4BEG[12] VPWR VGND sg13g2_buf_1
XFILLER_28_484 VPWR VGND sg13g2_fill_2
XFILLER_15_101 VPWR VGND sg13g2_fill_1
X_2082_ VGND VPWR Inst_RegFile_ConfigMem.Inst_frame4_bit8.Q BD1 _0693_ _0692_ sg13g2_a21oi_1
X_2220_ _0822_ VPWR _0823_ VGND Inst_RegFile_ConfigMem.Inst_frame2_bit0.Q BD0 sg13g2_o21ai_1
X_2151_ VGND VPWR Inst_RegFile_ConfigMem.Inst_frame4_bit4.Q _1166_ _0758_ Inst_RegFile_ConfigMem.Inst_frame4_bit5.Q
+ sg13g2_a21oi_1
XFILLER_53_218 VPWR VGND sg13g2_fill_2
X_2984_ FrameData[12] FrameStrobe[6] Inst_RegFile_ConfigMem.Inst_frame6_bit12.Q VPWR
+ VGND sg13g2_dlhq_1
X_1797_ Inst_RegFile_ConfigMem.Inst_frame1_bit17.Q S1END[1] S2END[5] S1END[3] W1END[1]
+ Inst_RegFile_ConfigMem.Inst_frame1_bit16.Q _0426_ VPWR VGND sg13g2_mux4_1
X_3605_ Inst_RegFile_switch_matrix.JW2BEG4 net214 VPWR VGND sg13g2_buf_1
X_1935_ _0556_ _0491_ _0543_ Inst_RegFile_32x4.BD_comb\[3\] VPWR VGND sg13g2_a21o_1
X_1866_ _0483_ Inst_RegFile_ConfigMem.Inst_frame8_bit31.Q _0490_ _0492_ VPWR VGND
+ sg13g2_a21o_1
X_2418_ VGND VPWR _1159_ _0339_ _0999_ _0998_ sg13g2_a21oi_1
X_3467_ FrameData[27] net68 VPWR VGND sg13g2_buf_1
X_3536_ NN4END[12] net151 VPWR VGND sg13g2_buf_1
X_3398_ Inst_RegFile_switch_matrix.E2BEG2 net7 VPWR VGND sg13g2_buf_1
X_2349_ Inst_RegFile_ConfigMem.Inst_frame10_bit18.Q _1165_ _0940_ VPWR VGND sg13g2_nor2_1
X_1720_ Inst_RegFile_ConfigMem.Inst_frame3_bit18.Q _0351_ _0352_ VPWR VGND sg13g2_nor2_1
X_1651_ A_ADR0 Inst_RegFile_32x4.mem\[10\]\[2\] Inst_RegFile_32x4.mem\[11\]\[2\] Inst_RegFile_32x4.mem\[8\]\[2\]
+ Inst_RegFile_32x4.mem\[9\]\[2\] _1210_ _0287_ VPWR VGND sg13g2_mux4_1
XFILLER_7_174 VPWR VGND sg13g2_fill_2
XFILLER_11_192 VPWR VGND sg13g2_fill_2
X_3321_ VPWR VGND _1303_ sg13g2_tiehi
X_3252_ _1367_ VGND VPWR _0124_ Inst_RegFile_32x4.mem\[12\]\[0\] clknet_5_25__leaf_UserCLK_regs
+ sg13g2_dfrbpq_1
X_1582_ Inst_RegFile_ConfigMem.Inst_frame3_bit27.Q VPWR _0223_ VGND _0219_ _0222_
+ sg13g2_o21ai_1
X_2065_ _0677_ VPWR Inst_RegFile_switch_matrix.JS2BEG2 VGND _0672_ _0673_ sg13g2_o21ai_1
X_3183_ FrameData[19] FrameStrobe[0] Inst_RegFile_ConfigMem.Inst_frame0_bit19.Q VPWR
+ VGND sg13g2_dlhq_1
XFILLER_26_207 VPWR VGND sg13g2_fill_2
X_2134_ _0741_ VPWR _0742_ VGND Inst_RegFile_ConfigMem.Inst_frame3_bit4.Q BD0 sg13g2_o21ai_1
X_2203_ AD1 AD2 Inst_RegFile_ConfigMem.Inst_frame2_bit28.Q _0807_ VPWR VGND sg13g2_mux2_1
X_2967_ FrameData[27] FrameStrobe[7] Inst_RegFile_ConfigMem.Inst_frame7_bit27.Q VPWR
+ VGND sg13g2_dlhq_1
X_1849_ Inst_RegFile_ConfigMem.Inst_frame4_bit24.Q N1END[3] N2END[7] NN4END[1] E1END[3]
+ Inst_RegFile_ConfigMem.Inst_frame4_bit25.Q _0476_ VPWR VGND sg13g2_mux4_1
X_2898_ FrameData[22] FrameStrobe[9] Inst_RegFile_ConfigMem.Inst_frame9_bit22.Q VPWR
+ VGND sg13g2_dlhq_1
X_1918_ _0540_ _0539_ _0409_ VPWR VGND sg13g2_nand2b_1
X_3519_ N4END[11] net134 VPWR VGND sg13g2_buf_1
XFILLER_9_428 VPWR VGND sg13g2_fill_2
XFILLER_4_15 VPWR VGND sg13g2_fill_2
X_2821_ FrameData[9] FrameStrobe[11] Inst_RegFile_ConfigMem.Inst_frame11_bit9.Q VPWR
+ VGND sg13g2_dlhq_1
X_2683_ Inst_RegFile_32x4.mem\[8\]\[1\] _1067_ _1127_ _0109_ VPWR VGND sg13g2_mux2_1
X_2752_ _1309_ VGND VPWR _0046_ Inst_RegFile_32x4.mem\[23\]\[2\] clknet_5_8__leaf_UserCLK_regs
+ sg13g2_dfrbpq_1
X_1634_ VGND VPWR Inst_RegFile_32x4.mem\[25\]\[1\] A_ADR0 _0272_ _0271_ sg13g2_a21oi_1
X_1703_ _0337_ _0336_ _0186_ _0328_ _0326_ VPWR VGND sg13g2_a22oi_1
X_3235_ _1248_ VGND VPWR _0107_ Inst_RegFile_32x4.mem\[7\]\[3\] clknet_5_28__leaf_UserCLK_regs
+ sg13g2_dfrbpq_1
X_1565_ _0206_ _0205_ Inst_RegFile_ConfigMem.Inst_frame4_bit22.Q _0207_ VPWR VGND
+ sg13g2_mux2_1
X_1496_ Inst_RegFile_ConfigMem.Inst_frame8_bit15.Q VPWR _0140_ VGND Inst_RegFile_ConfigMem.Inst_frame8_bit14.Q
+ _0139_ sg13g2_o21ai_1
X_3304_ VPWR VGND _1286_ sg13g2_tiehi
X_2048_ _0654_ VPWR Inst_RegFile_switch_matrix.JW2BEG2 VGND Inst_RegFile_ConfigMem.Inst_frame1_bit11.Q
+ _0661_ sg13g2_o21ai_1
X_3166_ FrameData[2] FrameStrobe[0] Inst_RegFile_ConfigMem.Inst_frame0_bit2.Q VPWR
+ VGND sg13g2_dlhq_1
X_3097_ FrameData[29] FrameStrobe[3] Inst_RegFile_ConfigMem.Inst_frame3_bit29.Q VPWR
+ VGND sg13g2_dlhq_1
X_2117_ VGND VPWR Inst_RegFile_ConfigMem.Inst_frame2_bit4.Q _1166_ _0726_ Inst_RegFile_ConfigMem.Inst_frame2_bit5.Q
+ sg13g2_a21oi_1
XFILLER_10_438 VPWR VGND sg13g2_fill_2
XFILLER_45_379 VPWR VGND sg13g2_fill_2
XFILLER_45_357 VPWR VGND sg13g2_fill_2
X_3020_ FrameData[16] FrameStrobe[5] Inst_RegFile_ConfigMem.Inst_frame5_bit16.Q VPWR
+ VGND sg13g2_dlhq_1
Xclkbuf_5_26__f_UserCLK_regs clknet_4_13_0_UserCLK_regs clknet_5_26__leaf_UserCLK_regs
+ VPWR VGND sg13g2_buf_8
X_2804_ FrameData[24] FrameStrobe[12] Inst_RegFile_ConfigMem.Inst_frame12_bit24.Q
+ VPWR VGND sg13g2_dlhq_1
X_2666_ _1124_ _1088_ _1122_ VPWR VGND sg13g2_nand2_1
X_2735_ _1334_ VGND VPWR _0029_ Inst_RegFile_32x4.mem\[9\]\[1\] clknet_5_20__leaf_UserCLK_regs
+ sg13g2_dfrbpq_1
X_1617_ A_ADR0 Inst_RegFile_32x4.mem\[20\]\[0\] _0257_ VPWR VGND sg13g2_nor2b_1
X_2597_ _1067_ Inst_RegFile_32x4.mem\[22\]\[1\] _1109_ _0041_ VPWR VGND sg13g2_mux2_1
X_3218_ _1265_ VGND VPWR _0090_ Inst_RegFile_32x4.mem\[3\]\[2\] clknet_5_30__leaf_UserCLK_regs
+ sg13g2_dfrbpq_1
X_1548_ VGND VPWR _1210_ _0189_ _0190_ _0143_ sg13g2_a21oi_1
X_3149_ FrameData[17] FrameStrobe[1] Inst_RegFile_ConfigMem.Inst_frame1_bit17.Q VPWR
+ VGND sg13g2_dlhq_1
X_1479_ Inst_RegFile_ConfigMem.Inst_frame2_bit14.Q _1233_ _1234_ VPWR VGND sg13g2_nor2_1
XFILLER_40_55 VPWR VGND sg13g2_fill_1
Xclkbuf_0_UserCLK_regs UserCLK_regs clknet_0_UserCLK_regs VPWR VGND sg13g2_buf_8
XFILLER_10_213 VPWR VGND sg13g2_fill_2
X_1402_ VPWR _1160_ Inst_RegFile_ConfigMem.Inst_frame12_bit21.Q VGND sg13g2_inv_1
X_2520_ Inst_RegFile_ConfigMem.Inst_frame0_bit6.Q N4END[0] _1071_ VPWR VGND sg13g2_nor2b_1
X_2451_ Inst_RegFile_ConfigMem.Inst_frame11_bit30.Q BD1 _0645_ Inst_RegFile_switch_matrix.E2BEG0
+ _0137_ Inst_RegFile_ConfigMem.Inst_frame11_bit31.Q Inst_RegFile_switch_matrix.S1BEG1
+ VPWR VGND sg13g2_mux4_1
X_2382_ VGND VPWR Inst_RegFile_ConfigMem.Inst_frame11_bit21.Q _0966_ _0969_ _1156_
+ sg13g2_a21oi_1
X_3003_ FrameData[31] FrameStrobe[6] Inst_RegFile_ConfigMem.Inst_frame6_bit31.Q VPWR
+ VGND sg13g2_dlhq_1
X_2718_ _1351_ VGND VPWR _0012_ Inst_RegFile_32x4.mem\[27\]\[0\] clknet_5_6__leaf_UserCLK_regs
+ sg13g2_dfrbpq_1
X_2649_ _1087_ Inst_RegFile_32x4.mem\[29\]\[3\] _1119_ _0083_ VPWR VGND sg13g2_mux2_1
XFILLER_27_121 VPWR VGND sg13g2_decap_4
XFILLER_19_34 VPWR VGND sg13g2_fill_2
XFILLER_4_0 VPWR VGND sg13g2_fill_1
XFILLER_33_124 VPWR VGND sg13g2_fill_2
X_1951_ _0571_ _0368_ _0570_ VPWR VGND sg13g2_nand2_1
X_3552_ Inst_RegFile_switch_matrix.JS2BEG4 net161 VPWR VGND sg13g2_buf_1
X_1882_ VGND VPWR _0409_ _0507_ _0508_ _0460_ sg13g2_a21oi_1
X_3621_ W6END[6] net232 VPWR VGND sg13g2_buf_1
X_3483_ FrameStrobe[11] net83 VPWR VGND sg13g2_buf_1
X_2434_ VPWR _1013_ _1012_ VGND sg13g2_inv_1
XFILLER_37_0 VPWR VGND sg13g2_fill_2
X_2503_ _1056_ VPWR _1057_ VGND N2END[3] Inst_RegFile_ConfigMem.Inst_frame8_bit7.Q
+ sg13g2_o21ai_1
X_2365_ Inst_RegFile_ConfigMem.Inst_frame10_bit12.Q N1END[2] E1END[2] W1END[2] AD1
+ Inst_RegFile_ConfigMem.Inst_frame10_bit13.Q _0954_ VPWR VGND sg13g2_mux4_1
X_2296_ Inst_RegFile_ConfigMem.Inst_frame9_bit17.Q AD0 AD2 AD1 AD3 Inst_RegFile_ConfigMem.Inst_frame9_bit16.Q
+ _0894_ VPWR VGND sg13g2_mux4_1
XFILLER_52_477 VPWR VGND sg13g2_fill_2
XANTENNA_20 VPWR VGND W2END[3] sg13g2_antennanp
XANTENNA_31 VPWR VGND W6END[11] sg13g2_antennanp
XANTENNA_64 VPWR VGND N2MID[7] sg13g2_antennanp
XANTENNA_75 VPWR VGND N2MID[7] sg13g2_antennanp
XANTENNA_42 VPWR VGND WW4END[13] sg13g2_antennanp
XANTENNA_53 VPWR VGND WW4END[9] sg13g2_antennanp
XANTENNA_86 VPWR VGND WW4END[11] sg13g2_antennanp
Xoutput171 net171 S2BEGb[6] VPWR VGND sg13g2_buf_1
Xoutput182 net182 S4BEG[3] VPWR VGND sg13g2_buf_1
Xoutput160 net160 S2BEG[3] VPWR VGND sg13g2_buf_1
Xoutput193 net193 SS4BEG[13] VPWR VGND sg13g2_buf_1
XFILLER_15_179 VPWR VGND sg13g2_fill_1
X_2081_ Inst_RegFile_ConfigMem.Inst_frame4_bit8.Q BD0 _0692_ VPWR VGND sg13g2_nor2b_1
X_2150_ VGND VPWR _0757_ Inst_RegFile_ConfigMem.Inst_frame4_bit4.Q W6END[0] sg13g2_or2_1
XFILLER_46_293 VPWR VGND sg13g2_fill_2
X_1934_ _0556_ _0553_ _0555_ _0551_ _0460_ VPWR VGND sg13g2_a22oi_1
XFILLER_19_485 VPWR VGND sg13g2_fill_1
X_2983_ FrameData[11] FrameStrobe[6] Inst_RegFile_ConfigMem.Inst_frame6_bit11.Q VPWR
+ VGND sg13g2_dlhq_1
X_1796_ Inst_RegFile_ConfigMem.Inst_frame1_bit16.Q N1END[1] N2END[5] E1END[1] E2END[5]
+ Inst_RegFile_ConfigMem.Inst_frame1_bit17.Q _0425_ VPWR VGND sg13g2_mux4_1
X_3604_ Inst_RegFile_switch_matrix.JW2BEG3 net213 VPWR VGND sg13g2_buf_1
X_3535_ NN4END[11] net150 VPWR VGND sg13g2_buf_1
X_1865_ VGND VPWR Inst_RegFile_ConfigMem.Inst_frame8_bit31.Q _0483_ _0491_ _0490_
+ sg13g2_a21oi_1
X_3466_ FrameData[26] net67 VPWR VGND sg13g2_buf_1
X_2417_ Inst_RegFile_ConfigMem.Inst_frame12_bit27.Q VPWR _0998_ VGND _1159_ _0997_
+ sg13g2_o21ai_1
X_2348_ VGND VPWR _1154_ _0339_ _0939_ _0938_ sg13g2_a21oi_1
X_3397_ Inst_RegFile_switch_matrix.E2BEG1 net6 VPWR VGND sg13g2_buf_1
XFILLER_37_260 VPWR VGND sg13g2_fill_2
X_2279_ AD2 AD3 Inst_RegFile_ConfigMem.Inst_frame4_bit0.Q _0878_ VPWR VGND sg13g2_mux2_1
XFILLER_40_414 VPWR VGND sg13g2_fill_2
XFILLER_28_260 VPWR VGND sg13g2_fill_1
X_1581_ Inst_RegFile_ConfigMem.Inst_frame3_bit26.Q VPWR _0222_ VGND _0220_ _0221_
+ sg13g2_o21ai_1
X_1650_ Inst_RegFile_32x4.AD_comb\[1\] Inst_RegFile_32x4.AD_reg\[1\] Inst_RegFile_ConfigMem.Inst_frame12_bit2.Q
+ AD1 VPWR VGND sg13g2_mux2_1
XFILLER_7_142 VPWR VGND sg13g2_fill_1
X_3251_ _1368_ VGND VPWR _0123_ Inst_RegFile_32x4.mem\[11\]\[3\] clknet_5_20__leaf_UserCLK_regs
+ sg13g2_dfrbpq_1
X_3320_ VPWR VGND _1302_ sg13g2_tiehi
X_3182_ FrameData[18] FrameStrobe[0] Inst_RegFile_ConfigMem.Inst_frame0_bit18.Q VPWR
+ VGND sg13g2_dlhq_1
X_2202_ _0805_ VPWR _0806_ VGND _1149_ _0803_ sg13g2_o21ai_1
X_2064_ _0677_ _0676_ Inst_RegFile_ConfigMem.Inst_frame2_bit11.Q VPWR VGND sg13g2_nand2b_1
XFILLER_26_219 VPWR VGND sg13g2_fill_1
X_2133_ VGND VPWR Inst_RegFile_ConfigMem.Inst_frame3_bit4.Q _1164_ _0741_ Inst_RegFile_ConfigMem.Inst_frame3_bit5.Q
+ sg13g2_a21oi_1
X_2897_ FrameData[21] FrameStrobe[9] Inst_RegFile_ConfigMem.Inst_frame9_bit21.Q VPWR
+ VGND sg13g2_dlhq_1
X_2966_ FrameData[26] FrameStrobe[7] Inst_RegFile_ConfigMem.Inst_frame7_bit26.Q VPWR
+ VGND sg13g2_dlhq_1
X_1917_ B_ADR0 Inst_RegFile_32x4.mem\[16\]\[3\] Inst_RegFile_32x4.mem\[17\]\[3\] Inst_RegFile_32x4.mem\[18\]\[3\]
+ Inst_RegFile_32x4.mem\[19\]\[3\] _0368_ _0539_ VPWR VGND sg13g2_mux4_1
X_1848_ _0468_ _0474_ Inst_RegFile_ConfigMem.Inst_frame4_bit27.Q _0475_ VPWR VGND
+ sg13g2_nand3_1
X_3518_ N4END[10] net133 VPWR VGND sg13g2_buf_1
X_1779_ Inst_RegFile_ConfigMem.Inst_frame5_bit28.Q NN4END[1] E2END[5] S2END[5] W2END[5]
+ Inst_RegFile_ConfigMem.Inst_frame5_bit29.Q _0408_ VPWR VGND sg13g2_mux4_1
X_3449_ FrameData[9] net80 VPWR VGND sg13g2_buf_1
XFILLER_27_12 VPWR VGND sg13g2_fill_1
XFILLER_13_458 VPWR VGND sg13g2_fill_1
XFILLER_48_388 VPWR VGND sg13g2_fill_2
XFILLER_48_366 VPWR VGND sg13g2_fill_1
XFILLER_16_230 VPWR VGND sg13g2_fill_1
X_2820_ FrameData[8] FrameStrobe[11] Inst_RegFile_ConfigMem.Inst_frame11_bit8.Q VPWR
+ VGND sg13g2_dlhq_1
X_2751_ _1310_ VGND VPWR _0045_ Inst_RegFile_32x4.mem\[23\]\[1\] clknet_5_8__leaf_UserCLK_regs
+ sg13g2_dfrbpq_1
X_1564_ Inst_RegFile_ConfigMem.Inst_frame4_bit21.Q N1END[2] NN4END[2] N2END[6] E1END[2]
+ Inst_RegFile_ConfigMem.Inst_frame4_bit20.Q _0206_ VPWR VGND sg13g2_mux4_1
X_2682_ Inst_RegFile_32x4.mem\[8\]\[0\] _1065_ _1127_ _0108_ VPWR VGND sg13g2_mux2_1
X_1702_ _0336_ _0334_ _0335_ _0329_ _0143_ VPWR VGND sg13g2_a22oi_1
X_1633_ A_ADR0 Inst_RegFile_32x4.mem\[24\]\[1\] _0271_ VPWR VGND sg13g2_nor2b_1
X_3234_ _1249_ VGND VPWR _0106_ Inst_RegFile_32x4.mem\[7\]\[2\] clknet_5_30__leaf_UserCLK_regs
+ sg13g2_dfrbpq_1
X_3165_ FrameData[1] FrameStrobe[0] Inst_RegFile_ConfigMem.Inst_frame0_bit1.Q VPWR
+ VGND sg13g2_dlhq_1
X_1495_ VPWR _0139_ _0138_ VGND sg13g2_inv_1
X_3303_ VPWR VGND _1285_ sg13g2_tiehi
XFILLER_54_369 VPWR VGND sg13g2_fill_1
X_2047_ _0660_ VPWR _0661_ VGND Inst_RegFile_ConfigMem.Inst_frame1_bit10.Q _0655_
+ sg13g2_o21ai_1
X_3096_ FrameData[28] FrameStrobe[3] Inst_RegFile_ConfigMem.Inst_frame3_bit28.Q VPWR
+ VGND sg13g2_dlhq_1
X_2116_ VGND VPWR _0725_ Inst_RegFile_ConfigMem.Inst_frame2_bit4.Q W6END[0] sg13g2_or2_1
X_2949_ FrameData[9] FrameStrobe[7] Inst_RegFile_ConfigMem.Inst_frame7_bit9.Q VPWR
+ VGND sg13g2_dlhq_1
XFILLER_13_266 VPWR VGND sg13g2_fill_1
Xclkbuf_5_13__f_UserCLK_regs clknet_4_6_0_UserCLK_regs clknet_5_13__leaf_UserCLK_regs
+ VPWR VGND sg13g2_buf_8
XFILLER_44_391 VPWR VGND sg13g2_fill_1
X_2803_ FrameData[23] FrameStrobe[12] Inst_RegFile_ConfigMem.Inst_frame12_bit23.Q
+ VPWR VGND sg13g2_dlhq_1
X_2734_ _1335_ VGND VPWR _0028_ Inst_RegFile_32x4.mem\[9\]\[0\] clknet_5_28__leaf_UserCLK_regs
+ sg13g2_dfrbpq_1
X_2665_ Inst_RegFile_32x4.mem\[4\]\[3\] _1087_ _1123_ _0095_ VPWR VGND sg13g2_mux2_1
X_1547_ _0188_ VPWR _0189_ VGND Inst_RegFile_32x4.mem\[12\]\[0\] A_ADR0 sg13g2_o21ai_1
XFILLER_5_92 VPWR VGND sg13g2_fill_1
X_2596_ _1065_ Inst_RegFile_32x4.mem\[22\]\[0\] _1109_ _0040_ VPWR VGND sg13g2_mux2_1
X_1616_ Inst_RegFile_32x4.mem\[22\]\[0\] Inst_RegFile_32x4.mem\[23\]\[0\] A_ADR0 _0256_
+ VPWR VGND sg13g2_mux2_1
X_3217_ _1266_ VGND VPWR _0089_ Inst_RegFile_32x4.mem\[3\]\[1\] clknet_5_17__leaf_UserCLK_regs
+ sg13g2_dfrbpq_1
X_3148_ FrameData[16] FrameStrobe[1] Inst_RegFile_ConfigMem.Inst_frame1_bit16.Q VPWR
+ VGND sg13g2_dlhq_1
X_1478_ Inst_RegFile_ConfigMem.Inst_frame2_bit12.Q W6END[0] AD0 AD1 AD2 Inst_RegFile_ConfigMem.Inst_frame2_bit13.Q
+ _1233_ VPWR VGND sg13g2_mux4_1
X_3079_ FrameData[11] FrameStrobe[3] Inst_RegFile_ConfigMem.Inst_frame3_bit11.Q VPWR
+ VGND sg13g2_dlhq_1
XFILLER_2_468 VPWR VGND sg13g2_fill_1
XFILLER_41_350 VPWR VGND sg13g2_fill_1
X_2381_ _0967_ VPWR _0968_ VGND Inst_RegFile_ConfigMem.Inst_frame11_bit20.Q _1166_
+ sg13g2_o21ai_1
X_1401_ VPWR _1159_ Inst_RegFile_ConfigMem.Inst_frame12_bit26.Q VGND sg13g2_inv_1
X_2450_ Inst_RegFile_ConfigMem.Inst_frame10_bit0.Q BD2 _0338_ Inst_RegFile_switch_matrix.E2BEG1
+ _0429_ Inst_RegFile_ConfigMem.Inst_frame10_bit1.Q Inst_RegFile_switch_matrix.S1BEG2
+ VPWR VGND sg13g2_mux4_1
X_3002_ FrameData[30] FrameStrobe[6] Inst_RegFile_ConfigMem.Inst_frame6_bit30.Q VPWR
+ VGND sg13g2_dlhq_1
X_2717_ _1352_ VGND VPWR _0011_ Inst_RegFile_32x4.mem\[26\]\[3\] clknet_5_6__leaf_UserCLK_regs
+ sg13g2_dfrbpq_1
X_2579_ _1069_ Inst_RegFile_32x4.mem\[9\]\[2\] _1102_ _0030_ VPWR VGND sg13g2_mux2_1
X_2648_ _1069_ Inst_RegFile_32x4.mem\[29\]\[2\] _1119_ _0082_ VPWR VGND sg13g2_mux2_1
X_1950_ VGND VPWR Inst_RegFile_32x4.mem\[11\]\[2\] B_ADR0 _0570_ _0569_ sg13g2_a21oi_1
X_3551_ Inst_RegFile_switch_matrix.JS2BEG3 net160 VPWR VGND sg13g2_buf_1
X_1881_ B_ADR0 Inst_RegFile_32x4.mem\[20\]\[0\] Inst_RegFile_32x4.mem\[21\]\[0\] Inst_RegFile_32x4.mem\[22\]\[0\]
+ Inst_RegFile_32x4.mem\[23\]\[0\] _0368_ _0507_ VPWR VGND sg13g2_mux4_1
X_3620_ W6END[5] net231 VPWR VGND sg13g2_buf_1
X_2502_ _1056_ Inst_RegFile_ConfigMem.Inst_frame8_bit7.Q S2END[3] VPWR VGND sg13g2_nand2b_1
X_2433_ Inst_RegFile_ConfigMem.Inst_frame12_bit22.Q VPWR _1012_ VGND Inst_RegFile_ConfigMem.Inst_frame12_bit21.Q
+ _1011_ sg13g2_o21ai_1
X_3482_ FrameStrobe[10] net82 VPWR VGND sg13g2_buf_1
X_2364_ VPWR _0953_ _0952_ VGND sg13g2_inv_1
XFILLER_52_401 VPWR VGND sg13g2_fill_1
X_2295_ Inst_RegFile_ConfigMem.Inst_frame9_bit16.Q NN4END[2] E1END[2] SS4END[2] W1END[2]
+ Inst_RegFile_ConfigMem.Inst_frame9_bit17.Q _0893_ VPWR VGND sg13g2_mux4_1
XANTENNA_54 VPWR VGND EE4END[10] sg13g2_antennanp
XANTENNA_10 VPWR VGND FrameStrobe[13] sg13g2_antennanp
XANTENNA_21 VPWR VGND W2END[3] sg13g2_antennanp
XANTENNA_65 VPWR VGND N2MID[7] sg13g2_antennanp
XANTENNA_43 VPWR VGND WW4END[14] sg13g2_antennanp
XANTENNA_32 VPWR VGND W6END[2] sg13g2_antennanp
Xoutput150 net150 NN4BEG[7] VPWR VGND sg13g2_buf_1
XANTENNA_76 VPWR VGND N2MID[7] sg13g2_antennanp
XANTENNA_87 VPWR VGND S4END[6] sg13g2_antennanp
Xoutput161 net161 S2BEG[4] VPWR VGND sg13g2_buf_1
XFILLER_21_47 VPWR VGND sg13g2_fill_1
Xoutput172 net172 S2BEGb[7] VPWR VGND sg13g2_buf_1
Xoutput183 net183 S4BEG[4] VPWR VGND sg13g2_buf_1
Xoutput194 net194 SS4BEG[14] VPWR VGND sg13g2_buf_1
X_2080_ BD2 BD3 Inst_RegFile_ConfigMem.Inst_frame4_bit8.Q _0691_ VPWR VGND sg13g2_mux2_1
X_1933_ VGND VPWR _0409_ _0554_ _0555_ _0460_ sg13g2_a21oi_1
X_2982_ FrameData[10] FrameStrobe[6] Inst_RegFile_ConfigMem.Inst_frame6_bit10.Q VPWR
+ VGND sg13g2_dlhq_1
X_3465_ FrameData[25] net66 VPWR VGND sg13g2_buf_1
X_1795_ Inst_RegFile_ConfigMem.Inst_frame1_bit19.Q VPWR _0424_ VGND _0420_ _0423_
+ sg13g2_o21ai_1
X_3534_ NN4END[10] net149 VPWR VGND sg13g2_buf_1
X_3603_ Inst_RegFile_switch_matrix.JW2BEG2 net212 VPWR VGND sg13g2_buf_1
X_1864_ VPWR VGND _1140_ Inst_RegFile_ConfigMem.Inst_frame8_bit31.Q _0489_ _0485_
+ _0490_ _0487_ sg13g2_a221oi_1
X_2278_ _0877_ VPWR Inst_RegFile_switch_matrix.JN2BEG7 VGND _0869_ _0871_ sg13g2_o21ai_1
X_2347_ Inst_RegFile_ConfigMem.Inst_frame10_bit19.Q VPWR _0938_ VGND _1154_ _0209_
+ sg13g2_o21ai_1
X_3396_ Inst_RegFile_switch_matrix.E2BEG0 net5 VPWR VGND sg13g2_buf_1
X_2416_ Inst_RegFile_ConfigMem.Inst_frame5_bit11.Q N2END[2] S2END[2] E2END[2] WW4END[2]
+ Inst_RegFile_ConfigMem.Inst_frame5_bit10.Q _0997_ VPWR VGND sg13g2_mux4_1
XFILLER_37_283 VPWR VGND sg13g2_fill_1
X_1580_ Inst_RegFile_ConfigMem.Inst_frame3_bit25.Q VPWR _0221_ VGND Inst_RegFile_ConfigMem.Inst_frame3_bit24.Q
+ BD1 sg13g2_o21ai_1
X_3250_ _1369_ VGND VPWR _0122_ Inst_RegFile_32x4.mem\[11\]\[2\] clknet_5_22__leaf_UserCLK_regs
+ sg13g2_dfrbpq_1
X_3181_ FrameData[17] FrameStrobe[0] Inst_RegFile_ConfigMem.Inst_frame0_bit17.Q VPWR
+ VGND sg13g2_dlhq_1
X_2132_ VGND VPWR _0740_ _0739_ Inst_RegFile_ConfigMem.Inst_frame3_bit6.Q sg13g2_or2_1
X_2201_ VGND VPWR _1149_ _0804_ _0805_ _1150_ sg13g2_a21oi_1
X_2063_ _0674_ _0675_ Inst_RegFile_ConfigMem.Inst_frame2_bit10.Q _0676_ VPWR VGND
+ sg13g2_mux2_1
X_1847_ _0473_ VPWR _0474_ VGND Inst_RegFile_ConfigMem.Inst_frame4_bit25.Q _0470_
+ sg13g2_o21ai_1
X_2965_ FrameData[25] FrameStrobe[7] Inst_RegFile_ConfigMem.Inst_frame7_bit25.Q VPWR
+ VGND sg13g2_dlhq_1
X_2896_ FrameData[20] FrameStrobe[9] Inst_RegFile_ConfigMem.Inst_frame9_bit20.Q VPWR
+ VGND sg13g2_dlhq_1
X_1916_ VGND VPWR _0409_ _0537_ _0538_ _0459_ sg13g2_a21oi_1
X_3448_ FrameData[8] net79 VPWR VGND sg13g2_buf_1
X_3517_ N4END[9] net132 VPWR VGND sg13g2_buf_1
X_1778_ Inst_RegFile_ConfigMem.Inst_frame0_bit28.Q E6END[1] S4END[1] WW4END[3] Inst_RegFile_switch_matrix.JS2BEG4
+ Inst_RegFile_ConfigMem.Inst_frame0_bit29.Q _0407_ VPWR VGND sg13g2_mux4_1
Xclkbuf_5_21__f_UserCLK_regs clknet_4_10_0_UserCLK_regs clknet_5_21__leaf_UserCLK_regs
+ VPWR VGND sg13g2_buf_8
X_3379_ VPWR VGND _1361_ sg13g2_tiehi
XFILLER_25_220 VPWR VGND sg13g2_fill_2
XFILLER_4_168 VPWR VGND sg13g2_fill_2
XFILLER_4_39 VPWR VGND sg13g2_fill_2
X_2681_ _1061_ _1101_ _1127_ VPWR VGND sg13g2_and2_1
X_1701_ VGND VPWR _1210_ _0331_ _0335_ _0143_ sg13g2_a21oi_1
X_2750_ _1311_ VGND VPWR _0044_ Inst_RegFile_32x4.mem\[23\]\[0\] clknet_5_11__leaf_UserCLK_regs
+ sg13g2_dfrbpq_1
X_1563_ Inst_RegFile_ConfigMem.Inst_frame4_bit20.Q E2END[6] S1END[2] S2END[6] W1END[0]
+ Inst_RegFile_ConfigMem.Inst_frame4_bit21.Q _0205_ VPWR VGND sg13g2_mux4_1
X_1632_ VPWR VGND _0269_ _0236_ _0267_ _0263_ _0270_ _0265_ sg13g2_a221oi_1
X_1494_ Inst_RegFile_ConfigMem.Inst_frame5_bit20.Q N2END[5] E2END[5] SS4END[1] W2END[5]
+ Inst_RegFile_ConfigMem.Inst_frame5_bit21.Q _0138_ VPWR VGND sg13g2_mux4_1
X_3302_ VPWR VGND _1284_ sg13g2_tiehi
X_3233_ _1250_ VGND VPWR _0105_ Inst_RegFile_32x4.mem\[7\]\[1\] clknet_5_23__leaf_UserCLK_regs
+ sg13g2_dfrbpq_1
X_3164_ FrameData[0] FrameStrobe[0] Inst_RegFile_ConfigMem.Inst_frame0_bit0.Q VPWR
+ VGND sg13g2_dlhq_1
X_3095_ FrameData[27] FrameStrobe[3] Inst_RegFile_ConfigMem.Inst_frame3_bit27.Q VPWR
+ VGND sg13g2_dlhq_1
X_2115_ AD2 AD3 Inst_RegFile_ConfigMem.Inst_frame2_bit4.Q _0724_ VPWR VGND sg13g2_mux2_1
X_2046_ _0659_ VPWR _0660_ VGND Inst_RegFile_ConfigMem.Inst_frame1_bit9.Q _0658_ sg13g2_o21ai_1
XFILLER_22_212 VPWR VGND sg13g2_fill_2
X_2948_ FrameData[8] FrameStrobe[7] Inst_RegFile_ConfigMem.Inst_frame7_bit8.Q VPWR
+ VGND sg13g2_dlhq_1
X_2879_ FrameData[3] FrameStrobe[9] Inst_RegFile_ConfigMem.Inst_frame9_bit3.Q VPWR
+ VGND sg13g2_dlhq_1
XFILLER_54_88 VPWR VGND sg13g2_fill_1
XFILLER_13_234 VPWR VGND sg13g2_fill_2
XFILLER_36_304 VPWR VGND sg13g2_fill_1
XFILLER_51_307 VPWR VGND sg13g2_fill_1
X_2802_ FrameData[22] FrameStrobe[12] Inst_RegFile_ConfigMem.Inst_frame12_bit22.Q
+ VPWR VGND sg13g2_dlhq_1
X_2664_ Inst_RegFile_32x4.mem\[4\]\[2\] _1069_ _1123_ _0094_ VPWR VGND sg13g2_mux2_1
X_2733_ _1336_ VGND VPWR _0027_ Inst_RegFile_32x4.mem\[30\]\[3\] clknet_5_11__leaf_UserCLK_regs
+ sg13g2_dfrbpq_1
X_1546_ _0188_ A_ADR0 Inst_RegFile_32x4.mem\[13\]\[0\] VPWR VGND sg13g2_nand2b_1
X_2595_ _1109_ _1090_ _1108_ VPWR VGND sg13g2_nand2_1
X_1477_ VGND VPWR Inst_RegFile_ConfigMem.Inst_frame8_bit14.Q _1231_ _1232_ Inst_RegFile_ConfigMem.Inst_frame8_bit15.Q
+ sg13g2_a21oi_1
X_1615_ VPWR VGND _0254_ _0142_ _0253_ _1210_ _0255_ _0252_ sg13g2_a221oi_1
X_3078_ FrameData[10] FrameStrobe[3] Inst_RegFile_ConfigMem.Inst_frame3_bit10.Q VPWR
+ VGND sg13g2_dlhq_1
X_3216_ _1267_ VGND VPWR _0088_ Inst_RegFile_32x4.mem\[3\]\[0\] clknet_5_27__leaf_UserCLK_regs
+ sg13g2_dfrbpq_1
X_3147_ FrameData[15] FrameStrobe[1] Inst_RegFile_ConfigMem.Inst_frame1_bit15.Q VPWR
+ VGND sg13g2_dlhq_1
X_2029_ _0644_ _0643_ Inst_RegFile_ConfigMem.Inst_frame8_bit10.Q VPWR VGND sg13g2_nand2b_1
XFILLER_6_208 VPWR VGND sg13g2_fill_1
XFILLER_10_215 VPWR VGND sg13g2_fill_1
XFILLER_24_25 VPWR VGND sg13g2_fill_2
X_2380_ VGND VPWR Inst_RegFile_ConfigMem.Inst_frame11_bit20.Q AD1 _0967_ Inst_RegFile_ConfigMem.Inst_frame11_bit21.Q
+ sg13g2_a21oi_1
X_1400_ VPWR _1158_ Inst_RegFile_ConfigMem.Inst_frame11_bit14.Q VGND sg13g2_inv_1
X_3001_ FrameData[29] FrameStrobe[6] Inst_RegFile_ConfigMem.Inst_frame6_bit29.Q VPWR
+ VGND sg13g2_dlhq_1
X_2647_ _1067_ Inst_RegFile_32x4.mem\[29\]\[1\] _1119_ _0081_ VPWR VGND sg13g2_mux2_1
X_2716_ _1353_ VGND VPWR _0010_ Inst_RegFile_32x4.mem\[26\]\[2\] clknet_5_7__leaf_UserCLK_regs
+ sg13g2_dfrbpq_1
X_1529_ AD3 BD0 Inst_RegFile_ConfigMem.Inst_frame1_bit20.Q _0172_ VPWR VGND sg13g2_mux2_1
X_2578_ _1067_ Inst_RegFile_32x4.mem\[9\]\[1\] _1102_ _0029_ VPWR VGND sg13g2_mux2_1
XFILLER_33_126 VPWR VGND sg13g2_fill_1
X_1880_ _0506_ _0505_ _0409_ VPWR VGND sg13g2_nand2b_1
X_3481_ FrameStrobe[9] net100 VPWR VGND sg13g2_buf_1
X_3550_ Inst_RegFile_switch_matrix.JS2BEG2 net159 VPWR VGND sg13g2_buf_1
X_2501_ VGND VPWR _1163_ _1053_ _1055_ _1054_ sg13g2_a21oi_1
X_2432_ VGND VPWR Inst_RegFile_ConfigMem.Inst_frame12_bit20.Q _0911_ _1011_ _1010_
+ sg13g2_a21oi_1
X_2294_ _0888_ VPWR Inst_RegFile_switch_matrix.JN2BEG0 VGND Inst_RegFile_ConfigMem.Inst_frame4_bit3.Q
+ _0892_ sg13g2_o21ai_1
X_2363_ Inst_RegFile_ConfigMem.Inst_frame10_bit14.Q VPWR _0952_ VGND Inst_RegFile_ConfigMem.Inst_frame10_bit13.Q
+ _0951_ sg13g2_o21ai_1
XANTENNA_11 VPWR VGND FrameStrobe[14] sg13g2_antennanp
XANTENNA_55 VPWR VGND N2MID[0] sg13g2_antennanp
XANTENNA_22 VPWR VGND W2END[3] sg13g2_antennanp
XANTENNA_66 VPWR VGND N2MID[7] sg13g2_antennanp
XFILLER_32_170 VPWR VGND sg13g2_fill_2
XANTENNA_77 VPWR VGND N2MID[7] sg13g2_antennanp
XANTENNA_33 VPWR VGND W6END[3] sg13g2_antennanp
XANTENNA_44 VPWR VGND WW4END[15] sg13g2_antennanp
XFILLER_20_343 VPWR VGND sg13g2_fill_1
Xoutput151 net151 NN4BEG[8] VPWR VGND sg13g2_buf_1
Xoutput140 net140 NN4BEG[12] VPWR VGND sg13g2_buf_1
Xoutput184 net184 S4BEG[5] VPWR VGND sg13g2_buf_1
Xoutput173 net173 S4BEG[0] VPWR VGND sg13g2_buf_1
Xoutput162 net162 S2BEG[5] VPWR VGND sg13g2_buf_1
Xoutput195 net195 SS4BEG[15] VPWR VGND sg13g2_buf_1
XFILLER_46_89 VPWR VGND sg13g2_fill_1
XFILLER_43_413 VPWR VGND sg13g2_fill_1
XFILLER_11_321 VPWR VGND sg13g2_fill_2
XFILLER_7_325 VPWR VGND sg13g2_fill_1
X_1932_ B_ADR0 Inst_RegFile_32x4.mem\[4\]\[3\] Inst_RegFile_32x4.mem\[5\]\[3\] Inst_RegFile_32x4.mem\[6\]\[3\]
+ Inst_RegFile_32x4.mem\[7\]\[3\] _0368_ _0554_ VPWR VGND sg13g2_mux4_1
X_2981_ FrameData[9] FrameStrobe[6] Inst_RegFile_ConfigMem.Inst_frame6_bit9.Q VPWR
+ VGND sg13g2_dlhq_1
X_1863_ VGND VPWR S2END[2] Inst_RegFile_ConfigMem.Inst_frame8_bit29.Q _0489_ _0488_
+ sg13g2_a21oi_1
X_3602_ Inst_RegFile_switch_matrix.JW2BEG1 net211 VPWR VGND sg13g2_buf_1
X_3464_ FrameData[24] net65 VPWR VGND sg13g2_buf_1
X_2415_ _0996_ _0995_ Inst_RegFile_ConfigMem.Inst_frame12_bit31.Q Inst_RegFile_switch_matrix.NN4BEG3
+ VPWR VGND sg13g2_mux2_1
XFILLER_42_0 VPWR VGND sg13g2_fill_2
X_1794_ Inst_RegFile_ConfigMem.Inst_frame1_bit18.Q VPWR _0423_ VGND _0421_ _0422_
+ sg13g2_o21ai_1
X_3533_ NN4END[9] net148 VPWR VGND sg13g2_buf_1
X_3395_ Inst_RegFile_switch_matrix.E1BEG3 net4 VPWR VGND sg13g2_buf_1
X_2277_ _0877_ _0876_ Inst_RegFile_ConfigMem.Inst_frame4_bit31.Q VPWR VGND sg13g2_nand2b_1
X_2346_ _0937_ _0936_ Inst_RegFile_ConfigMem.Inst_frame10_bit23.Q Inst_RegFile_switch_matrix.SS4BEG3
+ VPWR VGND sg13g2_mux2_1
XFILLER_40_416 VPWR VGND sg13g2_fill_1
XFILLER_12_107 VPWR VGND sg13g2_fill_1
XFILLER_25_468 VPWR VGND sg13g2_fill_2
X_3180_ FrameData[16] FrameStrobe[0] Inst_RegFile_ConfigMem.Inst_frame0_bit16.Q VPWR
+ VGND sg13g2_dlhq_1
X_2062_ Inst_RegFile_ConfigMem.Inst_frame2_bit8.Q E6END[1] S2END[3] S4END[3] W2END[3]
+ Inst_RegFile_ConfigMem.Inst_frame2_bit9.Q _0675_ VPWR VGND sg13g2_mux4_1
X_2200_ AD3 BD0 Inst_RegFile_ConfigMem.Inst_frame2_bit28.Q _0804_ VPWR VGND sg13g2_mux2_1
X_2131_ Inst_RegFile_ConfigMem.Inst_frame3_bit4.Q W6END[0] AD0 AD2 AD3 Inst_RegFile_ConfigMem.Inst_frame3_bit5.Q
+ _0739_ VPWR VGND sg13g2_mux4_1
X_2964_ FrameData[24] FrameStrobe[7] Inst_RegFile_ConfigMem.Inst_frame7_bit24.Q VPWR
+ VGND sg13g2_dlhq_1
XFILLER_34_221 VPWR VGND sg13g2_fill_1
X_1846_ VGND VPWR Inst_RegFile_ConfigMem.Inst_frame4_bit25.Q _0472_ _0473_ _1132_
+ sg13g2_a21oi_1
X_1777_ _0406_ VPWR Inst_RegFile_switch_matrix.JS2BEG4 VGND _0395_ _0402_ sg13g2_o21ai_1
X_2895_ FrameData[19] FrameStrobe[9] Inst_RegFile_ConfigMem.Inst_frame9_bit19.Q VPWR
+ VGND sg13g2_dlhq_1
X_1915_ B_ADR0 Inst_RegFile_32x4.mem\[28\]\[3\] Inst_RegFile_32x4.mem\[29\]\[3\] Inst_RegFile_32x4.mem\[30\]\[3\]
+ Inst_RegFile_32x4.mem\[31\]\[3\] _0368_ _0537_ VPWR VGND sg13g2_mux4_1
X_3447_ FrameData[7] net78 VPWR VGND sg13g2_buf_1
X_3516_ N4END[8] net131 VPWR VGND sg13g2_buf_1
X_3378_ VPWR VGND _1360_ sg13g2_tiehi
X_2329_ VGND VPWR _1153_ _0339_ _0924_ _0923_ sg13g2_a21oi_1
X_2680_ _1087_ Inst_RegFile_32x4.mem\[7\]\[3\] _1126_ _0107_ VPWR VGND sg13g2_mux2_1
X_1631_ VGND VPWR _0142_ _0268_ _0269_ _0185_ sg13g2_a21oi_1
X_1700_ _0334_ _0333_ _1210_ VPWR VGND sg13g2_nand2b_1
X_1562_ Inst_RegFile_ConfigMem.Inst_frame4_bit23.Q VPWR _0204_ VGND _0200_ _0203_
+ sg13g2_o21ai_1
X_3232_ _1251_ VGND VPWR _0104_ Inst_RegFile_32x4.mem\[7\]\[0\] clknet_5_31__leaf_UserCLK_regs
+ sg13g2_dfrbpq_1
X_1493_ Inst_RegFile_ConfigMem.Inst_frame0_bit21.Q N4END[1] W2END[4] SS4END[1] Inst_RegFile_switch_matrix.JS2BEG3
+ Inst_RegFile_ConfigMem.Inst_frame0_bit20.Q _0137_ VPWR VGND sg13g2_mux4_1
X_3301_ VPWR VGND _1283_ sg13g2_tiehi
X_2045_ VGND VPWR Inst_RegFile_ConfigMem.Inst_frame1_bit9.Q _0656_ _0659_ _1147_ sg13g2_a21oi_1
X_3094_ FrameData[26] FrameStrobe[3] Inst_RegFile_ConfigMem.Inst_frame3_bit26.Q VPWR
+ VGND sg13g2_dlhq_1
X_2114_ _0719_ VPWR Inst_RegFile_switch_matrix.JW2BEG1 VGND Inst_RegFile_ConfigMem.Inst_frame1_bit7.Q
+ _0723_ sg13g2_o21ai_1
X_3163_ FrameData[31] FrameStrobe[1] Inst_RegFile_ConfigMem.Inst_frame1_bit31.Q VPWR
+ VGND sg13g2_dlhq_1
X_2947_ FrameData[7] FrameStrobe[7] Inst_RegFile_ConfigMem.Inst_frame7_bit7.Q VPWR
+ VGND sg13g2_dlhq_1
X_1829_ VGND VPWR N2MID[0] _1137_ _0456_ Inst_RegFile_ConfigMem.Inst_frame7_bit31.Q
+ sg13g2_a21oi_1
X_2878_ FrameData[2] FrameStrobe[9] Inst_RegFile_ConfigMem.Inst_frame9_bit2.Q VPWR
+ VGND sg13g2_dlhq_1
Xclkbuf_4_8_0_UserCLK_regs clknet_0_UserCLK_regs clknet_4_8_0_UserCLK_regs VPWR VGND
+ sg13g2_buf_8
XFILLER_53_382 VPWR VGND sg13g2_fill_1
X_2801_ FrameData[21] FrameStrobe[12] Inst_RegFile_ConfigMem.Inst_frame12_bit21.Q
+ VPWR VGND sg13g2_dlhq_1
X_2663_ Inst_RegFile_32x4.mem\[4\]\[1\] _1067_ _1123_ _0093_ VPWR VGND sg13g2_mux2_1
X_1614_ VGND VPWR Inst_RegFile_32x4.mem\[19\]\[0\] A_ADR0 _0254_ _1210_ sg13g2_a21oi_1
X_2594_ _1105_ _1033_ _1108_ VPWR VGND sg13g2_nor2b_1
X_2732_ _1337_ VGND VPWR _0026_ Inst_RegFile_32x4.mem\[30\]\[2\] clknet_5_12__leaf_UserCLK_regs
+ sg13g2_dfrbpq_1
X_1545_ Inst_RegFile_32x4.mem\[14\]\[0\] Inst_RegFile_32x4.mem\[15\]\[0\] A_ADR0 _0187_
+ VPWR VGND sg13g2_mux2_1
X_1476_ Inst_RegFile_ConfigMem.Inst_frame6_bit20.Q N2MID[5] E2MID[5] S2MID[5] W2MID[5]
+ Inst_RegFile_ConfigMem.Inst_frame6_bit21.Q _1231_ VPWR VGND sg13g2_mux4_1
X_3215_ _1268_ VGND VPWR _0087_ Inst_RegFile_32x4.mem\[31\]\[3\] clknet_5_14__leaf_UserCLK_regs
+ sg13g2_dfrbpq_1
X_3077_ FrameData[9] FrameStrobe[3] Inst_RegFile_ConfigMem.Inst_frame3_bit9.Q VPWR
+ VGND sg13g2_dlhq_1
X_2028_ Inst_RegFile_ConfigMem.Inst_frame7_bit16.Q N2MID[6] E2MID[6] W2MID[6] Inst_RegFile_switch_matrix.JN2BEG5
+ Inst_RegFile_ConfigMem.Inst_frame7_bit17.Q _0643_ VPWR VGND sg13g2_mux4_1
X_3146_ FrameData[14] FrameStrobe[1] Inst_RegFile_ConfigMem.Inst_frame1_bit14.Q VPWR
+ VGND sg13g2_dlhq_1
XFILLER_49_23 VPWR VGND sg13g2_fill_1
XFILLER_2_437 VPWR VGND sg13g2_fill_2
XFILLER_5_231 VPWR VGND sg13g2_fill_1
X_3000_ FrameData[28] FrameStrobe[6] Inst_RegFile_ConfigMem.Inst_frame6_bit28.Q VPWR
+ VGND sg13g2_dlhq_1
XFILLER_32_385 VPWR VGND sg13g2_fill_2
X_2577_ _1065_ Inst_RegFile_32x4.mem\[9\]\[0\] _1102_ _0028_ VPWR VGND sg13g2_mux2_1
X_2646_ _1065_ Inst_RegFile_32x4.mem\[29\]\[0\] _1119_ _0080_ VPWR VGND sg13g2_mux2_1
X_2715_ _1354_ VGND VPWR _0009_ Inst_RegFile_32x4.mem\[26\]\[1\] clknet_5_4__leaf_UserCLK_regs
+ sg13g2_dfrbpq_1
X_1528_ _0170_ VPWR _0171_ VGND Inst_RegFile_ConfigMem.Inst_frame1_bit20.Q BD2 sg13g2_o21ai_1
X_1459_ Inst_RegFile_ConfigMem.Inst_frame2_bit20.Q W1END[2] AD0 AD1 AD2 Inst_RegFile_ConfigMem.Inst_frame2_bit21.Q
+ _1215_ VPWR VGND sg13g2_mux4_1
X_3129_ FrameData[29] FrameStrobe[2] Inst_RegFile_ConfigMem.Inst_frame2_bit29.Q VPWR
+ VGND sg13g2_dlhq_1
XFILLER_23_363 VPWR VGND sg13g2_fill_1
XFILLER_14_374 VPWR VGND sg13g2_fill_1
X_3480_ FrameStrobe[8] net99 VPWR VGND sg13g2_buf_1
X_2431_ Inst_RegFile_ConfigMem.Inst_frame12_bit20.Q _1164_ _1010_ VPWR VGND sg13g2_nor2_1
X_2500_ Inst_RegFile_ConfigMem.Inst_frame8_bit7.Q _1031_ _1054_ VPWR VGND sg13g2_and2_1
X_2293_ VGND VPWR Inst_RegFile_ConfigMem.Inst_frame4_bit2.Q _0890_ _0892_ _0891_ sg13g2_a21oi_1
X_2362_ VGND VPWR Inst_RegFile_ConfigMem.Inst_frame10_bit12.Q _0911_ _0951_ _0950_
+ sg13g2_a21oi_1
XFILLER_37_477 VPWR VGND sg13g2_fill_1
XANTENNA_12 VPWR VGND FrameStrobe[15] sg13g2_antennanp
XANTENNA_78 VPWR VGND N2MID[7] sg13g2_antennanp
XANTENNA_67 VPWR VGND N2MID[7] sg13g2_antennanp
XANTENNA_56 VPWR VGND N2MID[0] sg13g2_antennanp
XANTENNA_34 VPWR VGND W6END[4] sg13g2_antennanp
XANTENNA_45 VPWR VGND WW4END[1] sg13g2_antennanp
XANTENNA_23 VPWR VGND W2END[4] sg13g2_antennanp
Xoutput141 net141 NN4BEG[13] VPWR VGND sg13g2_buf_1
Xoutput152 net152 NN4BEG[9] VPWR VGND sg13g2_buf_1
Xoutput130 net130 N4BEG[3] VPWR VGND sg13g2_buf_1
X_2629_ _1087_ Inst_RegFile_32x4.mem\[1\]\[3\] _1115_ _0067_ VPWR VGND sg13g2_mux2_1
Xoutput185 net185 S4BEG[6] VPWR VGND sg13g2_buf_1
Xoutput163 net163 S2BEG[6] VPWR VGND sg13g2_buf_1
Xoutput196 net196 SS4BEG[1] VPWR VGND sg13g2_buf_1
Xoutput174 net174 S4BEG[10] VPWR VGND sg13g2_buf_1
XFILLER_19_411 VPWR VGND sg13g2_fill_2
X_2980_ FrameData[8] FrameStrobe[6] Inst_RegFile_ConfigMem.Inst_frame6_bit8.Q VPWR
+ VGND sg13g2_dlhq_1
X_1931_ _0553_ _0552_ _0409_ VPWR VGND sg13g2_nand2b_1
X_1793_ Inst_RegFile_ConfigMem.Inst_frame1_bit17.Q VPWR _0422_ VGND Inst_RegFile_ConfigMem.Inst_frame1_bit16.Q
+ BD2 sg13g2_o21ai_1
X_3601_ Inst_RegFile_switch_matrix.JW2BEG0 net210 VPWR VGND sg13g2_buf_1
X_1862_ Inst_RegFile_ConfigMem.Inst_frame8_bit29.Q N2END[2] _0488_ VPWR VGND sg13g2_nor2b_1
X_3463_ FrameData[23] net64 VPWR VGND sg13g2_buf_1
X_2414_ Inst_RegFile_ConfigMem.Inst_frame12_bit29.Q N1END[1] E1END[1] W1END[1] AD0
+ Inst_RegFile_ConfigMem.Inst_frame12_bit30.Q _0996_ VPWR VGND sg13g2_mux4_1
XFILLER_35_0 VPWR VGND sg13g2_fill_2
X_3394_ Inst_RegFile_switch_matrix.E1BEG2 net3 VPWR VGND sg13g2_buf_1
X_3532_ NN4END[8] net147 VPWR VGND sg13g2_buf_1
X_2276_ Inst_RegFile_ConfigMem.Inst_frame4_bit29.Q _0875_ _0874_ _0872_ _0873_ Inst_RegFile_ConfigMem.Inst_frame4_bit30.Q
+ _0876_ VPWR VGND sg13g2_mux4_1
X_2345_ Inst_RegFile_ConfigMem.Inst_frame10_bit21.Q N1END[1] E1END[1] W1END[1] AD0
+ Inst_RegFile_ConfigMem.Inst_frame10_bit22.Q _0937_ VPWR VGND sg13g2_mux4_1
XFILLER_37_296 VPWR VGND sg13g2_fill_1
XFILLER_12_119 VPWR VGND sg13g2_fill_1
XFILLER_43_277 VPWR VGND sg13g2_fill_2
X_2061_ Inst_RegFile_ConfigMem.Inst_frame2_bit9.Q N2END[3] E2END[3] E1END[1] EE4END[2]
+ Inst_RegFile_ConfigMem.Inst_frame2_bit8.Q _0674_ VPWR VGND sg13g2_mux4_1
X_2130_ _0738_ VPWR Inst_RegFile_switch_matrix.JS2BEG1 VGND _0727_ _0733_ sg13g2_o21ai_1
XFILLER_19_252 VPWR VGND sg13g2_fill_1
X_2963_ FrameData[23] FrameStrobe[7] Inst_RegFile_ConfigMem.Inst_frame7_bit23.Q VPWR
+ VGND sg13g2_dlhq_1
X_1914_ _0535_ VPWR _0536_ VGND _0367_ _0534_ sg13g2_o21ai_1
X_1845_ _0471_ VPWR _0472_ VGND Inst_RegFile_ConfigMem.Inst_frame4_bit24.Q _1164_
+ sg13g2_o21ai_1
X_1776_ _0406_ _0405_ Inst_RegFile_ConfigMem.Inst_frame2_bit19.Q VPWR VGND sg13g2_nand2b_1
X_2894_ FrameData[18] FrameStrobe[9] Inst_RegFile_ConfigMem.Inst_frame9_bit18.Q VPWR
+ VGND sg13g2_dlhq_1
X_3515_ N4END[7] net130 VPWR VGND sg13g2_buf_1
X_3377_ VPWR VGND _1359_ sg13g2_tiehi
X_3446_ FrameData[6] net77 VPWR VGND sg13g2_buf_1
X_2328_ Inst_RegFile_ConfigMem.Inst_frame9_bit7.Q VPWR _0923_ VGND _1153_ _0922_ sg13g2_o21ai_1
X_2259_ Inst_RegFile_ConfigMem.Inst_frame3_bit2.Q VPWR _0860_ VGND Inst_RegFile_ConfigMem.Inst_frame3_bit1.Q
+ _0858_ sg13g2_o21ai_1
X_1630_ A_ADR0 Inst_RegFile_32x4.mem\[6\]\[1\] Inst_RegFile_32x4.mem\[7\]\[1\] Inst_RegFile_32x4.mem\[4\]\[1\]
+ Inst_RegFile_32x4.mem\[5\]\[1\] _1210_ _0268_ VPWR VGND sg13g2_mux4_1
X_3231_ _1252_ VGND VPWR _0103_ Inst_RegFile_32x4.mem\[6\]\[3\] clknet_5_29__leaf_UserCLK_regs
+ sg13g2_dfrbpq_1
X_1561_ Inst_RegFile_ConfigMem.Inst_frame4_bit22.Q VPWR _0203_ VGND _0201_ _0202_
+ sg13g2_o21ai_1
X_3162_ FrameData[30] FrameStrobe[1] Inst_RegFile_ConfigMem.Inst_frame1_bit30.Q VPWR
+ VGND sg13g2_dlhq_1
X_3300_ VPWR VGND _1282_ sg13g2_tiehi
X_1492_ _0136_ VPWR Inst_RegFile_switch_matrix.JS2BEG3 VGND _1234_ _0130_ sg13g2_o21ai_1
X_2044_ VGND VPWR S2END[3] Inst_RegFile_ConfigMem.Inst_frame1_bit8.Q _0658_ _0657_
+ sg13g2_a21oi_1
X_3093_ FrameData[25] FrameStrobe[3] Inst_RegFile_ConfigMem.Inst_frame3_bit25.Q VPWR
+ VGND sg13g2_dlhq_1
X_2113_ VGND VPWR Inst_RegFile_ConfigMem.Inst_frame1_bit6.Q _0721_ _0723_ _0722_ sg13g2_a21oi_1
X_2946_ FrameData[6] FrameStrobe[7] Inst_RegFile_ConfigMem.Inst_frame7_bit6.Q VPWR
+ VGND sg13g2_dlhq_1
X_2877_ FrameData[1] FrameStrobe[9] Inst_RegFile_ConfigMem.Inst_frame9_bit1.Q VPWR
+ VGND sg13g2_dlhq_1
X_1759_ _0389_ Inst_RegFile_ConfigMem.Inst_frame2_bit16.Q AD2 VPWR VGND sg13g2_nand2_1
X_1828_ _0455_ E2MID[0] Inst_RegFile_ConfigMem.Inst_frame7_bit30.Q VPWR VGND sg13g2_nand2_1
X_3429_ EE4END[9] net44 VPWR VGND sg13g2_buf_1
XFILLER_13_236 VPWR VGND sg13g2_fill_1
XFILLER_48_199 VPWR VGND sg13g2_fill_2
X_2800_ FrameData[20] FrameStrobe[12] Inst_RegFile_ConfigMem.Inst_frame12_bit20.Q
+ VPWR VGND sg13g2_dlhq_1
X_2731_ _1338_ VGND VPWR _0025_ Inst_RegFile_32x4.mem\[30\]\[1\] clknet_5_14__leaf_UserCLK_regs
+ sg13g2_dfrbpq_1
X_2662_ Inst_RegFile_32x4.mem\[4\]\[0\] _1065_ _1123_ _0092_ VPWR VGND sg13g2_mux2_1
X_2593_ _1087_ Inst_RegFile_32x4.mem\[17\]\[3\] _1107_ _0039_ VPWR VGND sg13g2_mux2_1
X_1613_ _0253_ Inst_RegFile_32x4.mem\[18\]\[0\] A_ADR0 VPWR VGND sg13g2_nand2b_1
X_1544_ _0186_ _0167_ _0184_ VPWR VGND sg13g2_nand2_1
X_1475_ _1230_ _1229_ Inst_RegFile_ConfigMem.Inst_frame8_bit14.Q VPWR VGND sg13g2_nand2b_1
X_3214_ _1269_ VGND VPWR _0086_ Inst_RegFile_32x4.mem\[31\]\[2\] clknet_5_5__leaf_UserCLK_regs
+ sg13g2_dfrbpq_1
X_3145_ FrameData[13] FrameStrobe[1] Inst_RegFile_ConfigMem.Inst_frame1_bit13.Q VPWR
+ VGND sg13g2_dlhq_1
X_2027_ _0640_ VPWR _0642_ VGND Inst_RegFile_ConfigMem.Inst_frame8_bit10.Q _0641_
+ sg13g2_o21ai_1
X_3076_ FrameData[8] FrameStrobe[3] Inst_RegFile_ConfigMem.Inst_frame3_bit8.Q VPWR
+ VGND sg13g2_dlhq_1
XFILLER_35_372 VPWR VGND sg13g2_fill_2
XFILLER_24_27 VPWR VGND sg13g2_fill_1
X_2929_ FrameData[21] FrameStrobe[8] Inst_RegFile_ConfigMem.Inst_frame8_bit21.Q VPWR
+ VGND sg13g2_dlhq_1
Xclkbuf_5_9__f_UserCLK_regs clknet_4_4_0_UserCLK_regs clknet_5_9__leaf_UserCLK_regs
+ VPWR VGND sg13g2_buf_8
X_2714_ _1355_ VGND VPWR _0008_ Inst_RegFile_32x4.mem\[26\]\[0\] clknet_5_7__leaf_UserCLK_regs
+ sg13g2_dfrbpq_1
X_2576_ _1102_ _1088_ _1101_ VPWR VGND sg13g2_nand2_1
X_1527_ _0170_ Inst_RegFile_ConfigMem.Inst_frame1_bit20.Q BD3 VPWR VGND sg13g2_nand2b_1
X_2645_ _1119_ _1088_ _1094_ VPWR VGND sg13g2_nand2_1
X_1458_ VGND VPWR Inst_RegFile_32x4.mem\[11\]\[0\] A_ADR0 _1214_ _1210_ sg13g2_a21oi_1
X_1389_ VPWR _1147_ Inst_RegFile_ConfigMem.Inst_frame1_bit10.Q VGND sg13g2_inv_1
XFILLER_27_114 VPWR VGND sg13g2_decap_8
X_3128_ FrameData[28] FrameStrobe[2] Inst_RegFile_ConfigMem.Inst_frame2_bit28.Q VPWR
+ VGND sg13g2_dlhq_1
X_3059_ FrameData[23] FrameStrobe[4] Inst_RegFile_ConfigMem.Inst_frame4_bit23.Q VPWR
+ VGND sg13g2_dlhq_1
XFILLER_18_125 VPWR VGND sg13g2_fill_2
X_2430_ _1008_ VPWR _1009_ VGND Inst_RegFile_ConfigMem.Inst_frame12_bit20.Q _0910_
+ sg13g2_o21ai_1
X_2361_ Inst_RegFile_ConfigMem.Inst_frame10_bit12.Q _1164_ _0950_ VPWR VGND sg13g2_nor2_1
X_2292_ Inst_RegFile_ConfigMem.Inst_frame4_bit2.Q _0889_ _0891_ VPWR VGND sg13g2_nor2b_1
XANTENNA_13 VPWR VGND FrameStrobe[18] sg13g2_antennanp
XFILLER_32_172 VPWR VGND sg13g2_fill_1
XANTENNA_79 VPWR VGND N2MID[7] sg13g2_antennanp
XANTENNA_46 VPWR VGND WW4END[1] sg13g2_antennanp
XANTENNA_68 VPWR VGND N2MID[7] sg13g2_antennanp
XANTENNA_57 VPWR VGND N2MID[0] sg13g2_antennanp
XANTENNA_35 VPWR VGND W6END[5] sg13g2_antennanp
XANTENNA_24 VPWR VGND W2END[4] sg13g2_antennanp
Xoutput142 net142 NN4BEG[14] VPWR VGND sg13g2_buf_1
Xoutput131 net131 N4BEG[4] VPWR VGND sg13g2_buf_1
Xoutput120 net120 N2BEGb[7] VPWR VGND sg13g2_buf_1
X_2628_ _1069_ Inst_RegFile_32x4.mem\[1\]\[2\] _1115_ _0066_ VPWR VGND sg13g2_mux2_1
Xoutput186 net186 S4BEG[7] VPWR VGND sg13g2_buf_1
Xoutput164 net164 S2BEG[7] VPWR VGND sg13g2_buf_1
Xoutput153 net153 S1BEG[0] VPWR VGND sg13g2_buf_1
Xoutput197 net197 SS4BEG[2] VPWR VGND sg13g2_buf_1
X_2559_ _1067_ Inst_RegFile_32x4.mem\[28\]\[1\] _1095_ _0017_ VPWR VGND sg13g2_mux2_1
Xoutput175 net175 S4BEG[11] VPWR VGND sg13g2_buf_1
XFILLER_43_448 VPWR VGND sg13g2_fill_1
X_1930_ B_ADR0 Inst_RegFile_32x4.mem\[0\]\[3\] Inst_RegFile_32x4.mem\[1\]\[3\] Inst_RegFile_32x4.mem\[2\]\[3\]
+ Inst_RegFile_32x4.mem\[3\]\[3\] _0368_ _0552_ VPWR VGND sg13g2_mux4_1
X_1792_ BD3 Inst_RegFile_ConfigMem.Inst_frame1_bit16.Q _0421_ VPWR VGND sg13g2_nor2b_1
X_1861_ VGND VPWR Inst_RegFile_ConfigMem.Inst_frame8_bit29.Q _0486_ _0487_ _1140_
+ sg13g2_a21oi_1
X_3600_ Inst_RegFile_switch_matrix.W1BEG3 net209 VPWR VGND sg13g2_buf_1
X_3531_ NN4END[7] net146 VPWR VGND sg13g2_buf_1
X_3462_ FrameData[22] net63 VPWR VGND sg13g2_buf_1
X_2413_ Inst_RegFile_ConfigMem.Inst_frame12_bit29.Q BD0 _1229_ _0388_ _0994_ Inst_RegFile_ConfigMem.Inst_frame12_bit30.Q
+ _0995_ VPWR VGND sg13g2_mux4_1
XFILLER_28_0 VPWR VGND sg13g2_fill_2
X_3393_ Inst_RegFile_switch_matrix.E1BEG1 net2 VPWR VGND sg13g2_buf_1
X_2344_ Inst_RegFile_ConfigMem.Inst_frame10_bit21.Q BD0 _1229_ _0388_ _0935_ Inst_RegFile_ConfigMem.Inst_frame10_bit22.Q
+ _0936_ VPWR VGND sg13g2_mux4_1
XFILLER_37_220 VPWR VGND sg13g2_fill_2
X_2275_ N1END[0] N2END[0] Inst_RegFile_ConfigMem.Inst_frame4_bit28.Q _0875_ VPWR VGND
+ sg13g2_mux2_1
XFILLER_16_39 VPWR VGND sg13g2_fill_1
XFILLER_20_175 VPWR VGND sg13g2_fill_2
XFILLER_11_120 VPWR VGND sg13g2_fill_2
X_2060_ Inst_RegFile_ConfigMem.Inst_frame2_bit11.Q VPWR _0673_ VGND _0666_ _0667_
+ sg13g2_o21ai_1
X_2893_ FrameData[17] FrameStrobe[9] Inst_RegFile_ConfigMem.Inst_frame9_bit17.Q VPWR
+ VGND sg13g2_dlhq_1
X_2962_ FrameData[22] FrameStrobe[7] Inst_RegFile_ConfigMem.Inst_frame7_bit22.Q VPWR
+ VGND sg13g2_dlhq_1
X_1913_ VGND VPWR _0367_ _0533_ _0535_ _0409_ sg13g2_a21oi_1
X_1775_ _0403_ _0404_ Inst_RegFile_ConfigMem.Inst_frame2_bit18.Q _0405_ VPWR VGND
+ sg13g2_mux2_1
X_1844_ _0471_ Inst_RegFile_ConfigMem.Inst_frame4_bit24.Q BD3 VPWR VGND sg13g2_nand2_1
X_3445_ FrameData[5] net76 VPWR VGND sg13g2_buf_1
XFILLER_30_484 VPWR VGND sg13g2_fill_2
X_3514_ N4END[6] net129 VPWR VGND sg13g2_buf_1
X_3376_ VPWR VGND _1358_ sg13g2_tiehi
X_2258_ S2END[1] W2END[1] Inst_RegFile_ConfigMem.Inst_frame3_bit0.Q _0859_ VPWR VGND
+ sg13g2_mux2_1
X_2327_ Inst_RegFile_ConfigMem.Inst_frame5_bit12.Q N2END[4] E2END[4] SS4END[2] W2END[4]
+ Inst_RegFile_ConfigMem.Inst_frame5_bit13.Q _0922_ VPWR VGND sg13g2_mux4_1
X_2189_ VGND VPWR Inst_RegFile_ConfigMem.Inst_frame1_bit0.Q _1165_ _0794_ _0793_ sg13g2_a21oi_1
XFILLER_25_201 VPWR VGND sg13g2_fill_2
XFILLER_25_256 VPWR VGND sg13g2_fill_1
XFILLER_0_322 VPWR VGND sg13g2_fill_2
X_1560_ Inst_RegFile_ConfigMem.Inst_frame4_bit21.Q VPWR _0202_ VGND Inst_RegFile_ConfigMem.Inst_frame4_bit20.Q
+ BD2 sg13g2_o21ai_1
X_3230_ _1253_ VGND VPWR _0102_ Inst_RegFile_32x4.mem\[6\]\[2\] clknet_5_30__leaf_UserCLK_regs
+ sg13g2_dfrbpq_1
X_3161_ FrameData[29] FrameStrobe[1] Inst_RegFile_ConfigMem.Inst_frame1_bit29.Q VPWR
+ VGND sg13g2_dlhq_1
X_2112_ Inst_RegFile_ConfigMem.Inst_frame1_bit6.Q _0720_ _0722_ VPWR VGND sg13g2_nor2b_1
X_1491_ _0136_ _0135_ Inst_RegFile_ConfigMem.Inst_frame2_bit15.Q VPWR VGND sg13g2_nand2b_1
X_2043_ Inst_RegFile_ConfigMem.Inst_frame1_bit8.Q E6END[1] _0657_ VPWR VGND sg13g2_nor2b_1
X_3092_ FrameData[24] FrameStrobe[3] Inst_RegFile_ConfigMem.Inst_frame3_bit24.Q VPWR
+ VGND sg13g2_dlhq_1
X_1827_ _0453_ VPWR _0454_ VGND _1137_ Inst_RegFile_switch_matrix.JW2BEG6 sg13g2_o21ai_1
X_2945_ FrameData[5] FrameStrobe[7] Inst_RegFile_ConfigMem.Inst_frame7_bit5.Q VPWR
+ VGND sg13g2_dlhq_1
X_2876_ FrameData[0] FrameStrobe[9] Inst_RegFile_ConfigMem.Inst_frame9_bit0.Q VPWR
+ VGND sg13g2_dlhq_1
X_3428_ EE4END[8] net43 VPWR VGND sg13g2_buf_1
X_1758_ Inst_RegFile_ConfigMem.Inst_frame7_bit28.Q E2MID[4] S2MID[4] W2MID[4] Inst_RegFile_switch_matrix.JS2BEG6
+ Inst_RegFile_ConfigMem.Inst_frame7_bit29.Q _0388_ VPWR VGND sg13g2_mux4_1
X_1689_ A_ADR0 Inst_RegFile_32x4.mem\[24\]\[3\] _0323_ VPWR VGND sg13g2_nor2b_1
X_3359_ VPWR VGND _1341_ sg13g2_tiehi
XFILLER_5_458 VPWR VGND sg13g2_fill_1
XFILLER_21_281 VPWR VGND sg13g2_fill_1
XFILLER_48_156 VPWR VGND sg13g2_fill_1
X_2661_ _1061_ _1122_ _1123_ VPWR VGND sg13g2_and2_1
XFILLER_12_292 VPWR VGND sg13g2_fill_2
X_2730_ _1339_ VGND VPWR _0024_ Inst_RegFile_32x4.mem\[30\]\[0\] clknet_5_14__leaf_UserCLK_regs
+ sg13g2_dfrbpq_1
X_2592_ _1069_ Inst_RegFile_32x4.mem\[17\]\[2\] _1107_ _0038_ VPWR VGND sg13g2_mux2_1
X_1474_ Inst_RegFile_ConfigMem.Inst_frame7_bit21.Q N2MID[4] W2MID[4] S2MID[4] Inst_RegFile_switch_matrix.JS2BEG5
+ Inst_RegFile_ConfigMem.Inst_frame7_bit20.Q _1229_ VPWR VGND sg13g2_mux4_1
X_1612_ VGND VPWR Inst_RegFile_32x4.mem\[17\]\[0\] A_ADR0 _0252_ _0251_ sg13g2_a21oi_1
X_1543_ _0167_ _0184_ _0185_ VPWR VGND sg13g2_and2_1
X_3075_ FrameData[7] FrameStrobe[3] Inst_RegFile_ConfigMem.Inst_frame3_bit7.Q VPWR
+ VGND sg13g2_dlhq_1
X_3213_ _1270_ VGND VPWR _0085_ Inst_RegFile_32x4.mem\[31\]\[1\] clknet_5_15__leaf_UserCLK_regs
+ sg13g2_dfrbpq_1
X_3144_ FrameData[12] FrameStrobe[1] Inst_RegFile_ConfigMem.Inst_frame1_bit12.Q VPWR
+ VGND sg13g2_dlhq_1
X_2026_ Inst_RegFile_ConfigMem.Inst_frame5_bit17.Q N2END[7] S2END[7] EE4END[2] W2END[7]
+ Inst_RegFile_ConfigMem.Inst_frame5_bit16.Q _0641_ VPWR VGND sg13g2_mux4_1
X_2928_ FrameData[20] FrameStrobe[8] Inst_RegFile_ConfigMem.Inst_frame8_bit20.Q VPWR
+ VGND sg13g2_dlhq_1
X_2859_ FrameData[15] FrameStrobe[10] Inst_RegFile_ConfigMem.Inst_frame10_bit15.Q
+ VPWR VGND sg13g2_dlhq_1
Xclkbuf_4_4_0_UserCLK_regs clknet_0_UserCLK_regs clknet_4_4_0_UserCLK_regs VPWR VGND
+ sg13g2_buf_8
XFILLER_30_71 VPWR VGND sg13g2_fill_2
XFILLER_5_288 VPWR VGND sg13g2_fill_1
X_2644_ _1087_ Inst_RegFile_32x4.mem\[19\]\[3\] _1118_ _0079_ VPWR VGND sg13g2_mux2_1
X_2713_ _1356_ VGND VPWR _0007_ Inst_RegFile_32x4.mem\[25\]\[3\] clknet_5_13__leaf_UserCLK_regs
+ sg13g2_dfrbpq_1
X_1526_ _0169_ _0168_ Inst_RegFile_ConfigMem.Inst_frame1_bit22.Q VPWR VGND sg13g2_nand2b_1
X_1457_ _1213_ Inst_RegFile_32x4.mem\[10\]\[0\] A_ADR0 VPWR VGND sg13g2_nand2b_1
X_2575_ _1033_ _1100_ _1101_ VPWR VGND sg13g2_nor2_1
X_3058_ FrameData[22] FrameStrobe[4] Inst_RegFile_ConfigMem.Inst_frame4_bit22.Q VPWR
+ VGND sg13g2_dlhq_1
X_3127_ FrameData[27] FrameStrobe[2] Inst_RegFile_ConfigMem.Inst_frame2_bit27.Q VPWR
+ VGND sg13g2_dlhq_1
X_1388_ VPWR _1146_ Inst_RegFile_ConfigMem.Inst_frame8_bit19.Q VGND sg13g2_inv_1
X_2009_ Inst_RegFile_ConfigMem.Inst_frame4_bit14.Q VPWR _0625_ VGND Inst_RegFile_ConfigMem.Inst_frame4_bit13.Q
+ _0623_ sg13g2_o21ai_1
XFILLER_51_7 VPWR VGND sg13g2_fill_2
X_2291_ Inst_RegFile_ConfigMem.Inst_frame4_bit0.Q EE4END[0] E6END[1] S2END[1] W2END[1]
+ Inst_RegFile_ConfigMem.Inst_frame4_bit1.Q _0890_ VPWR VGND sg13g2_mux4_1
X_2360_ _0948_ VPWR _0949_ VGND Inst_RegFile_ConfigMem.Inst_frame10_bit12.Q _0910_
+ sg13g2_o21ai_1
XFILLER_2_64 VPWR VGND sg13g2_fill_2
XFILLER_1_280 VPWR VGND sg13g2_fill_2
XANTENNA_14 VPWR VGND FrameStrobe[19] sg13g2_antennanp
XANTENNA_47 VPWR VGND WW4END[1] sg13g2_antennanp
XANTENNA_25 VPWR VGND W2END[4] sg13g2_antennanp
XANTENNA_36 VPWR VGND W6END[6] sg13g2_antennanp
Xoutput143 net143 NN4BEG[15] VPWR VGND sg13g2_buf_1
Xoutput132 net132 N4BEG[5] VPWR VGND sg13g2_buf_1
Xoutput121 net121 N4BEG[0] VPWR VGND sg13g2_buf_1
XANTENNA_69 VPWR VGND N2MID[7] sg13g2_antennanp
Xoutput110 net110 N2BEG[5] VPWR VGND sg13g2_buf_1
X_2627_ _1067_ Inst_RegFile_32x4.mem\[1\]\[1\] _1115_ _0065_ VPWR VGND sg13g2_mux2_1
XANTENNA_58 VPWR VGND N2MID[0] sg13g2_antennanp
X_2489_ Inst_RegFile_ConfigMem.Inst_frame6_bit8.Q N2MID[7] E2MID[7] S2MID[7] W2MID[7]
+ Inst_RegFile_ConfigMem.Inst_frame6_bit9.Q _1043_ VPWR VGND sg13g2_mux4_1
X_1509_ BD3 Inst_RegFile_ConfigMem.Inst_frame1_bit12.Q _0153_ VPWR VGND sg13g2_nor2b_1
Xoutput187 net187 S4BEG[8] VPWR VGND sg13g2_buf_1
Xoutput198 net198 SS4BEG[3] VPWR VGND sg13g2_buf_1
Xoutput165 net165 S2BEGb[0] VPWR VGND sg13g2_buf_1
Xoutput154 net154 S1BEG[1] VPWR VGND sg13g2_buf_1
Xoutput176 net176 S4BEG[12] VPWR VGND sg13g2_buf_1
X_2558_ _1065_ Inst_RegFile_32x4.mem\[28\]\[0\] _1095_ _0016_ VPWR VGND sg13g2_mux2_1
XFILLER_19_413 VPWR VGND sg13g2_fill_1
X_1860_ Inst_RegFile_ConfigMem.Inst_frame6_bit4.Q N2MID[5] E2MID[5] S2MID[5] W2MID[5]
+ Inst_RegFile_ConfigMem.Inst_frame6_bit5.Q _0486_ VPWR VGND sg13g2_mux4_1
X_3461_ FrameData[21] net62 VPWR VGND sg13g2_buf_1
X_1791_ VGND VPWR _0418_ _0419_ _0420_ Inst_RegFile_ConfigMem.Inst_frame1_bit17.Q
+ sg13g2_a21oi_1
X_3530_ NN4END[6] net145 VPWR VGND sg13g2_buf_1
X_2274_ NN4END[0] E1END[0] Inst_RegFile_ConfigMem.Inst_frame4_bit28.Q _0874_ VPWR
+ VGND sg13g2_mux2_1
X_2412_ Inst_RegFile_ConfigMem.Inst_frame5_bit3.Q NN4END[0] S2END[2] E2END[2] W2END[2]
+ Inst_RegFile_ConfigMem.Inst_frame5_bit2.Q _0994_ VPWR VGND sg13g2_mux4_1
X_2343_ Inst_RegFile_ConfigMem.Inst_frame5_bit7.Q N2END[0] S2END[0] E2END[0] WW4END[3]
+ Inst_RegFile_ConfigMem.Inst_frame5_bit6.Q _0935_ VPWR VGND sg13g2_mux4_1
X_3392_ Inst_RegFile_switch_matrix.E1BEG0 net1 VPWR VGND sg13g2_buf_1
X_1989_ _0606_ Inst_RegFile_ConfigMem.Inst_frame7_bit24.Q E2MID[6] VPWR VGND sg13g2_nand2b_1
XFILLER_43_279 VPWR VGND sg13g2_fill_1
XFILLER_7_136 VPWR VGND sg13g2_fill_1
XFILLER_22_408 VPWR VGND sg13g2_fill_2
X_1843_ VGND VPWR Inst_RegFile_ConfigMem.Inst_frame4_bit24.Q BD0 _0470_ _0469_ sg13g2_a21oi_1
X_2892_ FrameData[16] FrameStrobe[9] Inst_RegFile_ConfigMem.Inst_frame9_bit16.Q VPWR
+ VGND sg13g2_dlhq_1
XFILLER_30_452 VPWR VGND sg13g2_fill_1
XFILLER_8_85 VPWR VGND sg13g2_fill_2
X_2961_ FrameData[21] FrameStrobe[7] Inst_RegFile_ConfigMem.Inst_frame7_bit21.Q VPWR
+ VGND sg13g2_dlhq_1
X_1912_ Inst_RegFile_32x4.mem\[26\]\[3\] Inst_RegFile_32x4.mem\[27\]\[3\] B_ADR0 _0534_
+ VPWR VGND sg13g2_mux2_1
X_3444_ FrameData[4] net75 VPWR VGND sg13g2_buf_1
X_1774_ Inst_RegFile_ConfigMem.Inst_frame2_bit16.Q S1END[1] S2END[5] SS4END[3] W1END[1]
+ Inst_RegFile_ConfigMem.Inst_frame2_bit17.Q _0404_ VPWR VGND sg13g2_mux4_1
XFILLER_40_0 VPWR VGND sg13g2_fill_2
X_3513_ N4END[5] net128 VPWR VGND sg13g2_buf_1
X_2326_ _0921_ _0920_ Inst_RegFile_ConfigMem.Inst_frame9_bit11.Q Inst_RegFile_switch_matrix.WW4BEG3
+ VPWR VGND sg13g2_mux2_1
X_2257_ VGND VPWR E6END[1] Inst_RegFile_ConfigMem.Inst_frame3_bit0.Q _0858_ _0857_
+ sg13g2_a21oi_1
X_3375_ VPWR VGND _1357_ sg13g2_tiehi
XFILLER_40_238 VPWR VGND sg13g2_fill_1
XFILLER_40_227 VPWR VGND sg13g2_fill_1
X_2188_ Inst_RegFile_ConfigMem.Inst_frame1_bit1.Q VPWR _0793_ VGND Inst_RegFile_ConfigMem.Inst_frame1_bit0.Q
+ BD2 sg13g2_o21ai_1
XFILLER_4_117 VPWR VGND sg13g2_fill_2
X_1490_ Inst_RegFile_ConfigMem.Inst_frame2_bit14.Q _0132_ _0134_ _0131_ _0133_ Inst_RegFile_ConfigMem.Inst_frame2_bit13.Q
+ _0135_ VPWR VGND sg13g2_mux4_1
X_3091_ FrameData[23] FrameStrobe[3] Inst_RegFile_ConfigMem.Inst_frame3_bit23.Q VPWR
+ VGND sg13g2_dlhq_1
X_2042_ S4END[3] W2END[3] Inst_RegFile_ConfigMem.Inst_frame1_bit8.Q _0656_ VPWR VGND
+ sg13g2_mux2_1
X_3160_ FrameData[28] FrameStrobe[1] Inst_RegFile_ConfigMem.Inst_frame1_bit28.Q VPWR
+ VGND sg13g2_dlhq_1
X_2111_ Inst_RegFile_ConfigMem.Inst_frame1_bit4.Q S2END[2] S4END[2] SS4END[1] W2END[2]
+ Inst_RegFile_ConfigMem.Inst_frame1_bit5.Q _0721_ VPWR VGND sg13g2_mux4_1
X_1826_ VGND VPWR _0453_ W2MID[0] Inst_RegFile_ConfigMem.Inst_frame7_bit30.Q sg13g2_or2_1
X_2875_ FrameData[31] FrameStrobe[10] Inst_RegFile_ConfigMem.Inst_frame10_bit31.Q
+ VPWR VGND sg13g2_dlhq_1
X_2944_ FrameData[4] FrameStrobe[7] Inst_RegFile_ConfigMem.Inst_frame7_bit4.Q VPWR
+ VGND sg13g2_dlhq_1
Xclkbuf_5_4__f_UserCLK_regs clknet_4_2_0_UserCLK_regs clknet_5_4__leaf_UserCLK_regs
+ VPWR VGND sg13g2_buf_8
X_3427_ EE4END[7] net42 VPWR VGND sg13g2_buf_1
X_1757_ _0387_ VPWR Inst_RegFile_switch_matrix.JS2BEG6 VGND _0373_ _0380_ sg13g2_o21ai_1
X_3358_ VPWR VGND _1340_ sg13g2_tiehi
X_1688_ Inst_RegFile_32x4.mem\[26\]\[3\] Inst_RegFile_32x4.mem\[27\]\[3\] A_ADR0 _0322_
+ VPWR VGND sg13g2_mux2_1
X_3289_ VPWR VGND _1271_ sg13g2_tiehi
X_2309_ VGND VPWR Inst_RegFile_ConfigMem.Inst_frame9_bit12.Q AD1 _0906_ Inst_RegFile_ConfigMem.Inst_frame9_bit13.Q
+ sg13g2_a21oi_1
Xclkbuf_4_12_0_UserCLK_regs clknet_0_UserCLK_regs clknet_4_12_0_UserCLK_regs VPWR
+ VGND sg13g2_buf_8
XFILLER_44_352 VPWR VGND sg13g2_fill_2
XFILLER_44_330 VPWR VGND sg13g2_fill_2
X_2660_ _1033_ _1096_ _1122_ VPWR VGND sg13g2_and2_1
X_1611_ A_ADR0 Inst_RegFile_32x4.mem\[16\]\[0\] _0251_ VPWR VGND sg13g2_nor2b_1
X_1473_ _1228_ VPWR Inst_RegFile_switch_matrix.JS2BEG5 VGND _1216_ _1222_ sg13g2_o21ai_1
X_2591_ _1067_ Inst_RegFile_32x4.mem\[17\]\[1\] _1107_ _0037_ VPWR VGND sg13g2_mux2_1
X_1542_ _0184_ _0182_ _0183_ VPWR VGND sg13g2_nand2_1
X_3212_ _1271_ VGND VPWR _0084_ Inst_RegFile_32x4.mem\[31\]\[0\] clknet_5_15__leaf_UserCLK_regs
+ sg13g2_dfrbpq_1
X_3143_ FrameData[11] FrameStrobe[1] Inst_RegFile_ConfigMem.Inst_frame1_bit11.Q VPWR
+ VGND sg13g2_dlhq_1
X_2025_ _0636_ Inst_RegFile_ConfigMem.Inst_frame0_bit17.Q _0639_ _0640_ VPWR VGND
+ sg13g2_a21o_1
Xclkbuf_5_19__f_UserCLK_regs clknet_4_9_0_UserCLK_regs clknet_5_19__leaf_UserCLK_regs
+ VPWR VGND sg13g2_buf_8
X_3074_ FrameData[6] FrameStrobe[3] Inst_RegFile_ConfigMem.Inst_frame3_bit6.Q VPWR
+ VGND sg13g2_dlhq_1
XFILLER_50_355 VPWR VGND sg13g2_fill_2
XFILLER_50_311 VPWR VGND sg13g2_fill_2
X_2927_ FrameData[19] FrameStrobe[8] Inst_RegFile_ConfigMem.Inst_frame8_bit19.Q VPWR
+ VGND sg13g2_dlhq_1
X_1809_ N2MID[1] E2MID[1] Inst_RegFile_ConfigMem.Inst_frame6_bit30.Q _0437_ VPWR VGND
+ sg13g2_mux2_1
X_2789_ FrameData[9] FrameStrobe[12] Inst_RegFile_ConfigMem.Inst_frame12_bit9.Q VPWR
+ VGND sg13g2_dlhq_1
X_2858_ FrameData[14] FrameStrobe[10] Inst_RegFile_ConfigMem.Inst_frame10_bit14.Q
+ VPWR VGND sg13g2_dlhq_1
XFILLER_41_300 VPWR VGND sg13g2_fill_2
XFILLER_49_400 VPWR VGND sg13g2_fill_1
XFILLER_36_149 VPWR VGND sg13g2_fill_1
XFILLER_1_473 VPWR VGND sg13g2_fill_1
X_2574_ _1100_ _1029_ _1026_ VPWR VGND sg13g2_nand2b_1
X_2643_ _1069_ Inst_RegFile_32x4.mem\[19\]\[2\] _1118_ _0078_ VPWR VGND sg13g2_mux2_1
X_2712_ _1357_ VGND VPWR _0006_ Inst_RegFile_32x4.mem\[25\]\[2\] clknet_5_18__leaf_UserCLK_regs
+ sg13g2_dfrbpq_1
X_1525_ Inst_RegFile_ConfigMem.Inst_frame1_bit20.Q WW4END[2] AD0 AD1 AD2 Inst_RegFile_ConfigMem.Inst_frame1_bit21.Q
+ _0168_ VPWR VGND sg13g2_mux4_1
X_1456_ VGND VPWR Inst_RegFile_32x4.mem\[9\]\[0\] A_ADR0 _1212_ _1211_ sg13g2_a21oi_1
X_1387_ VPWR _1145_ Inst_RegFile_ConfigMem.Inst_frame8_bit17.Q VGND sg13g2_inv_1
X_3126_ FrameData[26] FrameStrobe[2] Inst_RegFile_ConfigMem.Inst_frame2_bit26.Q VPWR
+ VGND sg13g2_dlhq_1
X_3057_ FrameData[21] FrameStrobe[4] Inst_RegFile_ConfigMem.Inst_frame4_bit21.Q VPWR
+ VGND sg13g2_dlhq_1
X_2008_ BD2 BD3 Inst_RegFile_ConfigMem.Inst_frame4_bit12.Q _0624_ VPWR VGND sg13g2_mux2_1
X_2290_ Inst_RegFile_ConfigMem.Inst_frame4_bit0.Q N2END[1] N4END[1] E1END[3] E2END[1]
+ Inst_RegFile_ConfigMem.Inst_frame4_bit1.Q _0889_ VPWR VGND sg13g2_mux4_1
XFILLER_2_54 VPWR VGND sg13g2_fill_2
XANTENNA_59 VPWR VGND N2MID[0] sg13g2_antennanp
XANTENNA_15 VPWR VGND S4END[8] sg13g2_antennanp
XANTENNA_48 VPWR VGND WW4END[1] sg13g2_antennanp
XANTENNA_37 VPWR VGND W6END[7] sg13g2_antennanp
XANTENNA_26 VPWR VGND W2END[4] sg13g2_antennanp
Xoutput144 net144 NN4BEG[1] VPWR VGND sg13g2_buf_1
Xoutput133 net133 N4BEG[6] VPWR VGND sg13g2_buf_1
Xoutput122 net122 N4BEG[10] VPWR VGND sg13g2_buf_1
Xoutput100 net100 FrameStrobe_O[9] VPWR VGND sg13g2_buf_1
X_2626_ _1065_ Inst_RegFile_32x4.mem\[1\]\[0\] _1115_ _0064_ VPWR VGND sg13g2_mux2_1
X_2557_ _1095_ _1061_ _1094_ VPWR VGND sg13g2_nand2_1
Xoutput166 net166 S2BEGb[1] VPWR VGND sg13g2_buf_1
Xoutput155 net155 S1BEG[2] VPWR VGND sg13g2_buf_1
Xoutput177 net177 S4BEG[13] VPWR VGND sg13g2_buf_1
Xoutput111 net111 N2BEG[6] VPWR VGND sg13g2_buf_1
X_2488_ Inst_RegFile_ConfigMem.Inst_frame7_bit8.Q E2MID[6] S2MID[6] W2MID[6] Inst_RegFile_switch_matrix.JN2BEG4
+ Inst_RegFile_ConfigMem.Inst_frame7_bit9.Q _1042_ VPWR VGND sg13g2_mux4_1
XFILLER_28_436 VPWR VGND sg13g2_fill_1
Xoutput188 net188 S4BEG[9] VPWR VGND sg13g2_buf_1
Xoutput199 net199 SS4BEG[4] VPWR VGND sg13g2_buf_1
X_1439_ Inst_RegFile_ConfigMem.Inst_frame3_bit15.Q VPWR _1196_ VGND _1192_ _1195_
+ sg13g2_o21ai_1
X_1508_ VGND VPWR _0150_ _0151_ _0152_ Inst_RegFile_ConfigMem.Inst_frame1_bit13.Q
+ sg13g2_a21oi_1
X_3109_ FrameData[9] FrameStrobe[2] Inst_RegFile_ConfigMem.Inst_frame2_bit9.Q VPWR
+ VGND sg13g2_dlhq_1
X_1790_ _0419_ AD3 Inst_RegFile_ConfigMem.Inst_frame1_bit16.Q VPWR VGND sg13g2_nand2b_1
X_3460_ FrameData[20] net61 VPWR VGND sg13g2_buf_1
X_3391_ VPWR VGND _1373_ sg13g2_tiehi
X_2411_ _0993_ _0992_ Inst_RegFile_ConfigMem.Inst_frame11_bit10.Q Inst_RegFile_switch_matrix.EE4BEG0
+ VPWR VGND sg13g2_mux2_1
X_2273_ S2END[0] W1END[0] Inst_RegFile_ConfigMem.Inst_frame4_bit28.Q _0873_ VPWR VGND
+ sg13g2_mux2_1
XFILLER_28_2 VPWR VGND sg13g2_fill_1
X_2342_ _0934_ _0933_ Inst_RegFile_ConfigMem.Inst_frame9_bit2.Q Inst_RegFile_switch_matrix.WW4BEG0
+ VPWR VGND sg13g2_mux2_1
X_1988_ S2MID[6] Inst_RegFile_switch_matrix.JN2BEG6 Inst_RegFile_ConfigMem.Inst_frame7_bit24.Q
+ _0605_ VPWR VGND sg13g2_mux2_1
XFILLER_33_483 VPWR VGND sg13g2_fill_2
X_3589_ SS4END[13] net204 VPWR VGND sg13g2_buf_1
X_2609_ _1087_ Inst_RegFile_32x4.mem\[14\]\[3\] _1111_ _0051_ VPWR VGND sg13g2_mux2_1
XFILLER_3_321 VPWR VGND sg13g2_fill_2
XFILLER_22_40 VPWR VGND sg13g2_fill_2
XFILLER_0_0 VPWR VGND sg13g2_fill_1
X_2960_ FrameData[20] FrameStrobe[7] Inst_RegFile_ConfigMem.Inst_frame7_bit20.Q VPWR
+ VGND sg13g2_dlhq_1
X_1842_ Inst_RegFile_ConfigMem.Inst_frame4_bit24.Q AD3 _0469_ VPWR VGND sg13g2_nor2b_1
X_1773_ Inst_RegFile_ConfigMem.Inst_frame2_bit16.Q N1END[1] N2END[5] E1END[1] E2END[5]
+ Inst_RegFile_ConfigMem.Inst_frame2_bit17.Q _0403_ VPWR VGND sg13g2_mux4_1
X_2891_ FrameData[15] FrameStrobe[9] Inst_RegFile_ConfigMem.Inst_frame9_bit15.Q VPWR
+ VGND sg13g2_dlhq_1
X_1911_ VGND VPWR Inst_RegFile_32x4.mem\[25\]\[3\] B_ADR0 _0533_ _0532_ sg13g2_a21oi_1
X_3443_ FrameData[3] net74 VPWR VGND sg13g2_buf_1
XFILLER_33_0 VPWR VGND sg13g2_fill_2
X_3512_ N4END[4] net121 VPWR VGND sg13g2_buf_1
X_3374_ VPWR VGND _1356_ sg13g2_tiehi
X_2325_ Inst_RegFile_ConfigMem.Inst_frame9_bit9.Q N1END[1] S1END[1] W1END[1] AD0 Inst_RegFile_ConfigMem.Inst_frame9_bit10.Q
+ _0921_ VPWR VGND sg13g2_mux4_1
X_2187_ _0791_ VPWR _0792_ VGND Inst_RegFile_ConfigMem.Inst_frame1_bit0.Q BD0 sg13g2_o21ai_1
X_2256_ Inst_RegFile_ConfigMem.Inst_frame3_bit0.Q E2END[1] _0857_ VPWR VGND sg13g2_nor2b_1
XFILLER_31_228 VPWR VGND sg13g2_fill_1
Xclkbuf_5_27__f_UserCLK_regs clknet_4_13_0_UserCLK_regs clknet_5_27__leaf_UserCLK_regs
+ VPWR VGND sg13g2_buf_8
X_3090_ FrameData[22] FrameStrobe[3] Inst_RegFile_ConfigMem.Inst_frame3_bit22.Q VPWR
+ VGND sg13g2_dlhq_1
X_2041_ Inst_RegFile_ConfigMem.Inst_frame1_bit8.Q N1END[1] N2END[3] NN4END[2] E2END[3]
+ Inst_RegFile_ConfigMem.Inst_frame1_bit9.Q _0655_ VPWR VGND sg13g2_mux4_1
X_2110_ Inst_RegFile_ConfigMem.Inst_frame1_bit5.Q N1END[0] E2END[2] N2END[2] E6END[0]
+ Inst_RegFile_ConfigMem.Inst_frame1_bit4.Q _0720_ VPWR VGND sg13g2_mux4_1
X_2943_ FrameData[3] FrameStrobe[7] Inst_RegFile_ConfigMem.Inst_frame7_bit3.Q VPWR
+ VGND sg13g2_dlhq_1
X_1756_ _0386_ VPWR _0387_ VGND Inst_RegFile_ConfigMem.Inst_frame2_bit26.Q _0381_
+ sg13g2_o21ai_1
X_1825_ Inst_RegFile_switch_matrix.JW2BEG6 _0450_ _0452_ _0448_ _0445_ VPWR VGND sg13g2_a22oi_1
X_2874_ FrameData[30] FrameStrobe[10] Inst_RegFile_ConfigMem.Inst_frame10_bit30.Q
+ VPWR VGND sg13g2_dlhq_1
X_3426_ EE4END[6] net41 VPWR VGND sg13g2_buf_1
X_2308_ VGND VPWR Inst_RegFile_ConfigMem.Inst_frame9_bit12.Q AD3 _0905_ _0904_ sg13g2_a21oi_1
X_1687_ VPWR VGND _0320_ _0236_ _0318_ _0315_ _0321_ _0316_ sg13g2_a221oi_1
X_3357_ VPWR VGND _1339_ sg13g2_tiehi
X_2239_ Inst_RegFile_ConfigMem.Inst_frame3_bit30.Q VPWR _0841_ VGND Inst_RegFile_ConfigMem.Inst_frame3_bit29.Q
+ _0840_ sg13g2_o21ai_1
X_3288_ VPWR VGND _1270_ sg13g2_tiehi
X_2590_ _1065_ Inst_RegFile_32x4.mem\[17\]\[0\] _1107_ _0036_ VPWR VGND sg13g2_mux2_1
X_1610_ _0248_ _0249_ _0142_ _0250_ VPWR VGND sg13g2_mux2_1
X_1472_ _1228_ _1227_ Inst_RegFile_ConfigMem.Inst_frame2_bit23.Q VPWR VGND sg13g2_nand2b_1
X_3142_ FrameData[10] FrameStrobe[1] Inst_RegFile_ConfigMem.Inst_frame1_bit10.Q VPWR
+ VGND sg13g2_dlhq_1
XFILLER_5_43 VPWR VGND sg13g2_fill_1
X_3211_ _1272_ VGND VPWR _0083_ Inst_RegFile_32x4.mem\[29\]\[3\] clknet_5_14__leaf_UserCLK_regs
+ sg13g2_dfrbpq_1
X_1541_ VGND VPWR _1144_ _0180_ _0183_ Inst_RegFile_ConfigMem.Inst_frame8_bit17.Q
+ sg13g2_a21oi_1
X_2024_ Inst_RegFile_ConfigMem.Inst_frame8_bit10.Q VPWR _0639_ VGND Inst_RegFile_ConfigMem.Inst_frame0_bit17.Q
+ _0638_ sg13g2_o21ai_1
X_3073_ FrameData[5] FrameStrobe[3] Inst_RegFile_ConfigMem.Inst_frame3_bit5.Q VPWR
+ VGND sg13g2_dlhq_1
X_2926_ FrameData[18] FrameStrobe[8] Inst_RegFile_ConfigMem.Inst_frame8_bit18.Q VPWR
+ VGND sg13g2_dlhq_1
X_2857_ FrameData[13] FrameStrobe[10] Inst_RegFile_ConfigMem.Inst_frame10_bit13.Q
+ VPWR VGND sg13g2_dlhq_1
XFILLER_24_19 VPWR VGND sg13g2_fill_1
X_1739_ VGND VPWR Inst_RegFile_32x4.mem\[11\]\[0\] B_ADR0 _0370_ _0369_ sg13g2_a21oi_1
X_1808_ VGND VPWR Inst_RegFile_ConfigMem.Inst_frame6_bit30.Q W2MID[1] _0436_ _0435_
+ sg13g2_a21oi_1
X_2788_ FrameData[8] FrameStrobe[12] Inst_RegFile_ConfigMem.Inst_frame12_bit8.Q VPWR
+ VGND sg13g2_dlhq_1
X_3409_ E2MID[5] net18 VPWR VGND sg13g2_buf_1
XFILLER_26_397 VPWR VGND sg13g2_fill_2
XFILLER_14_52 VPWR VGND sg13g2_fill_1
XFILLER_30_73 VPWR VGND sg13g2_fill_1
XFILLER_29_180 VPWR VGND sg13g2_decap_8
X_2711_ _1358_ VGND VPWR _0005_ Inst_RegFile_32x4.mem\[25\]\[1\] clknet_5_6__leaf_UserCLK_regs
+ sg13g2_dfrbpq_1
X_2642_ _1067_ Inst_RegFile_32x4.mem\[19\]\[1\] _1118_ _0077_ VPWR VGND sg13g2_mux2_1
X_2573_ _1087_ Inst_RegFile_32x4.mem\[30\]\[3\] _1099_ _0027_ VPWR VGND sg13g2_mux2_1
X_1524_ _0166_ VPWR _0167_ VGND _0162_ _0164_ sg13g2_o21ai_1
X_3125_ FrameData[25] FrameStrobe[2] Inst_RegFile_ConfigMem.Inst_frame2_bit25.Q VPWR
+ VGND sg13g2_dlhq_1
X_1455_ A_ADR0 Inst_RegFile_32x4.mem\[8\]\[0\] _1211_ VPWR VGND sg13g2_nor2b_1
X_1386_ VPWR _1144_ Inst_RegFile_ConfigMem.Inst_frame8_bit16.Q VGND sg13g2_inv_1
X_3056_ FrameData[20] FrameStrobe[4] Inst_RegFile_ConfigMem.Inst_frame4_bit20.Q VPWR
+ VGND sg13g2_dlhq_1
X_2007_ VGND VPWR Inst_RegFile_ConfigMem.Inst_frame4_bit12.Q BD1 _0623_ _0622_ sg13g2_a21oi_1
X_2909_ FrameData[1] FrameStrobe[8] Inst_RegFile_ConfigMem.Inst_frame8_bit1.Q VPWR
+ VGND sg13g2_dlhq_1
XFILLER_25_51 VPWR VGND sg13g2_fill_1
XFILLER_2_44 VPWR VGND sg13g2_fill_2
XFILLER_2_33 VPWR VGND sg13g2_fill_2
Xclkbuf_4_0_0_UserCLK_regs clknet_0_UserCLK_regs clknet_4_0_0_UserCLK_regs VPWR VGND
+ sg13g2_buf_8
XANTENNA_27 VPWR VGND W2END[4] sg13g2_antennanp
XANTENNA_16 VPWR VGND S4END[9] sg13g2_antennanp
XFILLER_9_360 VPWR VGND sg13g2_fill_1
XANTENNA_49 VPWR VGND WW4END[4] sg13g2_antennanp
XANTENNA_38 VPWR VGND W6END[8] sg13g2_antennanp
Xoutput123 net123 N4BEG[11] VPWR VGND sg13g2_buf_1
Xoutput134 net134 N4BEG[7] VPWR VGND sg13g2_buf_1
Xoutput112 net112 N2BEG[7] VPWR VGND sg13g2_buf_1
Xoutput145 net145 NN4BEG[2] VPWR VGND sg13g2_buf_1
Xoutput101 net101 N1BEG[0] VPWR VGND sg13g2_buf_1
X_2625_ _1115_ _1088_ _1097_ VPWR VGND sg13g2_nand2_1
X_2487_ VGND VPWR _1041_ _1040_ _1039_ sg13g2_or2_1
Xoutput167 net167 S2BEGb[2] VPWR VGND sg13g2_buf_1
Xoutput156 net156 S1BEG[3] VPWR VGND sg13g2_buf_1
Xoutput178 net178 S4BEG[14] VPWR VGND sg13g2_buf_1
Xoutput189 net189 SS4BEG[0] VPWR VGND sg13g2_buf_1
X_2556_ _1030_ _1033_ _1094_ VPWR VGND sg13g2_nor2b_1
X_1507_ _0151_ BD0 Inst_RegFile_ConfigMem.Inst_frame1_bit12.Q VPWR VGND sg13g2_nand2b_1
X_3108_ FrameData[8] FrameStrobe[2] Inst_RegFile_ConfigMem.Inst_frame2_bit8.Q VPWR
+ VGND sg13g2_dlhq_1
X_1438_ Inst_RegFile_ConfigMem.Inst_frame3_bit14.Q VPWR _1195_ VGND _1193_ _1194_
+ sg13g2_o21ai_1
X_3039_ FrameData[3] FrameStrobe[4] Inst_RegFile_ConfigMem.Inst_frame4_bit3.Q VPWR
+ VGND sg13g2_dlhq_1
XFILLER_7_319 VPWR VGND sg13g2_fill_2
XFILLER_2_4 VPWR VGND sg13g2_fill_1
XFILLER_34_407 VPWR VGND sg13g2_fill_1
XFILLER_10_370 VPWR VGND sg13g2_fill_2
X_3390_ VPWR VGND _1372_ sg13g2_tiehi
X_2410_ Inst_RegFile_ConfigMem.Inst_frame11_bit8.Q N1END[2] E1END[2] S1END[2] AD1
+ Inst_RegFile_ConfigMem.Inst_frame11_bit9.Q _0993_ VPWR VGND sg13g2_mux4_1
X_2341_ Inst_RegFile_ConfigMem.Inst_frame9_bit0.Q N1END[2] S1END[2] W1END[2] AD1 Inst_RegFile_ConfigMem.Inst_frame9_bit1.Q
+ _0934_ VPWR VGND sg13g2_mux4_1
X_2272_ E2END[0] S1END[0] Inst_RegFile_ConfigMem.Inst_frame4_bit28.Q _0872_ VPWR VGND
+ sg13g2_mux2_1
X_1987_ Inst_RegFile_ConfigMem.Inst_frame8_bit22.Q VPWR _0604_ VGND Inst_RegFile_ConfigMem.Inst_frame8_bit21.Q
+ _0603_ sg13g2_o21ai_1
X_3588_ SS4END[12] net203 VPWR VGND sg13g2_buf_1
X_2608_ _1069_ Inst_RegFile_32x4.mem\[14\]\[2\] _1111_ _0050_ VPWR VGND sg13g2_mux2_1
X_2539_ _1089_ _1034_ _1088_ VPWR VGND sg13g2_nand2_1
X_2890_ FrameData[14] FrameStrobe[9] Inst_RegFile_ConfigMem.Inst_frame9_bit14.Q VPWR
+ VGND sg13g2_dlhq_1
X_1910_ B_ADR0 Inst_RegFile_32x4.mem\[24\]\[3\] _0532_ VPWR VGND sg13g2_nor2b_1
X_3511_ N2MID[7] net120 VPWR VGND sg13g2_buf_1
X_1841_ _0467_ VPWR _0468_ VGND Inst_RegFile_ConfigMem.Inst_frame4_bit25.Q _0466_
+ sg13g2_o21ai_1
X_1772_ Inst_RegFile_ConfigMem.Inst_frame2_bit19.Q VPWR _0402_ VGND _0400_ _0401_
+ sg13g2_o21ai_1
XFILLER_8_87 VPWR VGND sg13g2_fill_1
X_3442_ FrameData[2] net71 VPWR VGND sg13g2_buf_1
X_2324_ Inst_RegFile_ConfigMem.Inst_frame9_bit9.Q BD0 _1229_ _0388_ _0919_ Inst_RegFile_ConfigMem.Inst_frame9_bit10.Q
+ _0920_ VPWR VGND sg13g2_mux4_1
X_3373_ VPWR VGND _1355_ sg13g2_tiehi
XFILLER_26_0 VPWR VGND sg13g2_fill_2
X_2186_ VGND VPWR Inst_RegFile_ConfigMem.Inst_frame1_bit0.Q _1164_ _0791_ Inst_RegFile_ConfigMem.Inst_frame1_bit1.Q
+ sg13g2_a21oi_1
X_2255_ _0855_ VPWR _0856_ VGND Inst_RegFile_ConfigMem.Inst_frame3_bit2.Q _0849_ sg13g2_o21ai_1
XFILLER_0_358 VPWR VGND sg13g2_fill_2
Xclkbuf_5_14__f_UserCLK_regs clknet_4_7_0_UserCLK_regs clknet_5_14__leaf_UserCLK_regs
+ VPWR VGND sg13g2_buf_8
X_2040_ _0648_ _0653_ Inst_RegFile_ConfigMem.Inst_frame1_bit11.Q _0654_ VPWR VGND
+ sg13g2_nand3_1
XFILLER_30_251 VPWR VGND sg13g2_fill_1
X_2873_ FrameData[29] FrameStrobe[10] Inst_RegFile_ConfigMem.Inst_frame10_bit29.Q
+ VPWR VGND sg13g2_dlhq_1
X_2942_ FrameData[2] FrameStrobe[7] Inst_RegFile_ConfigMem.Inst_frame7_bit2.Q VPWR
+ VGND sg13g2_dlhq_1
X_1755_ VGND VPWR _0384_ _0385_ _0386_ Inst_RegFile_ConfigMem.Inst_frame2_bit27.Q
+ sg13g2_a21oi_1
X_1824_ VGND VPWR Inst_RegFile_ConfigMem.Inst_frame1_bit26.Q _0451_ _0452_ Inst_RegFile_ConfigMem.Inst_frame1_bit27.Q
+ sg13g2_a21oi_1
X_1686_ VGND VPWR _0142_ _0319_ _0320_ _0185_ sg13g2_a21oi_1
X_3425_ EE4END[5] net40 VPWR VGND sg13g2_buf_1
X_2307_ Inst_RegFile_ConfigMem.Inst_frame9_bit12.Q AD2 _0904_ VPWR VGND sg13g2_nor2b_1
X_2238_ VGND VPWR Inst_RegFile_ConfigMem.Inst_frame3_bit28.Q BD0 _0840_ _0839_ sg13g2_a21oi_1
X_3356_ VPWR VGND _1338_ sg13g2_tiehi
X_3287_ VPWR VGND _1269_ sg13g2_tiehi
X_2169_ VPWR VGND _0774_ Inst_RegFile_ConfigMem.Inst_frame1_bit30.Q _0773_ Inst_RegFile_ConfigMem.Inst_frame1_bit29.Q
+ _0775_ _0772_ sg13g2_a221oi_1
X_1540_ _0182_ Inst_RegFile_ConfigMem.Inst_frame8_bit16.Q _0181_ VPWR VGND sg13g2_nand2_1
X_1471_ Inst_RegFile_ConfigMem.Inst_frame2_bit22.Q _1224_ _1226_ _1223_ _1225_ Inst_RegFile_ConfigMem.Inst_frame2_bit21.Q
+ _1227_ VPWR VGND sg13g2_mux4_1
X_3141_ FrameData[9] FrameStrobe[1] Inst_RegFile_ConfigMem.Inst_frame1_bit9.Q VPWR
+ VGND sg13g2_dlhq_1
X_3210_ _1273_ VGND VPWR _0082_ Inst_RegFile_32x4.mem\[29\]\[2\] clknet_5_12__leaf_UserCLK_regs
+ sg13g2_dfrbpq_1
XFILLER_50_313 VPWR VGND sg13g2_fill_1
X_2023_ VGND VPWR E2END[3] Inst_RegFile_ConfigMem.Inst_frame0_bit16.Q _0638_ _0637_
+ sg13g2_a21oi_1
X_3072_ FrameData[4] FrameStrobe[3] Inst_RegFile_ConfigMem.Inst_frame3_bit4.Q VPWR
+ VGND sg13g2_dlhq_1
XFILLER_40_19 VPWR VGND sg13g2_fill_1
X_1807_ Inst_RegFile_ConfigMem.Inst_frame6_bit30.Q S2MID[1] _0435_ VPWR VGND sg13g2_nor2b_1
X_2856_ FrameData[12] FrameStrobe[10] Inst_RegFile_ConfigMem.Inst_frame10_bit12.Q
+ VPWR VGND sg13g2_dlhq_1
X_2925_ FrameData[17] FrameStrobe[8] Inst_RegFile_ConfigMem.Inst_frame8_bit17.Q VPWR
+ VGND sg13g2_dlhq_1
X_1738_ B_ADR0 Inst_RegFile_32x4.mem\[10\]\[0\] _0369_ VPWR VGND sg13g2_nor2b_1
X_1669_ A_ADR0 Inst_RegFile_32x4.mem\[20\]\[2\] _0305_ VPWR VGND sg13g2_nor2b_1
X_2787_ FrameData[7] FrameStrobe[12] Inst_RegFile_ConfigMem.Inst_frame12_bit7.Q VPWR
+ VGND sg13g2_dlhq_1
X_3408_ E2MID[4] net17 VPWR VGND sg13g2_buf_1
X_3339_ VPWR VGND _1321_ sg13g2_tiehi
XFILLER_30_52 VPWR VGND sg13g2_fill_2
XFILLER_17_332 VPWR VGND sg13g2_fill_1
X_2710_ _1359_ VGND VPWR _0004_ Inst_RegFile_32x4.mem\[25\]\[0\] clknet_5_13__leaf_UserCLK_regs
+ sg13g2_dfrbpq_1
X_1454_ _1210_ _1206_ _1209_ _1184_ _1181_ VPWR VGND sg13g2_a22oi_1
X_2641_ _1065_ Inst_RegFile_32x4.mem\[19\]\[0\] _1118_ _0076_ VPWR VGND sg13g2_mux2_1
X_2572_ _1069_ Inst_RegFile_32x4.mem\[30\]\[2\] _1099_ _0026_ VPWR VGND sg13g2_mux2_1
X_1523_ VGND VPWR _1144_ _0165_ _0166_ _1145_ sg13g2_a21oi_1
X_3124_ FrameData[24] FrameStrobe[2] Inst_RegFile_ConfigMem.Inst_frame2_bit24.Q VPWR
+ VGND sg13g2_dlhq_1
X_3055_ FrameData[19] FrameStrobe[4] Inst_RegFile_ConfigMem.Inst_frame4_bit19.Q VPWR
+ VGND sg13g2_dlhq_1
X_1385_ VPWR _1143_ Inst_RegFile_ConfigMem.Inst_frame2_bit14.Q VGND sg13g2_inv_1
XFILLER_35_19 VPWR VGND sg13g2_fill_2
X_2006_ Inst_RegFile_ConfigMem.Inst_frame4_bit12.Q BD0 _0622_ VPWR VGND sg13g2_nor2b_1
X_2839_ FrameData[27] FrameStrobe[11] Inst_RegFile_ConfigMem.Inst_frame11_bit27.Q
+ VPWR VGND sg13g2_dlhq_1
X_2908_ FrameData[0] FrameStrobe[8] Inst_RegFile_ConfigMem.Inst_frame8_bit0.Q VPWR
+ VGND sg13g2_dlhq_1
XFILLER_2_217 VPWR VGND sg13g2_fill_2
XANTENNA_17 VPWR VGND W2END[3] sg13g2_antennanp
X_2624_ _1087_ Inst_RegFile_32x4.mem\[18\]\[3\] _1114_ _0063_ VPWR VGND sg13g2_mux2_1
XANTENNA_39 VPWR VGND W6END[9] sg13g2_antennanp
XFILLER_20_349 VPWR VGND sg13g2_fill_2
XANTENNA_28 VPWR VGND W2END[4] sg13g2_antennanp
Xoutput146 net146 NN4BEG[3] VPWR VGND sg13g2_buf_1
Xoutput124 net124 N4BEG[12] VPWR VGND sg13g2_buf_1
Xoutput135 net135 N4BEG[8] VPWR VGND sg13g2_buf_1
Xoutput102 net102 N1BEG[1] VPWR VGND sg13g2_buf_1
X_2486_ Inst_RegFile_ConfigMem.Inst_frame9_bit29.Q VPWR _1040_ VGND Inst_RegFile_ConfigMem.Inst_frame9_bit28.Q
+ _0981_ sg13g2_o21ai_1
X_1437_ Inst_RegFile_ConfigMem.Inst_frame3_bit13.Q VPWR _1194_ VGND Inst_RegFile_ConfigMem.Inst_frame3_bit12.Q
+ BD2 sg13g2_o21ai_1
Xoutput113 net113 N2BEGb[0] VPWR VGND sg13g2_buf_1
X_1506_ _0150_ Inst_RegFile_ConfigMem.Inst_frame1_bit12.Q BD1 VPWR VGND sg13g2_nand2_1
Xoutput168 net168 S2BEGb[3] VPWR VGND sg13g2_buf_1
Xoutput157 net157 S2BEG[0] VPWR VGND sg13g2_buf_1
Xoutput179 net179 S4BEG[15] VPWR VGND sg13g2_buf_1
X_2555_ _1087_ Inst_RegFile_32x4.mem\[27\]\[3\] _1093_ _0015_ VPWR VGND sg13g2_mux2_1
XFILLER_43_419 VPWR VGND sg13g2_fill_2
X_3107_ FrameData[7] FrameStrobe[2] Inst_RegFile_ConfigMem.Inst_frame2_bit7.Q VPWR
+ VGND sg13g2_dlhq_1
X_3038_ FrameData[2] FrameStrobe[4] Inst_RegFile_ConfigMem.Inst_frame4_bit2.Q VPWR
+ VGND sg13g2_dlhq_1
XFILLER_11_54 VPWR VGND sg13g2_fill_2
XFILLER_42_430 VPWR VGND sg13g2_fill_1
XFILLER_14_121 VPWR VGND sg13g2_fill_2
XFILLER_52_61 VPWR VGND sg13g2_fill_2
X_2271_ Inst_RegFile_ConfigMem.Inst_frame4_bit31.Q VPWR _0871_ VGND Inst_RegFile_ConfigMem.Inst_frame4_bit30.Q
+ _0870_ sg13g2_o21ai_1
X_2340_ Inst_RegFile_ConfigMem.Inst_frame9_bit1.Q BD1 _0910_ _0911_ _0408_ Inst_RegFile_ConfigMem.Inst_frame9_bit0.Q
+ _0933_ VPWR VGND sg13g2_mux4_1
X_1986_ Inst_RegFile_ConfigMem.Inst_frame5_bit24.Q N2END[7] E2END[7] S2END[7] WW4END[0]
+ Inst_RegFile_ConfigMem.Inst_frame5_bit25.Q _0603_ VPWR VGND sg13g2_mux4_1
XFILLER_33_485 VPWR VGND sg13g2_fill_1
X_3587_ SS4END[11] net202 VPWR VGND sg13g2_buf_1
X_2607_ _1067_ Inst_RegFile_32x4.mem\[14\]\[1\] _1111_ _0049_ VPWR VGND sg13g2_mux2_1
Xclkbuf_5_22__f_UserCLK_regs clknet_4_11_0_UserCLK_regs clknet_5_22__leaf_UserCLK_regs
+ VPWR VGND sg13g2_buf_8
X_2538_ _1047_ _1058_ _1059_ _1088_ VPWR VGND sg13g2_nor3_1
X_2469_ N2END[0] S2END[0] Inst_RegFile_ConfigMem.Inst_frame8_bit4.Q _1023_ VPWR VGND
+ sg13g2_mux2_1
XFILLER_47_83 VPWR VGND sg13g2_fill_1
X_1840_ VGND VPWR Inst_RegFile_ConfigMem.Inst_frame4_bit25.Q _0464_ _0467_ Inst_RegFile_ConfigMem.Inst_frame4_bit26.Q
+ sg13g2_a21oi_1
XFILLER_42_282 VPWR VGND sg13g2_fill_2
X_3510_ N2MID[6] net119 VPWR VGND sg13g2_buf_1
X_1771_ Inst_RegFile_ConfigMem.Inst_frame2_bit18.Q VPWR _0401_ VGND _0396_ _0397_
+ sg13g2_o21ai_1
X_3441_ FrameData[1] net60 VPWR VGND sg13g2_buf_1
X_2254_ _0854_ Inst_RegFile_ConfigMem.Inst_frame3_bit3.Q _0855_ VPWR VGND sg13g2_nor2b_1
X_3372_ VPWR VGND _1354_ sg13g2_tiehi
X_2323_ Inst_RegFile_ConfigMem.Inst_frame5_bit5.Q N2END[4] S2END[4] EE4END[0] W2END[4]
+ Inst_RegFile_ConfigMem.Inst_frame5_bit4.Q _0919_ VPWR VGND sg13g2_mux4_1
XFILLER_43_19 VPWR VGND sg13g2_fill_1
X_2185_ VPWR VGND _0789_ Inst_RegFile_ConfigMem.Inst_frame1_bit2.Q _0788_ Inst_RegFile_ConfigMem.Inst_frame1_bit1.Q
+ _0790_ _0787_ sg13g2_a221oi_1
XFILLER_19_0 VPWR VGND sg13g2_fill_1
X_1969_ _0587_ Inst_RegFile_ConfigMem.Inst_frame4_bit16.Q AD2 VPWR VGND sg13g2_nand2_1
X_3639_ WW4END[14] net239 VPWR VGND sg13g2_buf_1
X_1823_ Inst_RegFile_ConfigMem.Inst_frame1_bit25.Q S1END[1] S2END[7] S1END[3] W1END[3]
+ Inst_RegFile_ConfigMem.Inst_frame1_bit24.Q _0451_ VPWR VGND sg13g2_mux4_1
X_2941_ FrameData[1] FrameStrobe[7] Inst_RegFile_ConfigMem.Inst_frame7_bit1.Q VPWR
+ VGND sg13g2_dlhq_1
XFILLER_30_274 VPWR VGND sg13g2_fill_2
X_2872_ FrameData[28] FrameStrobe[10] Inst_RegFile_ConfigMem.Inst_frame10_bit28.Q
+ VPWR VGND sg13g2_dlhq_1
X_1685_ A_ADR0 Inst_RegFile_32x4.mem\[6\]\[3\] Inst_RegFile_32x4.mem\[7\]\[3\] Inst_RegFile_32x4.mem\[4\]\[3\]
+ Inst_RegFile_32x4.mem\[5\]\[3\] _1210_ _0319_ VPWR VGND sg13g2_mux4_1
X_1754_ VGND VPWR Inst_RegFile_ConfigMem.Inst_frame2_bit25.Q _0382_ _0385_ _1136_
+ sg13g2_a21oi_1
X_3424_ EE4END[4] net33 VPWR VGND sg13g2_buf_1
XFILLER_38_352 VPWR VGND sg13g2_fill_1
X_2306_ VPWR VGND Inst_RegFile_ConfigMem.Inst_frame9_bit13.Q Inst_RegFile_ConfigMem.Inst_frame9_bit14.Q
+ _0902_ _0899_ _0903_ _0900_ sg13g2_a221oi_1
X_2237_ Inst_RegFile_ConfigMem.Inst_frame3_bit28.Q AD3 _0839_ VPWR VGND sg13g2_nor2b_1
X_3286_ VPWR VGND _1268_ sg13g2_tiehi
X_3355_ VPWR VGND _1337_ sg13g2_tiehi
XFILLER_53_311 VPWR VGND sg13g2_fill_1
X_2168_ VGND VPWR Inst_RegFile_ConfigMem.Inst_frame1_bit28.Q _1166_ _0774_ Inst_RegFile_ConfigMem.Inst_frame1_bit29.Q
+ sg13g2_a21oi_1
X_2099_ AD2 AD3 Inst_RegFile_ConfigMem.Inst_frame1_bit4.Q _0709_ VPWR VGND sg13g2_mux2_1
X_1470_ S1END[2] S2END[6] Inst_RegFile_ConfigMem.Inst_frame2_bit20.Q _1226_ VPWR VGND
+ sg13g2_mux2_1
X_3140_ FrameData[8] FrameStrobe[1] Inst_RegFile_ConfigMem.Inst_frame1_bit8.Q VPWR
+ VGND sg13g2_dlhq_1
X_3071_ FrameData[3] FrameStrobe[3] Inst_RegFile_ConfigMem.Inst_frame3_bit3.Q VPWR
+ VGND sg13g2_dlhq_1
X_2022_ Inst_RegFile_ConfigMem.Inst_frame0_bit16.Q N4END[3] _0637_ VPWR VGND sg13g2_nor2b_1
X_2786_ FrameData[6] FrameStrobe[12] Inst_RegFile_ConfigMem.Inst_frame12_bit6.Q VPWR
+ VGND sg13g2_dlhq_1
X_1806_ _0430_ Inst_RegFile_ConfigMem.Inst_frame8_bit27.Q _0433_ _0434_ VPWR VGND
+ sg13g2_a21o_1
X_2924_ FrameData[16] FrameStrobe[8] Inst_RegFile_ConfigMem.Inst_frame8_bit16.Q VPWR
+ VGND sg13g2_dlhq_1
X_2855_ FrameData[11] FrameStrobe[10] Inst_RegFile_ConfigMem.Inst_frame10_bit11.Q
+ VPWR VGND sg13g2_dlhq_1
X_1599_ _0239_ Inst_RegFile_32x4.mem\[2\]\[0\] A_ADR0 VPWR VGND sg13g2_nand2b_1
X_1737_ _0368_ _0341_ _0366_ VPWR VGND sg13g2_nand2_1
X_3338_ VPWR VGND _1320_ sg13g2_tiehi
X_3407_ E2MID[3] net16 VPWR VGND sg13g2_buf_1
X_1668_ A_ADR0 Inst_RegFile_32x4.mem\[18\]\[2\] Inst_RegFile_32x4.mem\[19\]\[2\] Inst_RegFile_32x4.mem\[16\]\[2\]
+ Inst_RegFile_32x4.mem\[17\]\[2\] _1210_ _0304_ VPWR VGND sg13g2_mux4_1
X_3269_ VPWR VGND _1251_ sg13g2_tiehi
XFILLER_26_399 VPWR VGND sg13g2_fill_1
XFILLER_26_377 VPWR VGND sg13g2_fill_2
XFILLER_14_87 VPWR VGND sg13g2_fill_1
X_2640_ _1118_ _1092_ _1106_ VPWR VGND sg13g2_nand2_1
X_1453_ _1208_ Inst_RegFile_ConfigMem.Inst_frame8_bit13.Q _1209_ VPWR VGND sg13g2_nor2b_1
X_1522_ Inst_RegFile_ConfigMem.Inst_frame5_bit22.Q NN4END[2] E2END[1] S2END[1] W2END[1]
+ Inst_RegFile_ConfigMem.Inst_frame5_bit23.Q _0165_ VPWR VGND sg13g2_mux4_1
X_2571_ _1067_ Inst_RegFile_32x4.mem\[30\]\[1\] _1099_ _0025_ VPWR VGND sg13g2_mux2_1
X_3123_ FrameData[23] FrameStrobe[2] Inst_RegFile_ConfigMem.Inst_frame2_bit23.Q VPWR
+ VGND sg13g2_dlhq_1
X_1384_ VPWR _1142_ Inst_RegFile_ConfigMem.Inst_frame2_bit22.Q VGND sg13g2_inv_1
X_3054_ FrameData[18] FrameStrobe[4] Inst_RegFile_ConfigMem.Inst_frame4_bit18.Q VPWR
+ VGND sg13g2_dlhq_1
XFILLER_35_130 VPWR VGND sg13g2_fill_1
X_2005_ _0620_ VPWR _0621_ VGND Inst_RegFile_ConfigMem.Inst_frame4_bit13.Q _0619_
+ sg13g2_o21ai_1
XFILLER_50_166 VPWR VGND sg13g2_fill_2
X_2907_ FrameData[31] FrameStrobe[9] Inst_RegFile_ConfigMem.Inst_frame9_bit31.Q VPWR
+ VGND sg13g2_dlhq_1
X_2838_ FrameData[26] FrameStrobe[11] Inst_RegFile_ConfigMem.Inst_frame11_bit26.Q
+ VPWR VGND sg13g2_dlhq_1
X_2769_ _1292_ VGND VPWR _0063_ Inst_RegFile_32x4.mem\[18\]\[3\] clknet_5_3__leaf_UserCLK_regs
+ sg13g2_dfrbpq_1
XANTENNA_18 VPWR VGND W2END[3] sg13g2_antennanp
XANTENNA_29 VPWR VGND W2END[4] sg13g2_antennanp
Xoutput125 net125 N4BEG[13] VPWR VGND sg13g2_buf_1
Xoutput114 net114 N2BEGb[1] VPWR VGND sg13g2_buf_1
Xoutput103 net103 N1BEG[2] VPWR VGND sg13g2_buf_1
Xclkbuf_5_30__f_UserCLK_regs clknet_4_15_0_UserCLK_regs clknet_5_30__leaf_UserCLK_regs
+ VPWR VGND sg13g2_buf_8
X_2623_ _1069_ Inst_RegFile_32x4.mem\[18\]\[2\] _1114_ _0062_ VPWR VGND sg13g2_mux2_1
X_2554_ _1069_ Inst_RegFile_32x4.mem\[27\]\[2\] _1093_ _0014_ VPWR VGND sg13g2_mux2_1
Xoutput147 net147 NN4BEG[4] VPWR VGND sg13g2_buf_1
Xoutput136 net136 N4BEG[9] VPWR VGND sg13g2_buf_1
XFILLER_49_0 VPWR VGND sg13g2_fill_1
X_2485_ VGND VPWR Inst_RegFile_ConfigMem.Inst_frame0_bit9.Q _1035_ _1039_ _1038_ sg13g2_a21oi_1
Xoutput169 net169 S2BEGb[4] VPWR VGND sg13g2_buf_1
Xoutput158 net158 S2BEG[1] VPWR VGND sg13g2_buf_1
X_1436_ BD3 Inst_RegFile_ConfigMem.Inst_frame3_bit12.Q _1193_ VPWR VGND sg13g2_nor2b_1
X_1505_ VPWR VGND _0148_ Inst_RegFile_ConfigMem.Inst_frame1_bit14.Q _0147_ Inst_RegFile_ConfigMem.Inst_frame1_bit13.Q
+ _0149_ _0146_ sg13g2_a221oi_1
X_3106_ FrameData[6] FrameStrobe[2] Inst_RegFile_ConfigMem.Inst_frame2_bit6.Q VPWR
+ VGND sg13g2_dlhq_1
X_3037_ FrameData[1] FrameStrobe[4] Inst_RegFile_ConfigMem.Inst_frame4_bit1.Q VPWR
+ VGND sg13g2_dlhq_1
XFILLER_23_155 VPWR VGND sg13g2_decap_4
X_2270_ Inst_RegFile_ConfigMem.Inst_frame4_bit28.Q W1END[2] AD0 AD1 AD2 Inst_RegFile_ConfigMem.Inst_frame4_bit29.Q
+ _0870_ VPWR VGND sg13g2_mux4_1
X_1985_ VGND VPWR Inst_RegFile_ConfigMem.Inst_frame0_bit25.Q _0598_ _0602_ _0601_
+ sg13g2_a21oi_1
X_3586_ SS4END[10] net201 VPWR VGND sg13g2_buf_1
X_2606_ _1065_ Inst_RegFile_32x4.mem\[14\]\[0\] _1111_ _0048_ VPWR VGND sg13g2_mux2_1
X_2537_ _1087_ Inst_RegFile_32x4.mem\[24\]\[3\] _1062_ _0003_ VPWR VGND sg13g2_mux2_1
X_1419_ Inst_RegFile_ConfigMem.Inst_frame3_bit20.Q N1END[2] N2END[6] E1END[2] E2END[6]
+ Inst_RegFile_ConfigMem.Inst_frame3_bit21.Q _1177_ VPWR VGND sg13g2_mux4_1
X_2399_ Inst_RegFile_ConfigMem.Inst_frame11_bit14.Q _1165_ _0984_ VPWR VGND sg13g2_nor2_1
X_2468_ Inst_RegFile_ConfigMem.Inst_frame8_bit5.Q VPWR _1022_ VGND _1161_ _1231_ sg13g2_o21ai_1
XFILLER_36_291 VPWR VGND sg13g2_fill_1
X_1770_ VGND VPWR _0398_ _0399_ _0400_ Inst_RegFile_ConfigMem.Inst_frame2_bit17.Q
+ sg13g2_a21oi_1
X_3440_ FrameData[0] net49 VPWR VGND sg13g2_buf_1
X_3371_ VPWR VGND _1353_ sg13g2_tiehi
X_2322_ Inst_RegFile_switch_matrix.W6BEG0 _0916_ _0918_ _0909_ _1152_ VPWR VGND sg13g2_a22oi_1
X_2184_ VGND VPWR Inst_RegFile_ConfigMem.Inst_frame1_bit0.Q _1167_ _0789_ Inst_RegFile_ConfigMem.Inst_frame1_bit1.Q
+ sg13g2_a21oi_1
X_2253_ VGND VPWR Inst_RegFile_ConfigMem.Inst_frame3_bit1.Q _0852_ _0854_ _0853_ sg13g2_a21oi_1
X_1899_ B_ADR0 Inst_RegFile_32x4.mem\[8\]\[1\] Inst_RegFile_32x4.mem\[9\]\[1\] Inst_RegFile_32x4.mem\[10\]\[1\]
+ Inst_RegFile_32x4.mem\[11\]\[1\] _0368_ _0523_ VPWR VGND sg13g2_mux4_1
X_1968_ _0583_ _0585_ Inst_RegFile_ConfigMem.Inst_frame4_bit18.Q _0586_ VPWR VGND
+ sg13g2_nand3_1
XFILLER_21_456 VPWR VGND sg13g2_fill_2
X_3638_ WW4END[13] net253 VPWR VGND sg13g2_buf_1
X_3569_ S4END[9] net184 VPWR VGND sg13g2_buf_1
XFILLER_48_309 VPWR VGND sg13g2_fill_2
XFILLER_12_445 VPWR VGND sg13g2_fill_1
XFILLER_47_364 VPWR VGND sg13g2_fill_2
X_2940_ FrameData[0] FrameStrobe[7] Inst_RegFile_ConfigMem.Inst_frame7_bit0.Q VPWR
+ VGND sg13g2_dlhq_1
X_1822_ _0450_ _0449_ Inst_RegFile_ConfigMem.Inst_frame1_bit26.Q VPWR VGND sg13g2_nand2b_1
X_1753_ _0384_ _0383_ Inst_RegFile_ConfigMem.Inst_frame2_bit25.Q VPWR VGND sg13g2_nand2b_1
X_2871_ FrameData[27] FrameStrobe[10] Inst_RegFile_ConfigMem.Inst_frame10_bit27.Q
+ VPWR VGND sg13g2_dlhq_1
X_1684_ _0318_ _0143_ _0317_ VPWR VGND sg13g2_nand2_1
X_3423_ Inst_RegFile_switch_matrix.E6BEG1 net23 VPWR VGND sg13g2_buf_1
XFILLER_31_0 VPWR VGND sg13g2_fill_2
X_3354_ VPWR VGND _1336_ sg13g2_tiehi
X_3285_ VPWR VGND _1267_ sg13g2_tiehi
XFILLER_38_386 VPWR VGND sg13g2_fill_2
X_2305_ VGND VPWR W1END[3] Inst_RegFile_ConfigMem.Inst_frame9_bit12.Q _0902_ _0901_
+ sg13g2_a21oi_1
X_2236_ _0837_ VPWR _0838_ VGND Inst_RegFile_ConfigMem.Inst_frame3_bit28.Q _1164_
+ sg13g2_o21ai_1
X_2167_ VGND VPWR _0773_ Inst_RegFile_ConfigMem.Inst_frame1_bit28.Q WW4END[0] sg13g2_or2_1
XFILLER_53_334 VPWR VGND sg13g2_fill_2
X_2098_ _0708_ VPWR Inst_RegFile_switch_matrix.JN2BEG2 VGND _0695_ _0701_ sg13g2_o21ai_1
XFILLER_28_20 VPWR VGND sg13g2_fill_1
XFILLER_44_41 VPWR VGND sg13g2_fill_1
XFILLER_8_268 VPWR VGND sg13g2_fill_1
X_2021_ W2END[3] Inst_RegFile_switch_matrix.JN2BEG3 Inst_RegFile_ConfigMem.Inst_frame0_bit16.Q
+ _0636_ VPWR VGND sg13g2_mux2_1
X_3070_ FrameData[2] FrameStrobe[3] Inst_RegFile_ConfigMem.Inst_frame3_bit2.Q VPWR
+ VGND sg13g2_dlhq_1
X_2923_ FrameData[15] FrameStrobe[8] Inst_RegFile_ConfigMem.Inst_frame8_bit15.Q VPWR
+ VGND sg13g2_dlhq_1
X_1736_ _0341_ _0366_ _0367_ VPWR VGND sg13g2_and2_1
X_1805_ Inst_RegFile_ConfigMem.Inst_frame8_bit28.Q VPWR _0433_ VGND Inst_RegFile_ConfigMem.Inst_frame8_bit27.Q
+ _0431_ sg13g2_o21ai_1
X_2854_ FrameData[10] FrameStrobe[10] Inst_RegFile_ConfigMem.Inst_frame10_bit10.Q
+ VPWR VGND sg13g2_dlhq_1
X_2785_ FrameData[5] FrameStrobe[12] Inst_RegFile_ConfigMem.Inst_frame12_bit5.Q VPWR
+ VGND sg13g2_dlhq_1
X_1598_ VGND VPWR Inst_RegFile_32x4.mem\[1\]\[0\] A_ADR0 _0238_ _0237_ sg13g2_a21oi_1
X_3406_ E2MID[2] net15 VPWR VGND sg13g2_buf_1
X_3337_ VPWR VGND _1319_ sg13g2_tiehi
X_1667_ VGND VPWR _0143_ _0300_ _0303_ _0186_ sg13g2_a21oi_1
X_3268_ VPWR VGND _1250_ sg13g2_tiehi
X_2219_ VGND VPWR Inst_RegFile_ConfigMem.Inst_frame2_bit0.Q _1164_ _0822_ Inst_RegFile_ConfigMem.Inst_frame2_bit1.Q
+ sg13g2_a21oi_1
X_3199_ _1319_ VGND VPWR Inst_RegFile_32x4.BD_comb\[3\] Inst_RegFile_32x4.BD_reg\[3\]
+ clknet_5_5__leaf_UserCLK_regs sg13g2_dfrbpq_1
XFILLER_30_21 VPWR VGND sg13g2_fill_2
X_2570_ _1065_ Inst_RegFile_32x4.mem\[30\]\[0\] _1099_ _0024_ VPWR VGND sg13g2_mux2_1
X_3122_ FrameData[22] FrameStrobe[2] Inst_RegFile_ConfigMem.Inst_frame2_bit22.Q VPWR
+ VGND sg13g2_dlhq_1
X_1383_ VPWR _1141_ Inst_RegFile_ConfigMem.Inst_frame3_bit22.Q VGND sg13g2_inv_1
X_1452_ Inst_RegFile_ConfigMem.Inst_frame8_bit12.Q _1207_ _1208_ VPWR VGND sg13g2_nor2_1
XFILLER_4_293 VPWR VGND sg13g2_fill_2
X_1521_ Inst_RegFile_ConfigMem.Inst_frame8_bit16.Q VPWR _0164_ VGND Inst_RegFile_ConfigMem.Inst_frame0_bit23.Q
+ _0163_ sg13g2_o21ai_1
X_3053_ FrameData[17] FrameStrobe[4] Inst_RegFile_ConfigMem.Inst_frame4_bit17.Q VPWR
+ VGND sg13g2_dlhq_1
XFILLER_35_153 VPWR VGND sg13g2_fill_1
X_2004_ VGND VPWR Inst_RegFile_ConfigMem.Inst_frame4_bit13.Q _0617_ _0620_ Inst_RegFile_ConfigMem.Inst_frame4_bit14.Q
+ sg13g2_a21oi_1
XFILLER_50_145 VPWR VGND sg13g2_fill_1
XFILLER_35_175 VPWR VGND sg13g2_fill_2
X_2906_ FrameData[30] FrameStrobe[9] Inst_RegFile_ConfigMem.Inst_frame9_bit30.Q VPWR
+ VGND sg13g2_dlhq_1
X_2837_ FrameData[25] FrameStrobe[11] Inst_RegFile_ConfigMem.Inst_frame11_bit25.Q
+ VPWR VGND sg13g2_dlhq_1
X_2699_ _1069_ Inst_RegFile_32x4.mem\[11\]\[2\] _1130_ _0122_ VPWR VGND sg13g2_mux2_1
X_1719_ Inst_RegFile_ConfigMem.Inst_frame3_bit16.Q N1END[1] N2END[5] E1END[1] E2END[5]
+ Inst_RegFile_ConfigMem.Inst_frame3_bit17.Q _0351_ VPWR VGND sg13g2_mux4_1
X_2768_ _1293_ VGND VPWR _0062_ Inst_RegFile_32x4.mem\[18\]\[2\] clknet_5_0__leaf_UserCLK_regs
+ sg13g2_dfrbpq_1
XFILLER_26_186 VPWR VGND sg13g2_decap_4
XFILLER_49_212 VPWR VGND sg13g2_fill_1
XFILLER_49_256 VPWR VGND sg13g2_fill_2
XANTENNA_19 VPWR VGND W2END[3] sg13g2_antennanp
XFILLER_32_178 VPWR VGND sg13g2_fill_2
Xoutput137 net137 NN4BEG[0] VPWR VGND sg13g2_buf_1
Xoutput115 net115 N2BEGb[2] VPWR VGND sg13g2_buf_1
Xoutput126 net126 N4BEG[14] VPWR VGND sg13g2_buf_1
Xoutput104 net104 N1BEG[3] VPWR VGND sg13g2_buf_1
Xoutput148 net148 NN4BEG[5] VPWR VGND sg13g2_buf_1
X_1504_ VGND VPWR Inst_RegFile_ConfigMem.Inst_frame1_bit12.Q _1166_ _0148_ Inst_RegFile_ConfigMem.Inst_frame1_bit13.Q
+ sg13g2_a21oi_1
Xoutput159 net159 S2BEG[2] VPWR VGND sg13g2_buf_1
X_2622_ _1067_ Inst_RegFile_32x4.mem\[18\]\[1\] _1114_ _0061_ VPWR VGND sg13g2_mux2_1
X_2553_ _1067_ Inst_RegFile_32x4.mem\[27\]\[1\] _1093_ _0013_ VPWR VGND sg13g2_mux2_1
X_2484_ Inst_RegFile_ConfigMem.Inst_frame9_bit28.Q VPWR _1038_ VGND Inst_RegFile_ConfigMem.Inst_frame0_bit9.Q
+ _1037_ sg13g2_o21ai_1
X_3105_ FrameData[5] FrameStrobe[2] Inst_RegFile_ConfigMem.Inst_frame2_bit5.Q VPWR
+ VGND sg13g2_dlhq_1
X_1435_ VGND VPWR _1190_ _1191_ _1192_ Inst_RegFile_ConfigMem.Inst_frame3_bit13.Q
+ sg13g2_a21oi_1
X_3036_ FrameData[0] FrameStrobe[4] Inst_RegFile_ConfigMem.Inst_frame4_bit0.Q VPWR
+ VGND sg13g2_dlhq_1
XFILLER_11_23 VPWR VGND sg13g2_fill_1
XFILLER_11_56 VPWR VGND sg13g2_fill_1
XFILLER_11_67 VPWR VGND sg13g2_fill_2
XFILLER_14_123 VPWR VGND sg13g2_fill_1
XFILLER_18_484 VPWR VGND sg13g2_fill_2
X_1984_ Inst_RegFile_ConfigMem.Inst_frame8_bit21.Q VPWR _0601_ VGND Inst_RegFile_ConfigMem.Inst_frame0_bit25.Q
+ _0600_ sg13g2_o21ai_1
X_3585_ SS4END[9] net200 VPWR VGND sg13g2_buf_1
X_2605_ _1111_ _1090_ _1103_ VPWR VGND sg13g2_nand2_1
X_2536_ _1086_ VPWR _1087_ VGND _1074_ _1075_ sg13g2_o21ai_1
X_2467_ Inst_RegFile_ConfigMem.Inst_frame8_bit4.Q _1180_ _1021_ VPWR VGND sg13g2_nor2_1
X_1418_ Inst_RegFile_ConfigMem.Inst_frame3_bit20.Q EE4END[2] S1END[0] S1END[2] S2END[6]
+ Inst_RegFile_ConfigMem.Inst_frame3_bit21.Q _1176_ VPWR VGND sg13g2_mux4_1
X_2398_ VGND VPWR _1158_ _0339_ _0983_ _0982_ sg13g2_a21oi_1
X_3019_ FrameData[15] FrameStrobe[5] Inst_RegFile_ConfigMem.Inst_frame5_bit15.Q VPWR
+ VGND sg13g2_dlhq_1
XFILLER_11_148 VPWR VGND sg13g2_fill_1
XFILLER_19_204 VPWR VGND sg13g2_fill_2
XFILLER_42_284 VPWR VGND sg13g2_fill_1
X_2321_ VGND VPWR _1151_ _0917_ _0918_ _1152_ sg13g2_a21oi_1
X_3370_ VPWR VGND _1352_ sg13g2_tiehi
X_2183_ VGND VPWR _0788_ Inst_RegFile_ConfigMem.Inst_frame1_bit0.Q W6END[1] sg13g2_or2_1
X_2252_ Inst_RegFile_ConfigMem.Inst_frame3_bit2.Q VPWR _0853_ VGND Inst_RegFile_ConfigMem.Inst_frame3_bit1.Q
+ _0851_ sg13g2_o21ai_1
XFILLER_33_295 VPWR VGND sg13g2_fill_2
X_1967_ _0584_ VPWR _0585_ VGND Inst_RegFile_ConfigMem.Inst_frame4_bit16.Q AD3 sg13g2_o21ai_1
X_3637_ WW4END[12] net252 VPWR VGND sg13g2_buf_1
X_1898_ VGND VPWR _0519_ _0521_ _0522_ _0491_ sg13g2_a21oi_1
X_3499_ Inst_RegFile_switch_matrix.JN2BEG3 net108 VPWR VGND sg13g2_buf_1
X_3568_ S4END[8] net183 VPWR VGND sg13g2_buf_1
X_2519_ S4END[0] Inst_RegFile_switch_matrix.JW2BEG1 Inst_RegFile_ConfigMem.Inst_frame0_bit6.Q
+ _1070_ VPWR VGND sg13g2_mux2_1
XFILLER_33_65 VPWR VGND sg13g2_fill_2
X_2870_ FrameData[26] FrameStrobe[10] Inst_RegFile_ConfigMem.Inst_frame10_bit26.Q
+ VPWR VGND sg13g2_dlhq_1
X_1752_ S1END[3] S2END[7] Inst_RegFile_ConfigMem.Inst_frame2_bit24.Q _0383_ VPWR VGND
+ sg13g2_mux2_1
X_1821_ Inst_RegFile_ConfigMem.Inst_frame1_bit24.Q N1END[3] N2END[7] E1END[3] E2END[7]
+ Inst_RegFile_ConfigMem.Inst_frame1_bit25.Q _0449_ VPWR VGND sg13g2_mux4_1
X_1683_ A_ADR0 Inst_RegFile_32x4.mem\[2\]\[3\] Inst_RegFile_32x4.mem\[3\]\[3\] Inst_RegFile_32x4.mem\[0\]\[3\]
+ Inst_RegFile_32x4.mem\[1\]\[3\] _1210_ _0317_ VPWR VGND sg13g2_mux4_1
XFILLER_30_276 VPWR VGND sg13g2_fill_1
X_3422_ Inst_RegFile_switch_matrix.E6BEG0 net22 VPWR VGND sg13g2_buf_1
X_3284_ VPWR VGND _1266_ sg13g2_tiehi
X_2304_ Inst_RegFile_ConfigMem.Inst_frame9_bit12.Q SS4END[1] _0901_ VPWR VGND sg13g2_nor2b_1
X_3353_ VPWR VGND _1335_ sg13g2_tiehi
XFILLER_24_0 VPWR VGND sg13g2_fill_2
X_2097_ _0707_ VPWR _0708_ VGND Inst_RegFile_ConfigMem.Inst_frame4_bit10.Q _0702_
+ sg13g2_o21ai_1
X_2235_ _0837_ Inst_RegFile_ConfigMem.Inst_frame3_bit28.Q BD2 VPWR VGND sg13g2_nand2_1
X_2166_ _0771_ VPWR _0772_ VGND Inst_RegFile_ConfigMem.Inst_frame1_bit28.Q _1167_
+ sg13g2_o21ai_1
X_2999_ FrameData[27] FrameStrobe[6] Inst_RegFile_ConfigMem.Inst_frame6_bit27.Q VPWR
+ VGND sg13g2_dlhq_1
XFILLER_21_232 VPWR VGND sg13g2_fill_2
XFILLER_21_276 VPWR VGND sg13g2_fill_1
XFILLER_29_398 VPWR VGND sg13g2_fill_1
X_2020_ _0635_ VPWR Inst_RegFile_switch_matrix.JN2BEG3 VGND _0626_ _0627_ sg13g2_o21ai_1
X_2853_ FrameData[9] FrameStrobe[10] Inst_RegFile_ConfigMem.Inst_frame10_bit9.Q VPWR
+ VGND sg13g2_dlhq_1
X_2922_ FrameData[14] FrameStrobe[8] Inst_RegFile_ConfigMem.Inst_frame8_bit14.Q VPWR
+ VGND sg13g2_dlhq_1
X_1735_ _0365_ VPWR _0366_ VGND _0358_ _0361_ sg13g2_o21ai_1
X_1666_ _0302_ _0142_ _0301_ VPWR VGND sg13g2_nand2_1
X_1804_ VPWR _0432_ _0431_ VGND sg13g2_inv_1
X_2784_ FrameData[4] FrameStrobe[12] Inst_RegFile_ConfigMem.Inst_frame12_bit4.Q VPWR
+ VGND sg13g2_dlhq_1
X_1597_ A_ADR0 Inst_RegFile_32x4.mem\[0\]\[0\] _0237_ VPWR VGND sg13g2_nor2b_1
X_3267_ VPWR VGND _1249_ sg13g2_tiehi
X_3336_ VPWR VGND _1318_ sg13g2_tiehi
X_3405_ E2MID[1] net14 VPWR VGND sg13g2_buf_1
XFILLER_38_195 VPWR VGND sg13g2_fill_2
X_2218_ VGND VPWR Inst_RegFile_ConfigMem.Inst_frame2_bit0.Q _1165_ _0821_ _0820_ sg13g2_a21oi_1
X_3198_ _1318_ VGND VPWR Inst_RegFile_32x4.BD_comb\[2\] Inst_RegFile_32x4.BD_reg\[2\]
+ clknet_5_4__leaf_UserCLK_regs sg13g2_dfrbpq_1
X_2149_ AD2 AD3 Inst_RegFile_ConfigMem.Inst_frame4_bit4.Q _0756_ VPWR VGND sg13g2_mux2_1
XFILLER_14_45 VPWR VGND sg13g2_fill_2
XFILLER_44_143 VPWR VGND sg13g2_fill_2
X_1520_ EE4END[3] S4END[0] Inst_RegFile_ConfigMem.Inst_frame0_bit22.Q _0163_ VPWR
+ VGND sg13g2_mux2_1
X_3121_ FrameData[21] FrameStrobe[2] Inst_RegFile_ConfigMem.Inst_frame2_bit21.Q VPWR
+ VGND sg13g2_dlhq_1
X_1451_ Inst_RegFile_ConfigMem.Inst_frame5_bit18.Q N2END[3] E2END[3] S2END[3] WW4END[1]
+ Inst_RegFile_ConfigMem.Inst_frame5_bit19.Q _1207_ VPWR VGND sg13g2_mux4_1
X_1382_ VPWR _1140_ Inst_RegFile_ConfigMem.Inst_frame8_bit30.Q VGND sg13g2_inv_1
X_3052_ FrameData[16] FrameStrobe[4] Inst_RegFile_ConfigMem.Inst_frame4_bit16.Q VPWR
+ VGND sg13g2_dlhq_1
X_2003_ VGND VPWR Inst_RegFile_ConfigMem.Inst_frame4_bit12.Q AD0 _0619_ _0618_ sg13g2_a21oi_1
X_2836_ FrameData[24] FrameStrobe[11] Inst_RegFile_ConfigMem.Inst_frame11_bit24.Q
+ VPWR VGND sg13g2_dlhq_1
X_2905_ FrameData[29] FrameStrobe[9] Inst_RegFile_ConfigMem.Inst_frame9_bit29.Q VPWR
+ VGND sg13g2_dlhq_1
X_2698_ _1067_ Inst_RegFile_32x4.mem\[11\]\[1\] _1130_ _0121_ VPWR VGND sg13g2_mux2_1
X_1718_ VPWR VGND _0349_ _1135_ _0348_ _0343_ _0350_ _0345_ sg13g2_a221oi_1
X_1649_ VGND VPWR Inst_RegFile_32x4.AD_comb\[1\] _0286_ _0270_ sg13g2_or2_1
X_2767_ _1294_ VGND VPWR _0061_ Inst_RegFile_32x4.mem\[18\]\[1\] clknet_5_1__leaf_UserCLK_regs
+ sg13g2_dfrbpq_1
X_3319_ VPWR VGND _1301_ sg13g2_tiehi
XFILLER_54_485 VPWR VGND sg13g2_fill_1
XFILLER_25_33 VPWR VGND sg13g2_fill_2
XFILLER_49_268 VPWR VGND sg13g2_fill_1
XFILLER_17_187 VPWR VGND sg13g2_fill_2
XFILLER_32_124 VPWR VGND sg13g2_fill_2
Xoutput138 net138 NN4BEG[10] VPWR VGND sg13g2_buf_1
Xoutput127 net127 N4BEG[15] VPWR VGND sg13g2_buf_1
Xoutput116 net116 N2BEGb[3] VPWR VGND sg13g2_buf_1
Xoutput149 net149 NN4BEG[6] VPWR VGND sg13g2_buf_1
Xoutput105 net105 N2BEG[0] VPWR VGND sg13g2_buf_1
X_2483_ VGND VPWR SS4END[3] Inst_RegFile_ConfigMem.Inst_frame0_bit8.Q _1037_ _1036_
+ sg13g2_a21oi_1
X_2621_ _1065_ Inst_RegFile_32x4.mem\[18\]\[0\] _1114_ _0060_ VPWR VGND sg13g2_mux2_1
X_2552_ _1065_ Inst_RegFile_32x4.mem\[27\]\[0\] _1093_ _0012_ VPWR VGND sg13g2_mux2_1
X_1503_ VGND VPWR _0147_ Inst_RegFile_ConfigMem.Inst_frame1_bit12.Q W6END[0] sg13g2_or2_1
X_1434_ _1191_ BD0 Inst_RegFile_ConfigMem.Inst_frame3_bit12.Q VPWR VGND sg13g2_nand2b_1
X_3104_ FrameData[4] FrameStrobe[2] Inst_RegFile_ConfigMem.Inst_frame2_bit4.Q VPWR
+ VGND sg13g2_dlhq_1
X_3035_ FrameData[31] FrameStrobe[5] Inst_RegFile_ConfigMem.Inst_frame5_bit31.Q VPWR
+ VGND sg13g2_dlhq_1
X_2819_ FrameData[7] FrameStrobe[11] Inst_RegFile_ConfigMem.Inst_frame11_bit7.Q VPWR
+ VGND sg13g2_dlhq_1
XFILLER_46_249 VPWR VGND sg13g2_fill_2
XFILLER_27_485 VPWR VGND sg13g2_fill_1
X_1983_ VGND VPWR EE4END[0] Inst_RegFile_ConfigMem.Inst_frame0_bit24.Q _0600_ _0599_
+ sg13g2_a21oi_1
X_2604_ _1087_ Inst_RegFile_32x4.mem\[23\]\[3\] _1110_ _0047_ VPWR VGND sg13g2_mux2_1
XFILLER_13_190 VPWR VGND sg13g2_fill_2
XFILLER_54_0 VPWR VGND sg13g2_fill_2
X_3584_ SS4END[8] net199 VPWR VGND sg13g2_buf_1
X_1417_ Inst_RegFile_ConfigMem.Inst_frame3_bit23.Q VPWR _1175_ VGND Inst_RegFile_ConfigMem.Inst_frame3_bit22.Q
+ _1174_ sg13g2_o21ai_1
X_2535_ Inst_RegFile_ConfigMem.Inst_frame9_bit27.Q _1080_ _1085_ _1086_ VPWR VGND
+ sg13g2_or3_1
X_2466_ _1020_ Inst_RegFile_ConfigMem.Inst_frame8_bit6.Q _1019_ VPWR VGND sg13g2_nand2b_1
X_2397_ Inst_RegFile_ConfigMem.Inst_frame11_bit15.Q VPWR _0982_ VGND _1158_ _0981_
+ sg13g2_o21ai_1
XFILLER_3_80 VPWR VGND sg13g2_fill_1
X_3018_ FrameData[14] FrameStrobe[5] Inst_RegFile_ConfigMem.Inst_frame5_bit14.Q VPWR
+ VGND sg13g2_dlhq_1
XFILLER_8_25 VPWR VGND sg13g2_fill_1
X_2320_ Inst_RegFile_ConfigMem.Inst_frame9_bit13.Q BD0 BD2 BD1 BD3 Inst_RegFile_ConfigMem.Inst_frame9_bit12.Q
+ _0917_ VPWR VGND sg13g2_mux4_1
X_2251_ BD2 BD3 Inst_RegFile_ConfigMem.Inst_frame3_bit0.Q _0852_ VPWR VGND sg13g2_mux2_1
X_2182_ AD2 AD3 Inst_RegFile_ConfigMem.Inst_frame1_bit0.Q _0787_ VPWR VGND sg13g2_mux2_1
X_1966_ VGND VPWR Inst_RegFile_ConfigMem.Inst_frame4_bit16.Q _1164_ _0584_ Inst_RegFile_ConfigMem.Inst_frame4_bit17.Q
+ sg13g2_a21oi_1
XFILLER_21_458 VPWR VGND sg13g2_fill_1
X_3567_ S4END[7] net182 VPWR VGND sg13g2_buf_1
X_1897_ VGND VPWR _0409_ _0520_ _0521_ _0460_ sg13g2_a21oi_1
X_3636_ WW4END[11] net251 VPWR VGND sg13g2_buf_1
X_3498_ Inst_RegFile_switch_matrix.JN2BEG2 net107 VPWR VGND sg13g2_buf_1
X_2518_ _1069_ Inst_RegFile_32x4.mem\[24\]\[2\] _1062_ _0002_ VPWR VGND sg13g2_mux2_1
X_2449_ Inst_RegFile_ConfigMem.Inst_frame10_bit2.Q BD3 _0486_ Inst_RegFile_switch_matrix.E2BEG2
+ _1016_ Inst_RegFile_ConfigMem.Inst_frame10_bit3.Q Inst_RegFile_switch_matrix.S1BEG3
+ VPWR VGND sg13g2_mux4_1
XFILLER_47_366 VPWR VGND sg13g2_fill_1
X_1820_ Inst_RegFile_ConfigMem.Inst_frame1_bit27.Q _0447_ _0448_ VPWR VGND sg13g2_and2_1
X_1751_ SS4END[1] W1END[1] Inst_RegFile_ConfigMem.Inst_frame2_bit24.Q _0382_ VPWR
+ VGND sg13g2_mux2_1
X_3421_ E6END[11] net32 VPWR VGND sg13g2_buf_1
X_1682_ VGND VPWR _0143_ _0313_ _0316_ _0186_ sg13g2_a21oi_1
X_3352_ VPWR VGND _1334_ sg13g2_tiehi
X_2303_ VGND VPWR E1END[3] Inst_RegFile_ConfigMem.Inst_frame9_bit12.Q _0900_ Inst_RegFile_ConfigMem.Inst_frame9_bit13.Q
+ sg13g2_a21oi_1
X_3283_ VPWR VGND _1265_ sg13g2_tiehi
XFILLER_31_2 VPWR VGND sg13g2_fill_1
X_2234_ Inst_RegFile_ConfigMem.Inst_frame3_bit28.Q W1END[0] AD0 AD1 AD2 Inst_RegFile_ConfigMem.Inst_frame3_bit29.Q
+ _0836_ VPWR VGND sg13g2_mux4_1
X_2096_ VGND VPWR _0705_ _0706_ _0707_ Inst_RegFile_ConfigMem.Inst_frame4_bit11.Q
+ sg13g2_a21oi_1
X_2165_ _0771_ Inst_RegFile_ConfigMem.Inst_frame1_bit28.Q AD2 VPWR VGND sg13g2_nand2_1
X_1949_ B_ADR0 Inst_RegFile_32x4.mem\[10\]\[2\] _0569_ VPWR VGND sg13g2_nor2b_1
X_2998_ FrameData[26] FrameStrobe[6] Inst_RegFile_ConfigMem.Inst_frame6_bit26.Q VPWR
+ VGND sg13g2_dlhq_1
X_3619_ W6END[4] net230 VPWR VGND sg13g2_buf_1
XFILLER_28_66 VPWR VGND sg13g2_fill_2
XFILLER_0_137 VPWR VGND sg13g2_fill_2
XFILLER_12_211 VPWR VGND sg13g2_fill_1
X_2852_ FrameData[8] FrameStrobe[10] Inst_RegFile_ConfigMem.Inst_frame10_bit8.Q VPWR
+ VGND sg13g2_dlhq_1
X_2921_ FrameData[13] FrameStrobe[8] Inst_RegFile_ConfigMem.Inst_frame8_bit13.Q VPWR
+ VGND sg13g2_dlhq_1
X_2783_ FrameData[3] FrameStrobe[12] Inst_RegFile_ConfigMem.Inst_frame12_bit3.Q VPWR
+ VGND sg13g2_dlhq_1
X_1803_ Inst_RegFile_ConfigMem.Inst_frame5_bit31.Q N2END[1] S2END[1] EE4END[3] W2END[1]
+ Inst_RegFile_ConfigMem.Inst_frame5_bit30.Q _0431_ VPWR VGND sg13g2_mux4_1
X_1734_ _0364_ Inst_RegFile_ConfigMem.Inst_frame8_bit24.Q _0365_ VPWR VGND sg13g2_nor2b_1
X_1596_ _0236_ _0211_ _0234_ VPWR VGND sg13g2_nand2_1
X_1665_ A_ADR0 Inst_RegFile_32x4.mem\[30\]\[2\] Inst_RegFile_32x4.mem\[31\]\[2\] Inst_RegFile_32x4.mem\[28\]\[2\]
+ Inst_RegFile_32x4.mem\[29\]\[2\] _1210_ _0301_ VPWR VGND sg13g2_mux4_1
X_3404_ E2MID[0] net13 VPWR VGND sg13g2_buf_1
X_3266_ VPWR VGND _1248_ sg13g2_tiehi
X_2217_ Inst_RegFile_ConfigMem.Inst_frame2_bit1.Q VPWR _0820_ VGND Inst_RegFile_ConfigMem.Inst_frame2_bit0.Q
+ BD2 sg13g2_o21ai_1
X_3197_ _1317_ VGND VPWR Inst_RegFile_32x4.BD_comb\[1\] Inst_RegFile_32x4.BD_reg\[1\]
+ clknet_5_4__leaf_UserCLK_regs sg13g2_dfrbpq_1
X_3335_ VPWR VGND _1317_ sg13g2_tiehi
XFILLER_53_177 VPWR VGND sg13g2_fill_2
X_2079_ _0686_ VPWR Inst_RegFile_switch_matrix.E2BEG2 VGND Inst_RegFile_ConfigMem.Inst_frame3_bit11.Q
+ _0690_ sg13g2_o21ai_1
X_2148_ _0746_ VPWR Inst_RegFile_switch_matrix.E2BEG1 VGND Inst_RegFile_ConfigMem.Inst_frame3_bit7.Q
+ _0755_ sg13g2_o21ai_1
XFILLER_30_23 VPWR VGND sg13g2_fill_1
XFILLER_1_468 VPWR VGND sg13g2_fill_1
X_1450_ _1202_ Inst_RegFile_ConfigMem.Inst_frame0_bit19.Q _1205_ _1206_ VPWR VGND
+ sg13g2_a21o_1
X_3120_ FrameData[20] FrameStrobe[2] Inst_RegFile_ConfigMem.Inst_frame2_bit20.Q VPWR
+ VGND sg13g2_dlhq_1
X_3051_ FrameData[15] FrameStrobe[4] Inst_RegFile_ConfigMem.Inst_frame4_bit15.Q VPWR
+ VGND sg13g2_dlhq_1
X_1381_ VPWR _1139_ Inst_RegFile_ConfigMem.Inst_frame8_bit28.Q VGND sg13g2_inv_1
XFILLER_50_114 VPWR VGND sg13g2_fill_1
XFILLER_35_177 VPWR VGND sg13g2_fill_1
XFILLER_35_100 VPWR VGND sg13g2_fill_1
X_2002_ Inst_RegFile_ConfigMem.Inst_frame4_bit12.Q W6END[0] _0618_ VPWR VGND sg13g2_nor2b_1
X_2835_ FrameData[23] FrameStrobe[11] Inst_RegFile_ConfigMem.Inst_frame11_bit23.Q
+ VPWR VGND sg13g2_dlhq_1
X_2904_ FrameData[28] FrameStrobe[9] Inst_RegFile_ConfigMem.Inst_frame9_bit28.Q VPWR
+ VGND sg13g2_dlhq_1
X_2766_ _1295_ VGND VPWR _0060_ Inst_RegFile_32x4.mem\[18\]\[0\] clknet_5_1__leaf_UserCLK_regs
+ sg13g2_dfrbpq_1
X_1717_ VGND VPWR _1133_ _0346_ _0349_ _1134_ sg13g2_a21oi_1
X_2697_ _1065_ Inst_RegFile_32x4.mem\[11\]\[0\] _1130_ _0120_ VPWR VGND sg13g2_mux2_1
X_1579_ BD3 Inst_RegFile_ConfigMem.Inst_frame3_bit24.Q _0220_ VPWR VGND sg13g2_nor2b_1
X_3318_ VPWR VGND _1300_ sg13g2_tiehi
X_1648_ VPWR VGND _0186_ _0235_ _0285_ _0275_ _0286_ _0277_ sg13g2_a221oi_1
X_3249_ _1370_ VGND VPWR _0121_ Inst_RegFile_32x4.mem\[11\]\[1\] clknet_5_21__leaf_UserCLK_regs
+ sg13g2_dfrbpq_1
XFILLER_39_450 VPWR VGND sg13g2_fill_1
XFILLER_26_133 VPWR VGND sg13g2_fill_2
XFILLER_32_147 VPWR VGND sg13g2_fill_2
X_2620_ _1114_ _1090_ _1106_ VPWR VGND sg13g2_nand2_1
Xoutput139 net139 NN4BEG[11] VPWR VGND sg13g2_buf_1
Xoutput128 net128 N4BEG[1] VPWR VGND sg13g2_buf_1
Xoutput117 net117 N2BEGb[4] VPWR VGND sg13g2_buf_1
Xoutput106 net106 N2BEG[1] VPWR VGND sg13g2_buf_1
X_2482_ Inst_RegFile_ConfigMem.Inst_frame0_bit8.Q E2END[3] _1036_ VPWR VGND sg13g2_nor2b_1
X_2551_ _1093_ _1034_ _1092_ VPWR VGND sg13g2_nand2_1
X_1502_ _0145_ VPWR _0146_ VGND Inst_RegFile_ConfigMem.Inst_frame1_bit12.Q _1167_
+ sg13g2_o21ai_1
X_1433_ _1190_ Inst_RegFile_ConfigMem.Inst_frame3_bit12.Q BD1 VPWR VGND sg13g2_nand2_1
X_3103_ FrameData[3] FrameStrobe[2] Inst_RegFile_ConfigMem.Inst_frame2_bit3.Q VPWR
+ VGND sg13g2_dlhq_1
X_3034_ FrameData[30] FrameStrobe[5] Inst_RegFile_ConfigMem.Inst_frame5_bit30.Q VPWR
+ VGND sg13g2_dlhq_1
X_2818_ FrameData[6] FrameStrobe[11] Inst_RegFile_ConfigMem.Inst_frame11_bit6.Q VPWR
+ VGND sg13g2_dlhq_1
X_2749_ _1312_ VGND VPWR _0043_ Inst_RegFile_32x4.mem\[22\]\[3\] clknet_5_8__leaf_UserCLK_regs
+ sg13g2_dfrbpq_1
XFILLER_39_291 VPWR VGND sg13g2_fill_2
Xclkbuf_4_7_0_UserCLK_regs clknet_0_UserCLK_regs clknet_4_7_0_UserCLK_regs VPWR VGND
+ sg13g2_buf_8
X_1982_ Inst_RegFile_ConfigMem.Inst_frame0_bit24.Q N4END[3] _0599_ VPWR VGND sg13g2_nor2b_1
XFILLER_20_139 VPWR VGND sg13g2_fill_2
X_3583_ SS4END[7] net198 VPWR VGND sg13g2_buf_1
X_2534_ VGND VPWR Inst_RegFile_ConfigMem.Inst_frame6_bit7.Q _1083_ _1085_ _1084_ sg13g2_a21oi_1
X_2603_ _1069_ Inst_RegFile_32x4.mem\[23\]\[2\] _1110_ _0046_ VPWR VGND sg13g2_mux2_1
X_1416_ Inst_RegFile_ConfigMem.Inst_frame3_bit20.Q W1END[2] AD0 AD1 AD2 Inst_RegFile_ConfigMem.Inst_frame3_bit21.Q
+ _1174_ VPWR VGND sg13g2_mux4_1
X_2396_ Inst_RegFile_ConfigMem.Inst_frame5_bit8.Q NN4END[3] E2END[6] S2END[6] W2END[6]
+ Inst_RegFile_ConfigMem.Inst_frame5_bit9.Q _0981_ VPWR VGND sg13g2_mux4_1
X_2465_ _1161_ Inst_RegFile_switch_matrix.JW2BEG7 Inst_RegFile_switch_matrix.JS2BEG7
+ Inst_RegFile_switch_matrix.JN2BEG7 _0935_ _1162_ _1019_ VPWR VGND sg13g2_mux4_1
X_3017_ FrameData[13] FrameStrobe[5] Inst_RegFile_ConfigMem.Inst_frame5_bit13.Q VPWR
+ VGND sg13g2_dlhq_1
XFILLER_3_327 VPWR VGND sg13g2_fill_2
XFILLER_3_305 VPWR VGND sg13g2_fill_1
XFILLER_19_206 VPWR VGND sg13g2_fill_1
XFILLER_15_401 VPWR VGND sg13g2_fill_2
XFILLER_15_456 VPWR VGND sg13g2_fill_2
XFILLER_6_143 VPWR VGND sg13g2_fill_2
XFILLER_10_161 VPWR VGND sg13g2_fill_1
X_2250_ VGND VPWR Inst_RegFile_ConfigMem.Inst_frame3_bit0.Q BD1 _0851_ _0850_ sg13g2_a21oi_1
X_2181_ _0786_ VPWR Inst_RegFile_switch_matrix.JW2BEG7 VGND _0775_ _0782_ sg13g2_o21ai_1
X_1965_ _1165_ Inst_RegFile_ConfigMem.Inst_frame4_bit16.Q _0582_ _0583_ VPWR VGND
+ sg13g2_a21o_1
XFILLER_33_297 VPWR VGND sg13g2_fill_1
Xclkbuf_5_5__f_UserCLK_regs clknet_4_2_0_UserCLK_regs clknet_5_5__leaf_UserCLK_regs
+ VPWR VGND sg13g2_buf_8
X_3497_ Inst_RegFile_switch_matrix.JN2BEG1 net106 VPWR VGND sg13g2_buf_1
X_3635_ WW4END[10] net250 VPWR VGND sg13g2_buf_1
X_3566_ S4END[6] net181 VPWR VGND sg13g2_buf_1
X_1896_ B_ADR0 Inst_RegFile_32x4.mem\[20\]\[1\] Inst_RegFile_32x4.mem\[21\]\[1\] Inst_RegFile_32x4.mem\[22\]\[1\]
+ Inst_RegFile_32x4.mem\[23\]\[1\] _0368_ _0520_ VPWR VGND sg13g2_mux4_1
X_2517_ Inst_RegFile_ConfigMem.Inst_frame9_bit25.Q _0896_ _0919_ _0486_ _1068_ Inst_RegFile_ConfigMem.Inst_frame9_bit24.Q
+ _1069_ VPWR VGND sg13g2_mux4_1
X_2379_ VGND VPWR Inst_RegFile_ConfigMem.Inst_frame11_bit20.Q AD3 _0966_ _0965_ sg13g2_a21oi_1
X_2448_ Inst_RegFile_ConfigMem.Inst_frame10_bit5.Q E6END[1] S4END[1] S2END[2] AD0
+ Inst_RegFile_ConfigMem.Inst_frame10_bit4.Q Inst_RegFile_switch_matrix.S4BEG0 VPWR
+ VGND sg13g2_mux4_1
XFILLER_24_220 VPWR VGND sg13g2_fill_2
XFILLER_3_146 VPWR VGND sg13g2_fill_1
X_1750_ Inst_RegFile_ConfigMem.Inst_frame2_bit24.Q N1END[3] N2END[7] E1END[3] E2END[7]
+ Inst_RegFile_ConfigMem.Inst_frame2_bit25.Q _0381_ VPWR VGND sg13g2_mux4_1
X_3351_ VPWR VGND _1333_ sg13g2_tiehi
X_1681_ _0315_ _0142_ _0314_ VPWR VGND sg13g2_nand2_1
X_3420_ E6END[10] net31 VPWR VGND sg13g2_buf_1
XFILLER_7_485 VPWR VGND sg13g2_fill_1
X_3282_ VPWR VGND _1264_ sg13g2_tiehi
X_2302_ _0899_ NN4END[1] Inst_RegFile_ConfigMem.Inst_frame9_bit12.Q VPWR VGND sg13g2_nand2b_1
X_2233_ _0835_ VPWR Inst_RegFile_switch_matrix.JS2BEG0 VGND _0826_ _0827_ sg13g2_o21ai_1
X_2164_ _0770_ VPWR Inst_RegFile_switch_matrix.JN2BEG1 VGND _0759_ _0765_ sg13g2_o21ai_1
X_2095_ VGND VPWR Inst_RegFile_ConfigMem.Inst_frame4_bit9.Q _0703_ _0706_ _1148_ sg13g2_a21oi_1
X_2997_ FrameData[25] FrameStrobe[6] Inst_RegFile_ConfigMem.Inst_frame6_bit25.Q VPWR
+ VGND sg13g2_dlhq_1
X_1879_ B_ADR0 Inst_RegFile_32x4.mem\[16\]\[0\] Inst_RegFile_32x4.mem\[17\]\[0\] Inst_RegFile_32x4.mem\[18\]\[0\]
+ Inst_RegFile_32x4.mem\[19\]\[0\] _0368_ _0505_ VPWR VGND sg13g2_mux4_1
X_1948_ VPWR VGND _0567_ _0491_ _0565_ _0561_ _0568_ _0563_ sg13g2_a221oi_1
X_3549_ Inst_RegFile_switch_matrix.JS2BEG1 net158 VPWR VGND sg13g2_buf_1
X_3618_ W6END[3] net229 VPWR VGND sg13g2_buf_1
XFILLER_29_323 VPWR VGND sg13g2_fill_2
XFILLER_4_444 VPWR VGND sg13g2_fill_1
XFILLER_43_370 VPWR VGND sg13g2_fill_1
X_2920_ FrameData[12] FrameStrobe[8] Inst_RegFile_ConfigMem.Inst_frame8_bit12.Q VPWR
+ VGND sg13g2_dlhq_1
X_1733_ Inst_RegFile_ConfigMem.Inst_frame8_bit23.Q _0362_ _0364_ VPWR VGND sg13g2_nor2_1
X_2782_ FrameData[2] FrameStrobe[12] Inst_RegFile_ConfigMem.Inst_frame12_bit2.Q VPWR
+ VGND sg13g2_dlhq_1
X_2851_ FrameData[7] FrameStrobe[10] Inst_RegFile_ConfigMem.Inst_frame10_bit7.Q VPWR
+ VGND sg13g2_dlhq_1
X_1802_ VPWR _0430_ _0429_ VGND sg13g2_inv_1
X_1595_ _0211_ _0234_ _0235_ VPWR VGND sg13g2_and2_1
X_3403_ Inst_RegFile_switch_matrix.E2BEG7 net12 VPWR VGND sg13g2_buf_1
X_3334_ VPWR VGND _1316_ sg13g2_tiehi
X_1664_ A_ADR0 Inst_RegFile_32x4.mem\[26\]\[2\] Inst_RegFile_32x4.mem\[27\]\[2\] Inst_RegFile_32x4.mem\[24\]\[2\]
+ Inst_RegFile_32x4.mem\[25\]\[2\] _1210_ _0300_ VPWR VGND sg13g2_mux4_1
X_3265_ VPWR VGND _1247_ sg13g2_tiehi
XFILLER_38_197 VPWR VGND sg13g2_fill_1
XFILLER_26_304 VPWR VGND sg13g2_fill_1
X_2216_ _0812_ VPWR Inst_RegFile_switch_matrix.JS2BEG7 VGND Inst_RegFile_ConfigMem.Inst_frame2_bit31.Q
+ _0819_ sg13g2_o21ai_1
X_2147_ Inst_RegFile_ConfigMem.Inst_frame3_bit5.Q _0754_ _0752_ _0748_ _0750_ Inst_RegFile_ConfigMem.Inst_frame3_bit6.Q
+ _0755_ VPWR VGND sg13g2_mux4_1
X_3196_ _1316_ VGND VPWR Inst_RegFile_32x4.BD_comb\[0\] Inst_RegFile_32x4.BD_reg\[0\]
+ clknet_5_4__leaf_UserCLK_regs sg13g2_dfrbpq_1
X_2078_ VGND VPWR Inst_RegFile_ConfigMem.Inst_frame3_bit10.Q _0688_ _0690_ _0689_
+ sg13g2_a21oi_1
XFILLER_41_307 VPWR VGND sg13g2_fill_1
XFILLER_44_145 VPWR VGND sg13g2_fill_1
XFILLER_20_90 VPWR VGND sg13g2_fill_1
X_1380_ VPWR _1138_ WW4END[1] VGND sg13g2_inv_1
X_3050_ FrameData[14] FrameStrobe[4] Inst_RegFile_ConfigMem.Inst_frame4_bit14.Q VPWR
+ VGND sg13g2_dlhq_1
X_2001_ _0616_ VPWR _0617_ VGND Inst_RegFile_ConfigMem.Inst_frame4_bit12.Q _1167_
+ sg13g2_o21ai_1
X_2903_ FrameData[27] FrameStrobe[9] Inst_RegFile_ConfigMem.Inst_frame9_bit27.Q VPWR
+ VGND sg13g2_dlhq_1
X_2696_ _1130_ _1092_ _1101_ VPWR VGND sg13g2_nand2_1
X_1716_ _1165_ Inst_RegFile_ConfigMem.Inst_frame3_bit16.Q _0347_ _0348_ VPWR VGND
+ sg13g2_a21o_1
X_2834_ FrameData[22] FrameStrobe[11] Inst_RegFile_ConfigMem.Inst_frame11_bit22.Q
+ VPWR VGND sg13g2_dlhq_1
X_2765_ _1296_ VGND VPWR _0059_ Inst_RegFile_32x4.mem\[16\]\[3\] clknet_5_3__leaf_UserCLK_regs
+ sg13g2_dfrbpq_1
X_1578_ VGND VPWR _0217_ _0218_ _0219_ Inst_RegFile_ConfigMem.Inst_frame3_bit25.Q
+ sg13g2_a21oi_1
X_1647_ _0285_ _0283_ _0284_ _0278_ _0143_ VPWR VGND sg13g2_a22oi_1
X_3317_ VPWR VGND _1299_ sg13g2_tiehi
Xclkbuf_4_15_0_UserCLK_regs clknet_0_UserCLK_regs clknet_4_15_0_UserCLK_regs VPWR
+ VGND sg13g2_buf_8
X_3248_ _1371_ VGND VPWR _0120_ Inst_RegFile_32x4.mem\[11\]\[0\] clknet_5_22__leaf_UserCLK_regs
+ sg13g2_dfrbpq_1
X_3179_ FrameData[15] FrameStrobe[0] Inst_RegFile_ConfigMem.Inst_frame0_bit15.Q VPWR
+ VGND sg13g2_dlhq_1
XFILLER_25_35 VPWR VGND sg13g2_fill_1
XFILLER_1_244 VPWR VGND sg13g2_fill_2
XFILLER_32_126 VPWR VGND sg13g2_fill_1
Xoutput107 net107 N2BEG[2] VPWR VGND sg13g2_buf_1
X_2550_ _1047_ _1058_ _1060_ _1092_ VPWR VGND sg13g2_nor3_1
XFILLER_9_399 VPWR VGND sg13g2_fill_1
Xoutput129 net129 N4BEG[2] VPWR VGND sg13g2_buf_1
Xoutput118 net118 N2BEGb[5] VPWR VGND sg13g2_buf_1
X_2481_ WW4END[2] Inst_RegFile_switch_matrix.JN2BEG2 Inst_RegFile_ConfigMem.Inst_frame0_bit8.Q
+ _1035_ VPWR VGND sg13g2_mux2_1
X_1501_ _0145_ Inst_RegFile_ConfigMem.Inst_frame1_bit12.Q AD2 VPWR VGND sg13g2_nand2_1
X_1432_ VPWR VGND _1188_ Inst_RegFile_ConfigMem.Inst_frame3_bit14.Q _1187_ Inst_RegFile_ConfigMem.Inst_frame3_bit13.Q
+ _1189_ _1186_ sg13g2_a221oi_1
X_3102_ FrameData[2] FrameStrobe[2] Inst_RegFile_ConfigMem.Inst_frame2_bit2.Q VPWR
+ VGND sg13g2_dlhq_1
X_3033_ FrameData[29] FrameStrobe[5] Inst_RegFile_ConfigMem.Inst_frame5_bit29.Q VPWR
+ VGND sg13g2_dlhq_1
XFILLER_23_159 VPWR VGND sg13g2_fill_1
X_2679_ _1069_ Inst_RegFile_32x4.mem\[7\]\[2\] _1126_ _0106_ VPWR VGND sg13g2_mux2_1
X_2748_ _1313_ VGND VPWR _0042_ Inst_RegFile_32x4.mem\[22\]\[2\] clknet_5_2__leaf_UserCLK_regs
+ sg13g2_dfrbpq_1
X_2817_ FrameData[5] FrameStrobe[11] Inst_RegFile_ConfigMem.Inst_frame11_bit5.Q VPWR
+ VGND sg13g2_dlhq_1
XFILLER_54_295 VPWR VGND sg13g2_fill_2
XFILLER_6_336 VPWR VGND sg13g2_fill_2
XFILLER_10_321 VPWR VGND sg13g2_fill_1
X_1981_ S4END[3] Inst_RegFile_switch_matrix.JN2BEG4 Inst_RegFile_ConfigMem.Inst_frame0_bit24.Q
+ _0598_ VPWR VGND sg13g2_mux2_1
X_3582_ SS4END[6] net197 VPWR VGND sg13g2_buf_1
X_2533_ Inst_RegFile_ConfigMem.Inst_frame9_bit26.Q VPWR _1084_ VGND Inst_RegFile_ConfigMem.Inst_frame6_bit7.Q
+ _1082_ sg13g2_o21ai_1
X_2602_ _1067_ Inst_RegFile_32x4.mem\[23\]\[1\] _1110_ _0045_ VPWR VGND sg13g2_mux2_1
X_1415_ _1141_ _1169_ _1172_ _1173_ VPWR VGND sg13g2_nor3_1
X_2395_ _0980_ _0979_ Inst_RegFile_ConfigMem.Inst_frame11_bit19.Q Inst_RegFile_switch_matrix.EE4BEG3
+ VPWR VGND sg13g2_mux2_1
X_2464_ Inst_RegFile_ConfigMem.Inst_frame12_bit5.Q AD2 Inst_RegFile_switch_matrix.JW2BEG3
+ _1018_ _1017_ Inst_RegFile_ConfigMem.Inst_frame12_bit4.Q Inst_RegFile_switch_matrix.N1BEG0
+ VPWR VGND sg13g2_mux4_1
XFILLER_36_295 VPWR VGND sg13g2_fill_2
X_3016_ FrameData[12] FrameStrobe[5] Inst_RegFile_ConfigMem.Inst_frame5_bit12.Q VPWR
+ VGND sg13g2_dlhq_1
XFILLER_51_298 VPWR VGND sg13g2_fill_1
Xclkbuf_5_28__f_UserCLK_regs clknet_4_14_0_UserCLK_regs clknet_5_28__leaf_UserCLK_regs
+ VPWR VGND sg13g2_buf_8
XFILLER_2_394 VPWR VGND sg13g2_fill_1
X_2180_ _0786_ _0785_ Inst_RegFile_ConfigMem.Inst_frame1_bit31.Q VPWR VGND sg13g2_nand2b_1
X_1964_ Inst_RegFile_ConfigMem.Inst_frame4_bit17.Q VPWR _0582_ VGND Inst_RegFile_ConfigMem.Inst_frame4_bit16.Q
+ BD2 sg13g2_o21ai_1
XFILLER_33_287 VPWR VGND sg13g2_fill_1
X_3634_ WW4END[9] net249 VPWR VGND sg13g2_buf_1
X_1895_ _0519_ _0518_ _0409_ VPWR VGND sg13g2_nand2b_1
X_3496_ Inst_RegFile_switch_matrix.JN2BEG0 net105 VPWR VGND sg13g2_buf_1
X_3565_ S4END[5] net180 VPWR VGND sg13g2_buf_1
X_2447_ Inst_RegFile_ConfigMem.Inst_frame10_bit6.Q E6END[0] S2END[3] S4END[2] AD1
+ Inst_RegFile_ConfigMem.Inst_frame10_bit7.Q Inst_RegFile_switch_matrix.S4BEG1 VPWR
+ VGND sg13g2_mux4_1
X_2516_ Inst_RegFile_ConfigMem.Inst_frame0_bit5.Q N4END[1] W6END[1] E6END[1] Inst_RegFile_switch_matrix.JS2BEG1
+ Inst_RegFile_ConfigMem.Inst_frame0_bit4.Q _1068_ VPWR VGND sg13g2_mux4_1
X_2378_ Inst_RegFile_ConfigMem.Inst_frame11_bit20.Q AD2 _0965_ VPWR VGND sg13g2_nor2b_1
X_3350_ VPWR VGND _1332_ sg13g2_tiehi
X_2301_ Inst_RegFile_ConfigMem.Inst_frame9_bit18.Q _0893_ _0894_ _0898_ _0897_ Inst_RegFile_ConfigMem.Inst_frame9_bit19.Q
+ Inst_RegFile_switch_matrix.W6BEG1 VPWR VGND sg13g2_mux4_1
X_1680_ A_ADR0 Inst_RegFile_32x4.mem\[14\]\[3\] Inst_RegFile_32x4.mem\[15\]\[3\] Inst_RegFile_32x4.mem\[12\]\[3\]
+ Inst_RegFile_32x4.mem\[13\]\[3\] _1210_ _0314_ VPWR VGND sg13g2_mux4_1
X_2232_ _0834_ VPWR _0835_ VGND Inst_RegFile_ConfigMem.Inst_frame2_bit2.Q _0828_ sg13g2_o21ai_1
X_2163_ _0769_ VPWR _0770_ VGND Inst_RegFile_ConfigMem.Inst_frame4_bit6.Q _0766_ sg13g2_o21ai_1
X_3281_ VPWR VGND _1263_ sg13g2_tiehi
XFILLER_53_349 VPWR VGND sg13g2_fill_2
X_2094_ _0705_ _0704_ Inst_RegFile_ConfigMem.Inst_frame4_bit9.Q VPWR VGND sg13g2_nand2b_1
X_2996_ FrameData[24] FrameStrobe[6] Inst_RegFile_ConfigMem.Inst_frame6_bit24.Q VPWR
+ VGND sg13g2_dlhq_1
X_3617_ W6END[2] net226 VPWR VGND sg13g2_buf_1
X_1947_ VGND VPWR _0409_ _0566_ _0567_ _0460_ sg13g2_a21oi_1
X_1878_ VGND VPWR _0409_ _0503_ _0504_ _0459_ sg13g2_a21oi_1
X_3479_ FrameStrobe[7] net98 VPWR VGND sg13g2_buf_1
X_3548_ Inst_RegFile_switch_matrix.JS2BEG0 net157 VPWR VGND sg13g2_buf_1
XFILLER_0_139 VPWR VGND sg13g2_fill_1
XFILLER_29_357 VPWR VGND sg13g2_fill_2
XFILLER_28_68 VPWR VGND sg13g2_fill_1
X_2850_ FrameData[6] FrameStrobe[10] Inst_RegFile_ConfigMem.Inst_frame10_bit6.Q VPWR
+ VGND sg13g2_dlhq_1
X_1732_ VPWR _0363_ _0362_ VGND sg13g2_inv_1
X_1663_ VPWR VGND _0186_ _0236_ _0298_ _0288_ _0299_ _0290_ sg13g2_a221oi_1
X_1801_ Inst_RegFile_ConfigMem.Inst_frame0_bit30.Q NN4END[0] E6END[0] W2END[0] Inst_RegFile_switch_matrix.JW2BEG4
+ Inst_RegFile_ConfigMem.Inst_frame0_bit31.Q _0429_ VPWR VGND sg13g2_mux4_1
X_2781_ _1315_ VGND VPWR _0075_ Inst_RegFile_32x4.mem\[21\]\[3\] clknet_5_10__leaf_UserCLK_regs
+ sg13g2_dfrbpq_1
X_3264_ VPWR VGND _1246_ sg13g2_tiehi
X_1594_ _0233_ VPWR _0234_ VGND _1146_ _0230_ sg13g2_o21ai_1
X_3402_ Inst_RegFile_switch_matrix.E2BEG6 net11 VPWR VGND sg13g2_buf_1
XFILLER_22_0 VPWR VGND sg13g2_fill_2
X_3333_ VPWR VGND _1315_ sg13g2_tiehi
X_2077_ Inst_RegFile_ConfigMem.Inst_frame3_bit10.Q _0687_ _0689_ VPWR VGND sg13g2_nor2b_1
X_2215_ _0818_ VPWR _0819_ VGND Inst_RegFile_ConfigMem.Inst_frame2_bit30.Q _0813_
+ sg13g2_o21ai_1
X_3195_ FrameData[31] FrameStrobe[0] Inst_RegFile_ConfigMem.Inst_frame0_bit31.Q VPWR
+ VGND sg13g2_dlhq_1
X_2146_ VGND VPWR N2END[2] Inst_RegFile_ConfigMem.Inst_frame3_bit4.Q _0754_ _0753_
+ sg13g2_a21oi_1
X_2979_ FrameData[7] FrameStrobe[6] Inst_RegFile_ConfigMem.Inst_frame6_bit7.Q VPWR
+ VGND sg13g2_dlhq_1
XFILLER_29_187 VPWR VGND sg13g2_fill_2
XFILLER_17_327 VPWR VGND sg13g2_fill_1
XFILLER_48_441 VPWR VGND sg13g2_fill_1
X_2000_ _0616_ Inst_RegFile_ConfigMem.Inst_frame4_bit12.Q AD2 VPWR VGND sg13g2_nand2_1
XFILLER_43_190 VPWR VGND sg13g2_fill_2
X_2833_ FrameData[21] FrameStrobe[11] Inst_RegFile_ConfigMem.Inst_frame11_bit21.Q
+ VPWR VGND sg13g2_dlhq_1
X_2902_ FrameData[26] FrameStrobe[9] Inst_RegFile_ConfigMem.Inst_frame9_bit26.Q VPWR
+ VGND sg13g2_dlhq_1
X_2695_ Inst_RegFile_32x4.mem\[10\]\[3\] _1087_ _1129_ _0119_ VPWR VGND sg13g2_mux2_1
X_1715_ Inst_RegFile_ConfigMem.Inst_frame3_bit17.Q VPWR _0347_ VGND Inst_RegFile_ConfigMem.Inst_frame3_bit16.Q
+ BD2 sg13g2_o21ai_1
X_1646_ VGND VPWR _1210_ _0280_ _0284_ _0143_ sg13g2_a21oi_1
X_2764_ _1297_ VGND VPWR _0058_ Inst_RegFile_32x4.mem\[16\]\[2\] clknet_5_0__leaf_UserCLK_regs
+ sg13g2_dfrbpq_1
X_3247_ _1372_ VGND VPWR _0119_ Inst_RegFile_32x4.mem\[10\]\[3\] clknet_5_20__leaf_UserCLK_regs
+ sg13g2_dfrbpq_1
X_1577_ _0218_ AD3 Inst_RegFile_ConfigMem.Inst_frame3_bit24.Q VPWR VGND sg13g2_nand2b_1
X_3316_ VPWR VGND _1298_ sg13g2_tiehi
XFILLER_54_477 VPWR VGND sg13g2_fill_1
X_2129_ _0737_ VPWR _0738_ VGND Inst_RegFile_ConfigMem.Inst_frame2_bit6.Q _0734_ sg13g2_o21ai_1
X_3178_ FrameData[14] FrameStrobe[0] Inst_RegFile_ConfigMem.Inst_frame0_bit14.Q VPWR
+ VGND sg13g2_dlhq_1
XFILLER_22_330 VPWR VGND sg13g2_fill_1
XFILLER_45_422 VPWR VGND sg13g2_fill_2
XFILLER_32_149 VPWR VGND sg13g2_fill_1
Xoutput119 net119 N2BEGb[6] VPWR VGND sg13g2_buf_1
Xoutput108 net108 N2BEG[3] VPWR VGND sg13g2_buf_1
X_1500_ VPWR VGND _1214_ _0142_ _1213_ _1210_ _0144_ _1212_ sg13g2_a221oi_1
X_2480_ _1030_ _1033_ _1034_ VPWR VGND sg13g2_nor2_1
Xoutput90 net90 FrameStrobe_O[18] VPWR VGND sg13g2_buf_1
X_3101_ FrameData[1] FrameStrobe[2] Inst_RegFile_ConfigMem.Inst_frame2_bit1.Q VPWR
+ VGND sg13g2_dlhq_1
X_1431_ VGND VPWR Inst_RegFile_ConfigMem.Inst_frame3_bit12.Q _1166_ _1188_ Inst_RegFile_ConfigMem.Inst_frame3_bit13.Q
+ sg13g2_a21oi_1
X_3032_ FrameData[28] FrameStrobe[5] Inst_RegFile_ConfigMem.Inst_frame5_bit28.Q VPWR
+ VGND sg13g2_dlhq_1
X_2816_ FrameData[4] FrameStrobe[11] Inst_RegFile_ConfigMem.Inst_frame11_bit4.Q VPWR
+ VGND sg13g2_dlhq_1
X_2678_ _1067_ Inst_RegFile_32x4.mem\[7\]\[1\] _1126_ _0105_ VPWR VGND sg13g2_mux2_1
X_1629_ _0267_ _0143_ _0266_ VPWR VGND sg13g2_nand2_1
X_2747_ _1322_ VGND VPWR _0041_ Inst_RegFile_32x4.mem\[22\]\[1\] clknet_5_8__leaf_UserCLK_regs
+ sg13g2_dfrbpq_1
XFILLER_27_422 VPWR VGND sg13g2_fill_1
XFILLER_42_458 VPWR VGND sg13g2_fill_1
Xclkbuf_5_0__f_UserCLK_regs clknet_4_0_0_UserCLK_regs clknet_5_0__leaf_UserCLK_regs
+ VPWR VGND sg13g2_buf_8
XFILLER_10_399 VPWR VGND sg13g2_fill_2
XFILLER_33_414 VPWR VGND sg13g2_fill_2
X_1980_ _0593_ VPWR Inst_RegFile_switch_matrix.JN2BEG4 VGND Inst_RegFile_ConfigMem.Inst_frame4_bit19.Q
+ _0597_ sg13g2_o21ai_1
X_3581_ SS4END[5] net196 VPWR VGND sg13g2_buf_1
X_2532_ S2MID[1] W2MID[1] Inst_RegFile_ConfigMem.Inst_frame6_bit6.Q _1083_ VPWR VGND
+ sg13g2_mux2_1
X_2463_ Inst_RegFile_ConfigMem.Inst_frame12_bit6.Q AD3 _0645_ Inst_RegFile_switch_matrix.JW2BEG0
+ _0137_ Inst_RegFile_ConfigMem.Inst_frame12_bit7.Q Inst_RegFile_switch_matrix.N1BEG1
+ VPWR VGND sg13g2_mux4_1
X_2601_ _1065_ Inst_RegFile_32x4.mem\[23\]\[0\] _1110_ _0044_ VPWR VGND sg13g2_mux2_1
X_1414_ VGND VPWR _1170_ _1171_ _1172_ Inst_RegFile_ConfigMem.Inst_frame3_bit21.Q
+ sg13g2_a21oi_1
X_2394_ Inst_RegFile_ConfigMem.Inst_frame11_bit17.Q N1END[1] E1END[1] S1END[1] AD0
+ Inst_RegFile_ConfigMem.Inst_frame11_bit18.Q _0980_ VPWR VGND sg13g2_mux4_1
X_3015_ FrameData[11] FrameStrobe[5] Inst_RegFile_ConfigMem.Inst_frame5_bit11.Q VPWR
+ VGND sg13g2_dlhq_1
Xclkbuf_5_15__f_UserCLK_regs clknet_4_7_0_UserCLK_regs clknet_5_15__leaf_UserCLK_regs
+ VPWR VGND sg13g2_buf_8
XFILLER_15_458 VPWR VGND sg13g2_fill_1
Xclkbuf_4_3_0_UserCLK_regs clknet_0_UserCLK_regs clknet_4_3_0_UserCLK_regs VPWR VGND
+ sg13g2_buf_8
X_3633_ WW4END[8] net248 VPWR VGND sg13g2_buf_1
X_1894_ B_ADR0 Inst_RegFile_32x4.mem\[16\]\[1\] Inst_RegFile_32x4.mem\[17\]\[1\] Inst_RegFile_32x4.mem\[18\]\[1\]
+ Inst_RegFile_32x4.mem\[19\]\[1\] _0368_ _0518_ VPWR VGND sg13g2_mux4_1
X_1963_ Inst_RegFile_32x4.BD_comb\[2\] Inst_RegFile_32x4.BD_reg\[2\] Inst_RegFile_ConfigMem.Inst_frame12_bit3.Q
+ BD2 VPWR VGND sg13g2_mux2_1
X_3495_ Inst_RegFile_switch_matrix.N1BEG3 net104 VPWR VGND sg13g2_buf_1
X_2446_ Inst_RegFile_ConfigMem.Inst_frame10_bit9.Q S2END[0] W6END[1] S4END[3] AD2
+ Inst_RegFile_ConfigMem.Inst_frame10_bit8.Q Inst_RegFile_switch_matrix.S4BEG2 VPWR
+ VGND sg13g2_mux4_1
X_3564_ S4END[4] net173 VPWR VGND sg13g2_buf_1
X_2515_ _1067_ Inst_RegFile_32x4.mem\[24\]\[1\] _1062_ _0001_ VPWR VGND sg13g2_mux2_1
X_2377_ VPWR VGND Inst_RegFile_ConfigMem.Inst_frame11_bit21.Q Inst_RegFile_ConfigMem.Inst_frame11_bit22.Q
+ _0963_ _0960_ _0964_ _0961_ sg13g2_a221oi_1
XFILLER_17_15 VPWR VGND sg13g2_fill_1
XFILLER_17_48 VPWR VGND sg13g2_fill_2
XFILLER_15_211 VPWR VGND sg13g2_fill_1
X_3280_ VPWR VGND _1262_ sg13g2_tiehi
X_2300_ Inst_RegFile_ConfigMem.Inst_frame9_bit17.Q BD0 BD2 BD1 BD3 Inst_RegFile_ConfigMem.Inst_frame9_bit16.Q
+ _0898_ VPWR VGND sg13g2_mux4_1
X_2231_ Inst_RegFile_ConfigMem.Inst_frame2_bit3.Q _0833_ _0834_ VPWR VGND sg13g2_nor2_1
XFILLER_53_328 VPWR VGND sg13g2_fill_2
X_2093_ E6END[1] S2END[3] Inst_RegFile_ConfigMem.Inst_frame4_bit8.Q _0704_ VPWR VGND
+ sg13g2_mux2_1
X_2162_ VGND VPWR Inst_RegFile_ConfigMem.Inst_frame4_bit6.Q _0768_ _0769_ Inst_RegFile_ConfigMem.Inst_frame4_bit7.Q
+ sg13g2_a21oi_1
X_2995_ FrameData[23] FrameStrobe[6] Inst_RegFile_ConfigMem.Inst_frame6_bit23.Q VPWR
+ VGND sg13g2_dlhq_1
X_1946_ B_ADR0 Inst_RegFile_32x4.mem\[20\]\[2\] Inst_RegFile_32x4.mem\[21\]\[2\] Inst_RegFile_32x4.mem\[22\]\[2\]
+ Inst_RegFile_32x4.mem\[23\]\[2\] _0368_ _0566_ VPWR VGND sg13g2_mux4_1
X_3547_ Inst_RegFile_switch_matrix.S1BEG3 net156 VPWR VGND sg13g2_buf_1
X_3616_ W2MID[7] net225 VPWR VGND sg13g2_buf_1
X_1877_ B_ADR0 Inst_RegFile_32x4.mem\[28\]\[0\] Inst_RegFile_32x4.mem\[29\]\[0\] Inst_RegFile_32x4.mem\[30\]\[0\]
+ Inst_RegFile_32x4.mem\[31\]\[0\] _0368_ _0503_ VPWR VGND sg13g2_mux4_1
X_2429_ VGND VPWR Inst_RegFile_ConfigMem.Inst_frame12_bit20.Q _0363_ _1008_ _1160_
+ sg13g2_a21oi_1
X_3478_ FrameStrobe[6] net97 VPWR VGND sg13g2_buf_1
XFILLER_44_57 VPWR VGND sg13g2_fill_2
XFILLER_35_339 VPWR VGND sg13g2_fill_2
X_1800_ _0428_ VPWR Inst_RegFile_switch_matrix.JW2BEG4 VGND _0417_ _0424_ sg13g2_o21ai_1
X_1731_ Inst_RegFile_ConfigMem.Inst_frame5_bit26.Q N2END[3] E2END[3] SS4END[0] W2END[3]
+ Inst_RegFile_ConfigMem.Inst_frame5_bit27.Q _0362_ VPWR VGND sg13g2_mux4_1
X_1662_ _0298_ _0296_ _0297_ _0291_ _0143_ VPWR VGND sg13g2_a22oi_1
X_3401_ Inst_RegFile_switch_matrix.E2BEG5 net10 VPWR VGND sg13g2_buf_1
X_2780_ _1281_ VGND VPWR _0074_ Inst_RegFile_32x4.mem\[21\]\[2\] clknet_5_9__leaf_UserCLK_regs
+ sg13g2_dfrbpq_1
X_3332_ VPWR VGND _1314_ sg13g2_tiehi
X_1593_ VGND VPWR _0231_ _0232_ _0233_ Inst_RegFile_ConfigMem.Inst_frame8_bit20.Q
+ sg13g2_a21oi_1
X_3263_ VPWR VGND _1245_ sg13g2_tiehi
X_3194_ FrameData[30] FrameStrobe[0] Inst_RegFile_ConfigMem.Inst_frame0_bit30.Q VPWR
+ VGND sg13g2_dlhq_1
X_2214_ _0817_ VPWR _0818_ VGND Inst_RegFile_ConfigMem.Inst_frame2_bit29.Q _0816_
+ sg13g2_o21ai_1
X_2076_ Inst_RegFile_ConfigMem.Inst_frame3_bit8.Q E6END[1] S2END[3] SS4END[2] W2END[3]
+ Inst_RegFile_ConfigMem.Inst_frame3_bit9.Q _0688_ VPWR VGND sg13g2_mux4_1
X_2145_ Inst_RegFile_ConfigMem.Inst_frame3_bit4.Q N1END[0] _0753_ VPWR VGND sg13g2_nor2b_1
X_1929_ _0551_ _0550_ _0409_ _0549_ _0546_ VPWR VGND sg13g2_a22oi_1
X_2978_ FrameData[6] FrameStrobe[6] Inst_RegFile_ConfigMem.Inst_frame6_bit6.Q VPWR
+ VGND sg13g2_dlhq_1
XFILLER_14_16 VPWR VGND sg13g2_fill_1
X_2832_ FrameData[20] FrameStrobe[11] Inst_RegFile_ConfigMem.Inst_frame11_bit20.Q
+ VPWR VGND sg13g2_dlhq_1
X_2763_ _1298_ VGND VPWR _0057_ Inst_RegFile_32x4.mem\[16\]\[1\] clknet_5_0__leaf_UserCLK_regs
+ sg13g2_dfrbpq_1
X_2901_ FrameData[25] FrameStrobe[9] Inst_RegFile_ConfigMem.Inst_frame9_bit25.Q VPWR
+ VGND sg13g2_dlhq_1
X_2694_ Inst_RegFile_32x4.mem\[10\]\[2\] _1069_ _1129_ _0118_ VPWR VGND sg13g2_mux2_1
X_1714_ AD3 BD1 Inst_RegFile_ConfigMem.Inst_frame3_bit16.Q _0346_ VPWR VGND sg13g2_mux2_1
X_1576_ _0217_ Inst_RegFile_ConfigMem.Inst_frame3_bit24.Q BD0 VPWR VGND sg13g2_nand2_1
X_1645_ _0283_ _0282_ _1210_ VPWR VGND sg13g2_nand2b_1
X_3246_ _1373_ VGND VPWR _0118_ Inst_RegFile_32x4.mem\[10\]\[2\] clknet_5_21__leaf_UserCLK_regs
+ sg13g2_dfrbpq_1
X_3315_ VPWR VGND _1297_ sg13g2_tiehi
X_3177_ FrameData[13] FrameStrobe[0] Inst_RegFile_ConfigMem.Inst_frame0_bit13.Q VPWR
+ VGND sg13g2_dlhq_1
X_2059_ VPWR VGND _0671_ Inst_RegFile_ConfigMem.Inst_frame2_bit10.Q _0670_ Inst_RegFile_ConfigMem.Inst_frame2_bit9.Q
+ _0672_ _0669_ sg13g2_a221oi_1
X_2128_ VGND VPWR Inst_RegFile_ConfigMem.Inst_frame2_bit6.Q _0736_ _0737_ Inst_RegFile_ConfigMem.Inst_frame2_bit7.Q
+ sg13g2_a21oi_1
XFILLER_13_375 VPWR VGND sg13g2_fill_1
XFILLER_25_180 VPWR VGND sg13g2_decap_4
Xoutput109 net109 N2BEG[4] VPWR VGND sg13g2_buf_1
Xoutput1 net1 E1BEG[0] VPWR VGND sg13g2_buf_1
X_1430_ VGND VPWR _1187_ W6END[0] Inst_RegFile_ConfigMem.Inst_frame3_bit12.Q sg13g2_or2_1
XFILLER_48_261 VPWR VGND sg13g2_fill_2
X_3031_ FrameData[27] FrameStrobe[5] Inst_RegFile_ConfigMem.Inst_frame5_bit27.Q VPWR
+ VGND sg13g2_dlhq_1
Xoutput80 net80 FrameData_O[9] VPWR VGND sg13g2_buf_1
Xoutput91 net91 FrameStrobe_O[19] VPWR VGND sg13g2_buf_1
X_3100_ FrameData[0] FrameStrobe[2] Inst_RegFile_ConfigMem.Inst_frame2_bit0.Q VPWR
+ VGND sg13g2_dlhq_1
Xclkbuf_5_23__f_UserCLK_regs clknet_4_11_0_UserCLK_regs clknet_5_23__leaf_UserCLK_regs
+ VPWR VGND sg13g2_buf_8
X_2746_ _1323_ VGND VPWR _0040_ Inst_RegFile_32x4.mem\[22\]\[0\] clknet_5_11__leaf_UserCLK_regs
+ sg13g2_dfrbpq_1
X_2815_ FrameData[3] FrameStrobe[11] Inst_RegFile_ConfigMem.Inst_frame11_bit3.Q VPWR
+ VGND sg13g2_dlhq_1
X_2677_ _1065_ Inst_RegFile_32x4.mem\[7\]\[0\] _1126_ _0104_ VPWR VGND sg13g2_mux2_1
X_1559_ BD3 Inst_RegFile_ConfigMem.Inst_frame4_bit20.Q _0201_ VPWR VGND sg13g2_nor2b_1
X_1628_ A_ADR0 Inst_RegFile_32x4.mem\[2\]\[1\] Inst_RegFile_32x4.mem\[3\]\[1\] Inst_RegFile_32x4.mem\[0\]\[1\]
+ Inst_RegFile_32x4.mem\[1\]\[1\] _1210_ _0266_ VPWR VGND sg13g2_mux4_1
XFILLER_54_253 VPWR VGND sg13g2_fill_1
XFILLER_54_220 VPWR VGND sg13g2_fill_1
X_3229_ _1254_ VGND VPWR _0101_ Inst_RegFile_32x4.mem\[6\]\[1\] clknet_5_23__leaf_UserCLK_regs
+ sg13g2_dfrbpq_1
XFILLER_36_36 VPWR VGND sg13g2_fill_2
Xclkbuf_4_11_0_UserCLK_regs clknet_0_UserCLK_regs clknet_4_11_0_UserCLK_regs VPWR
+ VGND sg13g2_buf_8
XFILLER_18_401 VPWR VGND sg13g2_fill_1
XFILLER_33_448 VPWR VGND sg13g2_fill_1
X_3580_ SS4END[4] net189 VPWR VGND sg13g2_buf_1
XFILLER_9_154 VPWR VGND sg13g2_fill_2
X_2600_ _1110_ _1092_ _1108_ VPWR VGND sg13g2_nand2_1
X_1413_ _1171_ AD3 Inst_RegFile_ConfigMem.Inst_frame3_bit20.Q VPWR VGND sg13g2_nand2b_1
X_2393_ Inst_RegFile_ConfigMem.Inst_frame11_bit17.Q BD0 _1229_ _0388_ _0978_ Inst_RegFile_ConfigMem.Inst_frame11_bit18.Q
+ _0979_ VPWR VGND sg13g2_mux4_1
X_2531_ _1081_ VPWR _1082_ VGND N2MID[1] Inst_RegFile_ConfigMem.Inst_frame6_bit6.Q
+ sg13g2_o21ai_1
X_2462_ Inst_RegFile_ConfigMem.Inst_frame12_bit8.Q BD0 _0338_ Inst_RegFile_switch_matrix.JW2BEG1
+ _0429_ Inst_RegFile_ConfigMem.Inst_frame12_bit9.Q Inst_RegFile_switch_matrix.N1BEG2
+ VPWR VGND sg13g2_mux4_1
X_3014_ FrameData[10] FrameStrobe[5] Inst_RegFile_ConfigMem.Inst_frame5_bit10.Q VPWR
+ VGND sg13g2_dlhq_1
XFILLER_24_404 VPWR VGND sg13g2_fill_1
X_2729_ _1340_ VGND VPWR _0023_ Inst_RegFile_32x4.mem\[2\]\[3\] clknet_5_17__leaf_UserCLK_regs
+ sg13g2_dfrbpq_1
XFILLER_6_168 VPWR VGND sg13g2_fill_2
XFILLER_18_220 VPWR VGND sg13g2_fill_2
X_1962_ _0581_ _0491_ _0568_ Inst_RegFile_32x4.BD_comb\[2\] VPWR VGND sg13g2_a21o_1
X_3563_ S2MID[7] net172 VPWR VGND sg13g2_buf_1
X_3632_ WW4END[7] net247 VPWR VGND sg13g2_buf_1
X_1893_ _0517_ _0514_ _0516_ VPWR VGND sg13g2_nand2_1
X_3494_ Inst_RegFile_switch_matrix.N1BEG2 net103 VPWR VGND sg13g2_buf_1
X_2376_ VGND VPWR W1END[3] Inst_RegFile_ConfigMem.Inst_frame11_bit20.Q _0963_ _0962_
+ sg13g2_a21oi_1
X_2514_ Inst_RegFile_ConfigMem.Inst_frame9_bit22.Q _0484_ _0911_ _0994_ _1066_ Inst_RegFile_ConfigMem.Inst_frame9_bit23.Q
+ _1067_ VPWR VGND sg13g2_mux4_1
X_2445_ Inst_RegFile_ConfigMem.Inst_frame10_bit11.Q S2END[1] W6END[0] S4END[0] AD3
+ Inst_RegFile_ConfigMem.Inst_frame10_bit10.Q Inst_RegFile_switch_matrix.S4BEG3 VPWR
+ VGND sg13g2_mux4_1
X_2230_ VGND VPWR Inst_RegFile_ConfigMem.Inst_frame2_bit1.Q _0829_ _0833_ _0832_ sg13g2_a21oi_1
X_2092_ W2END[3] WW4END[2] Inst_RegFile_ConfigMem.Inst_frame4_bit8.Q _0703_ VPWR VGND
+ sg13g2_mux2_1
X_2161_ VPWR _0768_ _0767_ VGND sg13g2_inv_1
X_2994_ FrameData[22] FrameStrobe[6] Inst_RegFile_ConfigMem.Inst_frame6_bit22.Q VPWR
+ VGND sg13g2_dlhq_1
X_1945_ _0565_ _0564_ _0409_ VPWR VGND sg13g2_nand2b_1
X_3546_ Inst_RegFile_switch_matrix.S1BEG2 net155 VPWR VGND sg13g2_buf_1
X_1876_ _0501_ VPWR _0502_ VGND _0367_ _0500_ sg13g2_o21ai_1
X_3615_ W2MID[6] net224 VPWR VGND sg13g2_buf_1
X_3477_ FrameStrobe[5] net96 VPWR VGND sg13g2_buf_1
X_2428_ _1007_ _1006_ Inst_RegFile_ConfigMem.Inst_frame12_bit25.Q Inst_RegFile_switch_matrix.NN4BEG1
+ VPWR VGND sg13g2_mux2_1
XFILLER_0_119 VPWR VGND sg13g2_fill_1
X_2359_ VGND VPWR Inst_RegFile_ConfigMem.Inst_frame10_bit12.Q _0432_ _0948_ _1155_
+ sg13g2_a21oi_1
XFILLER_8_219 VPWR VGND sg13g2_fill_1
XFILLER_4_458 VPWR VGND sg13g2_fill_1
X_1661_ VGND VPWR _1210_ _0293_ _0297_ _0143_ sg13g2_a21oi_1
X_1730_ Inst_RegFile_ConfigMem.Inst_frame8_bit23.Q VPWR _0361_ VGND Inst_RegFile_ConfigMem.Inst_frame0_bit27.Q
+ _0360_ sg13g2_o21ai_1
X_1592_ VGND VPWR S2END[1] Inst_RegFile_ConfigMem.Inst_frame8_bit18.Q _0232_ Inst_RegFile_ConfigMem.Inst_frame8_bit19.Q
+ sg13g2_a21oi_1
X_3400_ Inst_RegFile_switch_matrix.E2BEG4 net9 VPWR VGND sg13g2_buf_1
X_3331_ VPWR VGND _1313_ sg13g2_tiehi
X_3262_ VPWR VGND _1244_ sg13g2_tiehi
X_2144_ VGND VPWR NN4END[1] Inst_RegFile_ConfigMem.Inst_frame3_bit4.Q _0752_ _0751_
+ sg13g2_a21oi_1
X_2213_ VGND VPWR Inst_RegFile_ConfigMem.Inst_frame2_bit29.Q _0814_ _0817_ _1150_
+ sg13g2_a21oi_1
X_3193_ FrameData[29] FrameStrobe[0] Inst_RegFile_ConfigMem.Inst_frame0_bit29.Q VPWR
+ VGND sg13g2_dlhq_1
X_2075_ Inst_RegFile_ConfigMem.Inst_frame3_bit8.Q N1END[1] N2END[3] N4END[3] E2END[3]
+ Inst_RegFile_ConfigMem.Inst_frame3_bit9.Q _0687_ VPWR VGND sg13g2_mux4_1
X_1928_ B_ADR0 Inst_RegFile_32x4.mem\[12\]\[3\] Inst_RegFile_32x4.mem\[13\]\[3\] Inst_RegFile_32x4.mem\[14\]\[3\]
+ Inst_RegFile_32x4.mem\[15\]\[3\] _0368_ _0550_ VPWR VGND sg13g2_mux4_1
X_2977_ FrameData[5] FrameStrobe[6] Inst_RegFile_ConfigMem.Inst_frame6_bit5.Q VPWR
+ VGND sg13g2_dlhq_1
XFILLER_14_39 VPWR VGND sg13g2_fill_1
X_1859_ _0485_ _0484_ Inst_RegFile_ConfigMem.Inst_frame8_bit29.Q VPWR VGND sg13g2_nand2b_1
X_3529_ NN4END[5] net144 VPWR VGND sg13g2_buf_1
X_2900_ FrameData[24] FrameStrobe[9] Inst_RegFile_ConfigMem.Inst_frame9_bit24.Q VPWR
+ VGND sg13g2_dlhq_1
Xclkbuf_5_31__f_UserCLK_regs clknet_4_15_0_UserCLK_regs clknet_5_31__leaf_UserCLK_regs
+ VPWR VGND sg13g2_buf_8
X_2831_ FrameData[19] FrameStrobe[11] Inst_RegFile_ConfigMem.Inst_frame11_bit19.Q
+ VPWR VGND sg13g2_dlhq_1
X_1713_ VGND VPWR _1133_ _0344_ _0345_ Inst_RegFile_ConfigMem.Inst_frame3_bit18.Q
+ sg13g2_a21oi_1
XFILLER_31_332 VPWR VGND sg13g2_fill_2
X_2762_ _1299_ VGND VPWR _0056_ Inst_RegFile_32x4.mem\[16\]\[0\] clknet_5_1__leaf_UserCLK_regs
+ sg13g2_dfrbpq_1
X_2693_ Inst_RegFile_32x4.mem\[10\]\[1\] _1067_ _1129_ _0117_ VPWR VGND sg13g2_mux2_1
X_1575_ VPWR VGND _0215_ Inst_RegFile_ConfigMem.Inst_frame3_bit26.Q _0214_ Inst_RegFile_ConfigMem.Inst_frame3_bit25.Q
+ _0216_ _0213_ sg13g2_a221oi_1
X_1644_ VGND VPWR Inst_RegFile_32x4.mem\[23\]\[1\] A_ADR0 _0282_ _0281_ sg13g2_a21oi_1
X_3314_ VPWR VGND _1296_ sg13g2_tiehi
X_3245_ _1238_ VGND VPWR _0117_ Inst_RegFile_32x4.mem\[10\]\[1\] clknet_5_21__leaf_UserCLK_regs
+ sg13g2_dfrbpq_1
X_2127_ VPWR _0736_ _0735_ VGND sg13g2_inv_1
X_3176_ FrameData[12] FrameStrobe[0] Inst_RegFile_ConfigMem.Inst_frame0_bit12.Q VPWR
+ VGND sg13g2_dlhq_1
X_2058_ VGND VPWR Inst_RegFile_ConfigMem.Inst_frame2_bit8.Q _1166_ _0671_ Inst_RegFile_ConfigMem.Inst_frame2_bit9.Q
+ sg13g2_a21oi_1
XFILLER_45_424 VPWR VGND sg13g2_fill_1
Xoutput70 net70 FrameData_O[29] VPWR VGND sg13g2_buf_1
Xclkbuf_5_10__f_UserCLK_regs clknet_4_5_0_UserCLK_regs clknet_5_10__leaf_UserCLK_regs
+ VPWR VGND sg13g2_buf_8
Xoutput2 net2 E1BEG[1] VPWR VGND sg13g2_buf_1
Xoutput92 net92 FrameStrobe_O[1] VPWR VGND sg13g2_buf_1
Xoutput81 net81 FrameStrobe_O[0] VPWR VGND sg13g2_buf_1
X_3030_ FrameData[26] FrameStrobe[5] Inst_RegFile_ConfigMem.Inst_frame5_bit26.Q VPWR
+ VGND sg13g2_dlhq_1
XFILLER_36_457 VPWR VGND sg13g2_fill_2
XFILLER_31_151 VPWR VGND sg13g2_decap_8
X_2676_ _1126_ _1092_ _1122_ VPWR VGND sg13g2_nand2_1
X_2745_ _1324_ VGND VPWR _0039_ Inst_RegFile_32x4.mem\[17\]\[3\] clknet_5_3__leaf_UserCLK_regs
+ sg13g2_dfrbpq_1
X_2814_ FrameData[2] FrameStrobe[11] Inst_RegFile_ConfigMem.Inst_frame11_bit2.Q VPWR
+ VGND sg13g2_dlhq_1
X_1558_ VGND VPWR _0198_ _0199_ _0200_ Inst_RegFile_ConfigMem.Inst_frame4_bit21.Q
+ sg13g2_a21oi_1
X_1627_ VGND VPWR _0142_ _0264_ _0265_ _0186_ sg13g2_a21oi_1
X_1489_ E6END[0] S2END[4] Inst_RegFile_ConfigMem.Inst_frame2_bit12.Q _0134_ VPWR VGND
+ sg13g2_mux2_1
X_3228_ _1255_ VGND VPWR _0100_ Inst_RegFile_32x4.mem\[6\]\[0\] clknet_5_31__leaf_UserCLK_regs
+ sg13g2_dfrbpq_1
X_3159_ FrameData[27] FrameStrobe[1] Inst_RegFile_ConfigMem.Inst_frame1_bit27.Q VPWR
+ VGND sg13g2_dlhq_1
XFILLER_45_254 VPWR VGND sg13g2_fill_2
X_2530_ _1081_ Inst_RegFile_ConfigMem.Inst_frame6_bit6.Q E2MID[1] VPWR VGND sg13g2_nand2b_1
X_1412_ _1170_ Inst_RegFile_ConfigMem.Inst_frame3_bit20.Q BD0 VPWR VGND sg13g2_nand2_1
X_2461_ Inst_RegFile_ConfigMem.Inst_frame12_bit10.Q BD1 _0486_ Inst_RegFile_switch_matrix.JW2BEG2
+ _1016_ Inst_RegFile_ConfigMem.Inst_frame12_bit11.Q Inst_RegFile_switch_matrix.N1BEG3
+ VPWR VGND sg13g2_mux4_1
X_2392_ Inst_RegFile_ConfigMem.Inst_frame5_bit0.Q N2END[6] E2END[6] SS4END[3] W2END[6]
+ Inst_RegFile_ConfigMem.Inst_frame5_bit1.Q _0978_ VPWR VGND sg13g2_mux4_1
XFILLER_36_265 VPWR VGND sg13g2_fill_2
X_3013_ FrameData[9] FrameStrobe[5] Inst_RegFile_ConfigMem.Inst_frame5_bit9.Q VPWR
+ VGND sg13g2_dlhq_1
X_2728_ _1341_ VGND VPWR _0022_ Inst_RegFile_32x4.mem\[2\]\[2\] clknet_5_25__leaf_UserCLK_regs
+ sg13g2_dfrbpq_1
X_2659_ _1087_ Inst_RegFile_32x4.mem\[3\]\[3\] _1121_ _0091_ VPWR VGND sg13g2_mux2_1
XFILLER_30_419 VPWR VGND sg13g2_fill_2
XFILLER_12_50 VPWR VGND sg13g2_fill_1
XFILLER_5_0 VPWR VGND sg13g2_fill_1
XFILLER_2_320 VPWR VGND sg13g2_fill_1
XFILLER_33_202 VPWR VGND sg13g2_fill_2
X_1961_ _0581_ _0578_ _0580_ _0576_ _0460_ VPWR VGND sg13g2_a22oi_1
X_1892_ VGND VPWR _0409_ _0515_ _0516_ _0459_ sg13g2_a21oi_1
XFILLER_14_471 VPWR VGND sg13g2_fill_1
X_3493_ Inst_RegFile_switch_matrix.N1BEG1 net102 VPWR VGND sg13g2_buf_1
X_2513_ Inst_RegFile_ConfigMem.Inst_frame0_bit3.Q EE4END[2] W2END[7] S4END[2] Inst_RegFile_switch_matrix.E2BEG1
+ Inst_RegFile_ConfigMem.Inst_frame0_bit2.Q _1066_ VPWR VGND sg13g2_mux4_1
X_3631_ WW4END[6] net246 VPWR VGND sg13g2_buf_1
X_3562_ S2MID[6] net171 VPWR VGND sg13g2_buf_1
X_2375_ Inst_RegFile_ConfigMem.Inst_frame11_bit20.Q SS4END[0] _0962_ VPWR VGND sg13g2_nor2b_1
XFILLER_38_0 VPWR VGND sg13g2_fill_2
X_2444_ Inst_RegFile_ConfigMem.Inst_frame10_bit25.Q BD1 Inst_RegFile_switch_matrix.JS2BEG3
+ _1018_ _1017_ Inst_RegFile_ConfigMem.Inst_frame10_bit24.Q Inst_RegFile_switch_matrix.W1BEG0
+ VPWR VGND sg13g2_mux4_1
XFILLER_30_249 VPWR VGND sg13g2_fill_2
XFILLER_15_246 VPWR VGND sg13g2_fill_1
X_2160_ Inst_RegFile_ConfigMem.Inst_frame4_bit4.Q EE4END[1] E6END[0] S2END[2] W2END[2]
+ Inst_RegFile_ConfigMem.Inst_frame4_bit5.Q _0767_ VPWR VGND sg13g2_mux4_1
X_2091_ Inst_RegFile_ConfigMem.Inst_frame4_bit9.Q N2END[3] E1END[1] N4END[3] E2END[3]
+ Inst_RegFile_ConfigMem.Inst_frame4_bit8.Q _0702_ VPWR VGND sg13g2_mux4_1
X_3614_ W2MID[5] net223 VPWR VGND sg13g2_buf_1
X_1944_ B_ADR0 Inst_RegFile_32x4.mem\[16\]\[2\] Inst_RegFile_32x4.mem\[17\]\[2\] Inst_RegFile_32x4.mem\[18\]\[2\]
+ Inst_RegFile_32x4.mem\[19\]\[2\] _0368_ _0564_ VPWR VGND sg13g2_mux4_1
X_2993_ FrameData[21] FrameStrobe[6] Inst_RegFile_ConfigMem.Inst_frame6_bit21.Q VPWR
+ VGND sg13g2_dlhq_1
X_1875_ VGND VPWR _0367_ _0499_ _0501_ _0409_ sg13g2_a21oi_1
X_3476_ FrameStrobe[4] net95 VPWR VGND sg13g2_buf_1
X_2427_ Inst_RegFile_ConfigMem.Inst_frame12_bit23.Q N1END[3] E1END[3] W1END[3] AD2
+ Inst_RegFile_ConfigMem.Inst_frame12_bit24.Q _1007_ VPWR VGND sg13g2_mux4_1
X_3545_ Inst_RegFile_switch_matrix.S1BEG1 net154 VPWR VGND sg13g2_buf_1
X_2289_ _0882_ _0887_ Inst_RegFile_ConfigMem.Inst_frame4_bit3.Q _0888_ VPWR VGND sg13g2_nand3_1
X_2358_ _0947_ _0946_ Inst_RegFile_ConfigMem.Inst_frame10_bit17.Q Inst_RegFile_switch_matrix.SS4BEG1
+ VPWR VGND sg13g2_mux2_1
X_1660_ _0296_ _0295_ _1210_ VPWR VGND sg13g2_nand2b_1
X_1591_ _0231_ N2END[1] Inst_RegFile_ConfigMem.Inst_frame8_bit18.Q VPWR VGND sg13g2_nand2b_1
X_3330_ VPWR VGND _1312_ sg13g2_tiehi
X_3261_ VPWR VGND _1243_ sg13g2_tiehi
X_2143_ Inst_RegFile_ConfigMem.Inst_frame3_bit4.Q N4END[2] _0751_ VPWR VGND sg13g2_nor2b_1
X_2212_ VGND VPWR S2END[0] Inst_RegFile_ConfigMem.Inst_frame2_bit28.Q _0816_ _0815_
+ sg13g2_a21oi_1
X_3192_ FrameData[28] FrameStrobe[0] Inst_RegFile_ConfigMem.Inst_frame0_bit28.Q VPWR
+ VGND sg13g2_dlhq_1
X_2074_ VGND VPWR _0686_ _0685_ _0684_ sg13g2_or2_1
X_1927_ VGND VPWR _0367_ _0548_ _0549_ _0409_ sg13g2_a21oi_1
X_2976_ FrameData[4] FrameStrobe[6] Inst_RegFile_ConfigMem.Inst_frame6_bit4.Q VPWR
+ VGND sg13g2_dlhq_1
X_1858_ Inst_RegFile_ConfigMem.Inst_frame7_bit3.Q E2MID[2] W2MID[2] S2MID[2] Inst_RegFile_switch_matrix.E2BEG3
+ Inst_RegFile_ConfigMem.Inst_frame7_bit2.Q _0484_ VPWR VGND sg13g2_mux4_1
X_3459_ FrameData[19] net59 VPWR VGND sg13g2_buf_1
X_1789_ _0418_ Inst_RegFile_ConfigMem.Inst_frame1_bit16.Q BD1 VPWR VGND sg13g2_nand2_1
X_3528_ NN4END[4] net137 VPWR VGND sg13g2_buf_1
XFILLER_52_160 VPWR VGND sg13g2_fill_2
X_2830_ FrameData[18] FrameStrobe[11] Inst_RegFile_ConfigMem.Inst_frame11_bit18.Q
+ VPWR VGND sg13g2_dlhq_1
XANTENNA_1 VPWR VGND EE4END[11] sg13g2_antennanp
X_2692_ Inst_RegFile_32x4.mem\[10\]\[0\] _1065_ _1129_ _0116_ VPWR VGND sg13g2_mux2_1
X_1712_ W1END[1] AD0 Inst_RegFile_ConfigMem.Inst_frame3_bit16.Q _0344_ VPWR VGND sg13g2_mux2_1
X_2761_ _1300_ VGND VPWR _0055_ Inst_RegFile_32x4.mem\[15\]\[3\] clknet_5_26__leaf_UserCLK_regs
+ sg13g2_dfrbpq_1
X_1643_ A_ADR0 Inst_RegFile_32x4.mem\[22\]\[1\] _0281_ VPWR VGND sg13g2_nor2b_1
X_3244_ _1239_ VGND VPWR _0116_ Inst_RegFile_32x4.mem\[10\]\[0\] clknet_5_17__leaf_UserCLK_regs
+ sg13g2_dfrbpq_1
X_1574_ VGND VPWR Inst_RegFile_ConfigMem.Inst_frame3_bit24.Q _1166_ _0215_ Inst_RegFile_ConfigMem.Inst_frame3_bit25.Q
+ sg13g2_a21oi_1
X_3313_ VPWR VGND _1295_ sg13g2_tiehi
X_2057_ VGND VPWR _0670_ Inst_RegFile_ConfigMem.Inst_frame2_bit8.Q W6END[1] sg13g2_or2_1
X_2126_ Inst_RegFile_ConfigMem.Inst_frame2_bit4.Q S2END[2] S4END[2] W2END[2] WW4END[1]
+ Inst_RegFile_ConfigMem.Inst_frame2_bit5.Q _0735_ VPWR VGND sg13g2_mux4_1
XFILLER_20_0 VPWR VGND sg13g2_fill_2
X_3175_ FrameData[11] FrameStrobe[0] Inst_RegFile_ConfigMem.Inst_frame0_bit11.Q VPWR
+ VGND sg13g2_dlhq_1
X_2959_ FrameData[19] FrameStrobe[7] Inst_RegFile_ConfigMem.Inst_frame7_bit19.Q VPWR
+ VGND sg13g2_dlhq_1
Xoutput93 net93 FrameStrobe_O[2] VPWR VGND sg13g2_buf_1
Xoutput82 net82 FrameStrobe_O[10] VPWR VGND sg13g2_buf_1
Xoutput71 net71 FrameData_O[2] VPWR VGND sg13g2_buf_1
Xoutput60 net60 FrameData_O[1] VPWR VGND sg13g2_buf_1
Xoutput3 net3 E1BEG[2] VPWR VGND sg13g2_buf_1
XFILLER_51_417 VPWR VGND sg13g2_fill_1
X_2813_ FrameData[1] FrameStrobe[11] Inst_RegFile_ConfigMem.Inst_frame11_bit1.Q VPWR
+ VGND sg13g2_dlhq_1
X_2675_ Inst_RegFile_32x4.mem\[6\]\[3\] _1087_ _1125_ _0103_ VPWR VGND sg13g2_mux2_1
X_1626_ A_ADR0 Inst_RegFile_32x4.mem\[14\]\[1\] Inst_RegFile_32x4.mem\[15\]\[1\] Inst_RegFile_32x4.mem\[12\]\[1\]
+ Inst_RegFile_32x4.mem\[13\]\[1\] _1210_ _0264_ VPWR VGND sg13g2_mux4_1
X_2744_ _1325_ VGND VPWR _0038_ Inst_RegFile_32x4.mem\[17\]\[2\] clknet_5_0__leaf_UserCLK_regs
+ sg13g2_dfrbpq_1
X_1557_ _0199_ AD3 Inst_RegFile_ConfigMem.Inst_frame4_bit20.Q VPWR VGND sg13g2_nand2b_1
X_3227_ _1256_ VGND VPWR _0099_ Inst_RegFile_32x4.mem\[5\]\[3\] clknet_5_28__leaf_UserCLK_regs
+ sg13g2_dfrbpq_1
X_1488_ S4END[0] W2END[4] Inst_RegFile_ConfigMem.Inst_frame2_bit12.Q _0133_ VPWR VGND
+ sg13g2_mux2_1
XFILLER_54_233 VPWR VGND sg13g2_fill_2
X_3089_ FrameData[21] FrameStrobe[3] Inst_RegFile_ConfigMem.Inst_frame3_bit21.Q VPWR
+ VGND sg13g2_dlhq_1
X_3158_ FrameData[26] FrameStrobe[1] Inst_RegFile_ConfigMem.Inst_frame1_bit26.Q VPWR
+ VGND sg13g2_dlhq_1
XFILLER_42_428 VPWR VGND sg13g2_fill_2
XFILLER_36_38 VPWR VGND sg13g2_fill_1
X_2109_ _0713_ _0718_ Inst_RegFile_ConfigMem.Inst_frame1_bit7.Q _0719_ VPWR VGND sg13g2_nand3_1
XFILLER_45_288 VPWR VGND sg13g2_fill_1
XFILLER_41_483 VPWR VGND sg13g2_fill_2
XFILLER_9_101 VPWR VGND sg13g2_fill_1
XFILLER_9_156 VPWR VGND sg13g2_fill_1
X_2460_ Inst_RegFile_ConfigMem.Inst_frame12_bit12.Q N2END[2] N4END[1] E6END[1] BD0
+ Inst_RegFile_ConfigMem.Inst_frame12_bit13.Q Inst_RegFile_switch_matrix.N4BEG0 VPWR
+ VGND sg13g2_mux4_1
X_1411_ VGND VPWR Inst_RegFile_ConfigMem.Inst_frame3_bit20.Q _1165_ _1169_ _1168_
+ sg13g2_a21oi_1
X_2391_ Inst_RegFile_switch_matrix.E6BEG0 _0975_ _0977_ _0970_ _1157_ VPWR VGND sg13g2_a22oi_1
X_3012_ FrameData[8] FrameStrobe[5] Inst_RegFile_ConfigMem.Inst_frame5_bit8.Q VPWR
+ VGND sg13g2_dlhq_1
XFILLER_22_29 VPWR VGND sg13g2_fill_1
X_2658_ _1069_ Inst_RegFile_32x4.mem\[3\]\[2\] _1121_ _0090_ VPWR VGND sg13g2_mux2_1
X_2727_ _1342_ VGND VPWR _0021_ Inst_RegFile_32x4.mem\[2\]\[1\] clknet_5_16__leaf_UserCLK_regs
+ sg13g2_dfrbpq_1
X_2589_ _1107_ _1088_ _1106_ VPWR VGND sg13g2_nand2_1
X_1609_ A_ADR0 Inst_RegFile_32x4.mem\[30\]\[0\] Inst_RegFile_32x4.mem\[31\]\[0\] Inst_RegFile_32x4.mem\[28\]\[0\]
+ Inst_RegFile_32x4.mem\[29\]\[0\] _1210_ _0249_ VPWR VGND sg13g2_mux4_1
XFILLER_23_483 VPWR VGND sg13g2_fill_2
X_1960_ VGND VPWR _0409_ _0579_ _0580_ _0460_ sg13g2_a21oi_1
X_3630_ WW4END[5] net245 VPWR VGND sg13g2_buf_1
X_1891_ B_ADR0 Inst_RegFile_32x4.mem\[28\]\[1\] Inst_RegFile_32x4.mem\[29\]\[1\] Inst_RegFile_32x4.mem\[30\]\[1\]
+ Inst_RegFile_32x4.mem\[31\]\[1\] _0368_ _0515_ VPWR VGND sg13g2_mux4_1
X_3492_ Inst_RegFile_switch_matrix.N1BEG0 net101 VPWR VGND sg13g2_buf_1
X_3561_ S2MID[5] net170 VPWR VGND sg13g2_buf_1
X_2443_ Inst_RegFile_ConfigMem.Inst_frame6_bit14.Q N2MID[1] E2MID[1] S2MID[1] W2MID[1]
+ Inst_RegFile_ConfigMem.Inst_frame6_bit15.Q _1018_ VPWR VGND sg13g2_mux4_1
X_2512_ _1065_ Inst_RegFile_32x4.mem\[24\]\[0\] _1062_ _0000_ VPWR VGND sg13g2_mux2_1
X_2374_ VGND VPWR E1END[3] Inst_RegFile_ConfigMem.Inst_frame11_bit20.Q _0961_ Inst_RegFile_ConfigMem.Inst_frame11_bit21.Q
+ sg13g2_a21oi_1
Xoutput250 net250 WW4BEG[6] VPWR VGND sg13g2_buf_1
XFILLER_7_457 VPWR VGND sg13g2_fill_1
X_2090_ _0701_ Inst_RegFile_ConfigMem.Inst_frame4_bit11.Q _0700_ VPWR VGND sg13g2_nand2_1
XFILLER_53_309 VPWR VGND sg13g2_fill_2
X_2992_ FrameData[20] FrameStrobe[6] Inst_RegFile_ConfigMem.Inst_frame6_bit20.Q VPWR
+ VGND sg13g2_dlhq_1
X_3613_ W2MID[4] net222 VPWR VGND sg13g2_buf_1
X_1943_ VGND VPWR _0409_ _0562_ _0563_ _0459_ sg13g2_a21oi_1
X_1874_ Inst_RegFile_32x4.mem\[26\]\[0\] Inst_RegFile_32x4.mem\[27\]\[0\] B_ADR0 _0500_
+ VPWR VGND sg13g2_mux2_1
X_3475_ FrameStrobe[3] net94 VPWR VGND sg13g2_buf_1
Xclkbuf_0_UserCLK UserCLK clknet_0_UserCLK VPWR VGND sg13g2_buf_8
XFILLER_50_0 VPWR VGND sg13g2_fill_2
X_2426_ Inst_RegFile_ConfigMem.Inst_frame12_bit24.Q BD2 _0895_ _0896_ _1207_ Inst_RegFile_ConfigMem.Inst_frame12_bit23.Q
+ _1006_ VPWR VGND sg13g2_mux4_1
X_3544_ Inst_RegFile_switch_matrix.S1BEG0 net153 VPWR VGND sg13g2_buf_1
X_2357_ Inst_RegFile_ConfigMem.Inst_frame10_bit15.Q N1END[3] E1END[3] W1END[3] AD2
+ Inst_RegFile_ConfigMem.Inst_frame10_bit16.Q _0947_ VPWR VGND sg13g2_mux4_1
X_2288_ _0884_ _0886_ Inst_RegFile_ConfigMem.Inst_frame4_bit2.Q _0887_ VPWR VGND sg13g2_nand3_1
XFILLER_52_353 VPWR VGND sg13g2_fill_2
X_3260_ VPWR VGND _1242_ sg13g2_tiehi
X_1590_ _0228_ _0229_ Inst_RegFile_ConfigMem.Inst_frame8_bit18.Q _0230_ VPWR VGND
+ sg13g2_mux2_1
XFILLER_53_139 VPWR VGND sg13g2_fill_1
X_2073_ Inst_RegFile_ConfigMem.Inst_frame3_bit11.Q VPWR _0685_ VGND _0679_ _0682_
+ sg13g2_o21ai_1
X_3191_ FrameData[27] FrameStrobe[0] Inst_RegFile_ConfigMem.Inst_frame0_bit27.Q VPWR
+ VGND sg13g2_dlhq_1
X_2211_ Inst_RegFile_ConfigMem.Inst_frame2_bit28.Q S1END[0] _0815_ VPWR VGND sg13g2_nor2b_1
X_2142_ VGND VPWR W2END[2] Inst_RegFile_ConfigMem.Inst_frame3_bit4.Q _0750_ _0749_
+ sg13g2_a21oi_1
X_2975_ FrameData[3] FrameStrobe[6] Inst_RegFile_ConfigMem.Inst_frame6_bit3.Q VPWR
+ VGND sg13g2_dlhq_1
X_3527_ Inst_RegFile_switch_matrix.N4BEG3 net127 VPWR VGND sg13g2_buf_1
X_1926_ VGND VPWR Inst_RegFile_32x4.mem\[9\]\[3\] B_ADR0 _0548_ _0547_ sg13g2_a21oi_1
X_1788_ VPWR VGND _0416_ Inst_RegFile_ConfigMem.Inst_frame1_bit18.Q _0415_ Inst_RegFile_ConfigMem.Inst_frame1_bit17.Q
+ _0417_ _0414_ sg13g2_a221oi_1
X_1857_ Inst_RegFile_ConfigMem.Inst_frame8_bit30.Q _0165_ Inst_RegFile_switch_matrix.JS2BEG6
+ Inst_RegFile_switch_matrix.JN2BEG6 Inst_RegFile_switch_matrix.JW2BEG6 Inst_RegFile_ConfigMem.Inst_frame8_bit29.Q
+ _0483_ VPWR VGND sg13g2_mux4_1
X_3458_ FrameData[18] net58 VPWR VGND sg13g2_buf_1
X_2409_ Inst_RegFile_ConfigMem.Inst_frame11_bit9.Q BD1 _0910_ _0911_ _0603_ Inst_RegFile_ConfigMem.Inst_frame11_bit8.Q
+ _0992_ VPWR VGND sg13g2_mux4_1
X_3389_ VPWR VGND _1371_ sg13g2_tiehi
XFILLER_25_342 VPWR VGND sg13g2_fill_2
XFILLER_35_128 VPWR VGND sg13g2_fill_2
XFILLER_0_485 VPWR VGND sg13g2_fill_1
XFILLER_16_353 VPWR VGND sg13g2_fill_1
XANTENNA_2 VPWR VGND EE4END[12] sg13g2_antennanp
X_2691_ _1090_ _1101_ _1129_ VPWR VGND sg13g2_and2_1
X_1711_ _0343_ Inst_RegFile_ConfigMem.Inst_frame3_bit17.Q _0342_ VPWR VGND sg13g2_nand2_1
X_2760_ _1301_ VGND VPWR _0054_ Inst_RegFile_32x4.mem\[15\]\[2\] clknet_5_19__leaf_UserCLK_regs
+ sg13g2_dfrbpq_1
X_1642_ VGND VPWR Inst_RegFile_32x4.mem\[21\]\[1\] A_ADR0 _0280_ _0279_ sg13g2_a21oi_1
X_3243_ _1240_ VGND VPWR _0115_ Inst_RegFile_32x4.mem\[0\]\[3\] clknet_5_19__leaf_UserCLK_regs
+ sg13g2_dfrbpq_1
X_1573_ VGND VPWR _0214_ Inst_RegFile_ConfigMem.Inst_frame3_bit24.Q W1END[3] sg13g2_or2_1
X_3312_ VPWR VGND _1294_ sg13g2_tiehi
X_2056_ _0668_ VPWR _0669_ VGND Inst_RegFile_ConfigMem.Inst_frame2_bit8.Q _1167_ sg13g2_o21ai_1
X_2125_ Inst_RegFile_ConfigMem.Inst_frame2_bit5.Q N2END[2] E2END[2] E1END[0] E6END[0]
+ Inst_RegFile_ConfigMem.Inst_frame2_bit4.Q _0734_ VPWR VGND sg13g2_mux4_1
XFILLER_13_0 VPWR VGND sg13g2_fill_2
X_3174_ FrameData[10] FrameStrobe[0] Inst_RegFile_ConfigMem.Inst_frame0_bit10.Q VPWR
+ VGND sg13g2_dlhq_1
X_1909_ Inst_RegFile_32x4.BD_comb\[1\] Inst_RegFile_32x4.BD_reg\[1\] Inst_RegFile_ConfigMem.Inst_frame12_bit3.Q
+ BD1 VPWR VGND sg13g2_mux2_1
X_2958_ FrameData[18] FrameStrobe[7] Inst_RegFile_ConfigMem.Inst_frame7_bit18.Q VPWR
+ VGND sg13g2_dlhq_1
X_2889_ FrameData[13] FrameStrobe[9] Inst_RegFile_ConfigMem.Inst_frame9_bit13.Q VPWR
+ VGND sg13g2_dlhq_1
XFILLER_9_316 VPWR VGND sg13g2_fill_1
XFILLER_13_345 VPWR VGND sg13g2_fill_1
XFILLER_25_161 VPWR VGND sg13g2_fill_2
XFILLER_9_349 VPWR VGND sg13g2_fill_1
Xoutput94 net94 FrameStrobe_O[3] VPWR VGND sg13g2_buf_1
Xoutput83 net83 FrameStrobe_O[11] VPWR VGND sg13g2_buf_1
Xoutput72 net72 FrameData_O[30] VPWR VGND sg13g2_buf_1
Xoutput50 net50 FrameData_O[10] VPWR VGND sg13g2_buf_1
Xoutput61 net61 FrameData_O[20] VPWR VGND sg13g2_buf_1
Xoutput4 net4 E1BEG[3] VPWR VGND sg13g2_buf_1
XFILLER_36_459 VPWR VGND sg13g2_fill_1
X_2743_ _1326_ VGND VPWR _0037_ Inst_RegFile_32x4.mem\[17\]\[1\] clknet_5_1__leaf_UserCLK_regs
+ sg13g2_dfrbpq_1
X_2812_ FrameData[0] FrameStrobe[11] Inst_RegFile_ConfigMem.Inst_frame11_bit0.Q VPWR
+ VGND sg13g2_dlhq_1
X_1625_ _0263_ _0143_ _0262_ VPWR VGND sg13g2_nand2_1
X_1556_ _0198_ Inst_RegFile_ConfigMem.Inst_frame4_bit20.Q BD0 VPWR VGND sg13g2_nand2_1
X_2674_ Inst_RegFile_32x4.mem\[6\]\[2\] _1069_ _1125_ _0102_ VPWR VGND sg13g2_mux2_1
X_3157_ FrameData[25] FrameStrobe[1] Inst_RegFile_ConfigMem.Inst_frame1_bit25.Q VPWR
+ VGND sg13g2_dlhq_1
X_3226_ _1257_ VGND VPWR _0098_ Inst_RegFile_32x4.mem\[5\]\[2\] clknet_5_31__leaf_UserCLK_regs
+ sg13g2_dfrbpq_1
XFILLER_39_242 VPWR VGND sg13g2_fill_2
X_1487_ N2END[4] E1END[2] Inst_RegFile_ConfigMem.Inst_frame2_bit12.Q _0132_ VPWR VGND
+ sg13g2_mux2_1
X_3088_ FrameData[20] FrameStrobe[3] Inst_RegFile_ConfigMem.Inst_frame3_bit20.Q VPWR
+ VGND sg13g2_dlhq_1
X_2039_ _0652_ VPWR _0653_ VGND Inst_RegFile_ConfigMem.Inst_frame1_bit9.Q _0650_ sg13g2_o21ai_1
XFILLER_42_407 VPWR VGND sg13g2_fill_2
X_2108_ _0715_ _0717_ Inst_RegFile_ConfigMem.Inst_frame1_bit6.Q _0718_ VPWR VGND sg13g2_nand3_1
XFILLER_10_337 VPWR VGND sg13g2_fill_1
XFILLER_45_256 VPWR VGND sg13g2_fill_1
XFILLER_13_131 VPWR VGND sg13g2_fill_1
X_1410_ Inst_RegFile_ConfigMem.Inst_frame3_bit21.Q VPWR _1168_ VGND Inst_RegFile_ConfigMem.Inst_frame3_bit20.Q
+ BD2 sg13g2_o21ai_1
X_2390_ VGND VPWR _1156_ _0976_ _0977_ _1157_ sg13g2_a21oi_1
X_3011_ FrameData[7] FrameStrobe[5] Inst_RegFile_ConfigMem.Inst_frame5_bit7.Q VPWR
+ VGND sg13g2_dlhq_1
XFILLER_36_289 VPWR VGND sg13g2_fill_2
XFILLER_36_267 VPWR VGND sg13g2_fill_1
X_2726_ _1343_ VGND VPWR _0020_ Inst_RegFile_32x4.mem\[2\]\[0\] clknet_5_19__leaf_UserCLK_regs
+ sg13g2_dfrbpq_1
XFILLER_32_484 VPWR VGND sg13g2_fill_2
X_2657_ _1067_ Inst_RegFile_32x4.mem\[3\]\[1\] _1121_ _0089_ VPWR VGND sg13g2_mux2_1
X_2588_ _1033_ _1105_ _1106_ VPWR VGND sg13g2_nor2_1
X_1539_ Inst_RegFile_ConfigMem.Inst_frame6_bit22.Q N2MID[1] E2MID[1] S2MID[1] W2MID[1]
+ Inst_RegFile_ConfigMem.Inst_frame6_bit23.Q _0181_ VPWR VGND sg13g2_mux4_1
X_1608_ A_ADR0 Inst_RegFile_32x4.mem\[26\]\[0\] Inst_RegFile_32x4.mem\[27\]\[0\] Inst_RegFile_32x4.mem\[24\]\[0\]
+ Inst_RegFile_32x4.mem\[25\]\[0\] _1210_ _0248_ VPWR VGND sg13g2_mux4_1
X_3209_ _1274_ VGND VPWR _0081_ Inst_RegFile_32x4.mem\[29\]\[1\] clknet_5_12__leaf_UserCLK_regs
+ sg13g2_dfrbpq_1
X_3560_ S2MID[4] net169 VPWR VGND sg13g2_buf_1
X_1890_ _0513_ VPWR _0514_ VGND _0368_ _0510_ sg13g2_o21ai_1
X_3491_ FrameStrobe[19] net91 VPWR VGND sg13g2_buf_1
X_2511_ Inst_RegFile_ConfigMem.Inst_frame9_bit20.Q _1063_ _1064_ _0978_ _1016_ Inst_RegFile_ConfigMem.Inst_frame9_bit21.Q
+ _1065_ VPWR VGND sg13g2_mux4_1
X_2373_ _0960_ NN4END[0] Inst_RegFile_ConfigMem.Inst_frame11_bit20.Q VPWR VGND sg13g2_nand2b_1
X_2442_ Inst_RegFile_ConfigMem.Inst_frame0_bit11.Q N4END[2] W2END[7] E2END[2] Inst_RegFile_switch_matrix.E2BEG2
+ Inst_RegFile_ConfigMem.Inst_frame0_bit10.Q _1017_ VPWR VGND sg13g2_mux4_1
XFILLER_24_226 VPWR VGND sg13g2_fill_2
X_2709_ _1360_ VGND VPWR _0003_ Inst_RegFile_32x4.mem\[24\]\[3\] clknet_5_13__leaf_UserCLK_regs
+ sg13g2_dfrbpq_1
Xoutput251 net251 WW4BEG[7] VPWR VGND sg13g2_buf_1
Xoutput240 net240 WW4BEG[11] VPWR VGND sg13g2_buf_1
X_1942_ B_ADR0 Inst_RegFile_32x4.mem\[28\]\[2\] Inst_RegFile_32x4.mem\[29\]\[2\] Inst_RegFile_32x4.mem\[30\]\[2\]
+ Inst_RegFile_32x4.mem\[31\]\[2\] _0368_ _0562_ VPWR VGND sg13g2_mux4_1
XFILLER_21_218 VPWR VGND sg13g2_fill_1
X_2991_ FrameData[19] FrameStrobe[6] Inst_RegFile_ConfigMem.Inst_frame6_bit19.Q VPWR
+ VGND sg13g2_dlhq_1
X_3543_ Inst_RegFile_switch_matrix.NN4BEG3 net143 VPWR VGND sg13g2_buf_1
X_3612_ W2MID[3] net221 VPWR VGND sg13g2_buf_1
X_1873_ VGND VPWR Inst_RegFile_32x4.mem\[25\]\[0\] B_ADR0 _0499_ _0498_ sg13g2_a21oi_1
X_3474_ FrameStrobe[2] net93 VPWR VGND sg13g2_buf_1
XFILLER_43_0 VPWR VGND sg13g2_fill_2
X_2425_ _1003_ _1005_ Inst_RegFile_switch_matrix.NN4BEG2 VPWR VGND sg13g2_nor2_1
X_2356_ Inst_RegFile_ConfigMem.Inst_frame10_bit16.Q BD2 _0895_ _0896_ _0165_ Inst_RegFile_ConfigMem.Inst_frame10_bit15.Q
+ _0946_ VPWR VGND sg13g2_mux4_1
X_2287_ _1165_ Inst_RegFile_ConfigMem.Inst_frame4_bit0.Q _0885_ _0886_ VPWR VGND sg13g2_a21o_1
X_3190_ FrameData[26] FrameStrobe[0] Inst_RegFile_ConfigMem.Inst_frame0_bit26.Q VPWR
+ VGND sg13g2_dlhq_1
X_2210_ SS4END[0] W1END[0] Inst_RegFile_ConfigMem.Inst_frame2_bit28.Q _0814_ VPWR
+ VGND sg13g2_mux2_1
XFILLER_53_129 VPWR VGND sg13g2_fill_2
X_2072_ Inst_RegFile_ConfigMem.Inst_frame3_bit10.Q _0683_ _0684_ VPWR VGND sg13g2_nor2_1
X_2141_ Inst_RegFile_ConfigMem.Inst_frame3_bit4.Q S2END[2] _0749_ VPWR VGND sg13g2_nor2b_1
X_1925_ B_ADR0 Inst_RegFile_32x4.mem\[8\]\[3\] _0547_ VPWR VGND sg13g2_nor2b_1
X_2974_ FrameData[2] FrameStrobe[6] Inst_RegFile_ConfigMem.Inst_frame6_bit2.Q VPWR
+ VGND sg13g2_dlhq_1
X_3526_ Inst_RegFile_switch_matrix.N4BEG2 net126 VPWR VGND sg13g2_buf_1
X_1856_ _0475_ VPWR Inst_RegFile_switch_matrix.JN2BEG6 VGND Inst_RegFile_ConfigMem.Inst_frame4_bit27.Q
+ _0482_ sg13g2_o21ai_1
X_1787_ VGND VPWR Inst_RegFile_ConfigMem.Inst_frame1_bit16.Q _1166_ _0416_ Inst_RegFile_ConfigMem.Inst_frame1_bit17.Q
+ sg13g2_a21oi_1
X_3388_ VPWR VGND _1370_ sg13g2_tiehi
X_3457_ FrameData[17] net57 VPWR VGND sg13g2_buf_1
X_2408_ _0991_ _0990_ Inst_RegFile_ConfigMem.Inst_frame11_bit13.Q Inst_RegFile_switch_matrix.EE4BEG1
+ VPWR VGND sg13g2_mux2_1
XFILLER_29_159 VPWR VGND sg13g2_decap_4
X_2339_ _0932_ _0931_ Inst_RegFile_ConfigMem.Inst_frame9_bit5.Q Inst_RegFile_switch_matrix.WW4BEG1
+ VPWR VGND sg13g2_mux2_1
XFILLER_25_354 VPWR VGND sg13g2_fill_1
XFILLER_4_269 VPWR VGND sg13g2_fill_2
XFILLER_20_30 VPWR VGND sg13g2_fill_2
XFILLER_31_368 VPWR VGND sg13g2_fill_1
XANTENNA_3 VPWR VGND EE4END[15] sg13g2_antennanp
X_2690_ Inst_RegFile_32x4.mem\[0\]\[3\] _1087_ _1128_ _0115_ VPWR VGND sg13g2_mux2_1
X_1710_ AD1 AD2 Inst_RegFile_ConfigMem.Inst_frame3_bit16.Q _0342_ VPWR VGND sg13g2_mux2_1
X_1572_ _0212_ VPWR _0213_ VGND Inst_RegFile_ConfigMem.Inst_frame3_bit24.Q _1167_
+ sg13g2_o21ai_1
X_1641_ A_ADR0 Inst_RegFile_32x4.mem\[20\]\[1\] _0279_ VPWR VGND sg13g2_nor2b_1
X_3311_ VPWR VGND _1293_ sg13g2_tiehi
X_3242_ _1241_ VGND VPWR _0114_ Inst_RegFile_32x4.mem\[0\]\[2\] clknet_5_28__leaf_UserCLK_regs
+ sg13g2_dfrbpq_1
X_3173_ FrameData[9] FrameStrobe[0] Inst_RegFile_ConfigMem.Inst_frame0_bit9.Q VPWR
+ VGND sg13g2_dlhq_1
X_2124_ Inst_RegFile_ConfigMem.Inst_frame2_bit7.Q VPWR _0733_ VGND _0729_ _0732_ sg13g2_o21ai_1
X_2055_ _0668_ Inst_RegFile_ConfigMem.Inst_frame2_bit8.Q AD3 VPWR VGND sg13g2_nand2_1
XFILLER_25_19 VPWR VGND sg13g2_fill_1
X_1839_ VGND VPWR Inst_RegFile_ConfigMem.Inst_frame4_bit24.Q AD0 _0466_ _0465_ sg13g2_a21oi_1
X_2957_ FrameData[17] FrameStrobe[7] Inst_RegFile_ConfigMem.Inst_frame7_bit17.Q VPWR
+ VGND sg13g2_dlhq_1
X_2888_ FrameData[12] FrameStrobe[9] Inst_RegFile_ConfigMem.Inst_frame9_bit12.Q VPWR
+ VGND sg13g2_dlhq_1
X_1908_ _0522_ _0517_ _0531_ Inst_RegFile_32x4.BD_comb\[1\] VPWR VGND sg13g2_a21o_1
X_3509_ N2MID[5] net118 VPWR VGND sg13g2_buf_1
Xoutput5 net5 E2BEG[0] VPWR VGND sg13g2_buf_1
XFILLER_21_390 VPWR VGND sg13g2_fill_1
Xoutput84 net84 FrameStrobe_O[12] VPWR VGND sg13g2_buf_1
XFILLER_48_243 VPWR VGND sg13g2_fill_1
Xoutput51 net51 FrameData_O[11] VPWR VGND sg13g2_buf_1
Xoutput95 net95 FrameStrobe_O[4] VPWR VGND sg13g2_buf_1
Xoutput73 net73 FrameData_O[31] VPWR VGND sg13g2_buf_1
Xoutput62 net62 FrameData_O[21] VPWR VGND sg13g2_buf_1
Xoutput40 net40 EE4BEG[1] VPWR VGND sg13g2_buf_1
X_2811_ FrameData[31] FrameStrobe[12] Inst_RegFile_ConfigMem.Inst_frame12_bit31.Q
+ VPWR VGND sg13g2_dlhq_1
XFILLER_31_165 VPWR VGND sg13g2_decap_4
X_2742_ _1327_ VGND VPWR _0036_ Inst_RegFile_32x4.mem\[17\]\[0\] clknet_5_5__leaf_UserCLK_regs
+ sg13g2_dfrbpq_1
X_2673_ Inst_RegFile_32x4.mem\[6\]\[1\] _1067_ _1125_ _0101_ VPWR VGND sg13g2_mux2_1
X_1555_ VPWR VGND _0196_ Inst_RegFile_ConfigMem.Inst_frame4_bit22.Q _0195_ Inst_RegFile_ConfigMem.Inst_frame4_bit21.Q
+ _0197_ _0194_ sg13g2_a221oi_1
X_1624_ A_ADR0 Inst_RegFile_32x4.mem\[10\]\[1\] Inst_RegFile_32x4.mem\[11\]\[1\] Inst_RegFile_32x4.mem\[8\]\[1\]
+ Inst_RegFile_32x4.mem\[9\]\[1\] _1210_ _0262_ VPWR VGND sg13g2_mux4_1
XFILLER_54_235 VPWR VGND sg13g2_fill_1
XFILLER_54_213 VPWR VGND sg13g2_fill_2
X_3156_ FrameData[24] FrameStrobe[1] Inst_RegFile_ConfigMem.Inst_frame1_bit24.Q VPWR
+ VGND sg13g2_dlhq_1
X_3225_ _1258_ VGND VPWR _0097_ Inst_RegFile_32x4.mem\[5\]\[1\] clknet_5_23__leaf_UserCLK_regs
+ sg13g2_dfrbpq_1
X_3087_ FrameData[19] FrameStrobe[3] Inst_RegFile_ConfigMem.Inst_frame3_bit19.Q VPWR
+ VGND sg13g2_dlhq_1
X_2107_ _0716_ VPWR _0717_ VGND Inst_RegFile_ConfigMem.Inst_frame1_bit4.Q BD0 sg13g2_o21ai_1
X_1486_ E2END[4] EE4END[3] Inst_RegFile_ConfigMem.Inst_frame2_bit12.Q _0131_ VPWR
+ VGND sg13g2_mux2_1
X_2038_ VGND VPWR Inst_RegFile_ConfigMem.Inst_frame1_bit9.Q _0651_ _0652_ _1147_ sg13g2_a21oi_1
XFILLER_45_224 VPWR VGND sg13g2_fill_1
XFILLER_41_485 VPWR VGND sg13g2_fill_1
X_3010_ FrameData[6] FrameStrobe[5] Inst_RegFile_ConfigMem.Inst_frame5_bit6.Q VPWR
+ VGND sg13g2_dlhq_1
Xclkbuf_5_6__f_UserCLK_regs clknet_4_3_0_UserCLK_regs clknet_5_6__leaf_UserCLK_regs
+ VPWR VGND sg13g2_buf_8
X_2656_ _1065_ Inst_RegFile_32x4.mem\[3\]\[0\] _1121_ _0088_ VPWR VGND sg13g2_mux2_1
X_2725_ _1344_ VGND VPWR _0019_ Inst_RegFile_32x4.mem\[28\]\[3\] clknet_5_11__leaf_UserCLK_regs
+ sg13g2_dfrbpq_1
X_1469_ SS4END[2] W1END[0] Inst_RegFile_ConfigMem.Inst_frame2_bit20.Q _1225_ VPWR
+ VGND sg13g2_mux2_1
X_1607_ _0247_ _0246_ _0241_ VPWR VGND sg13g2_nand2b_1
X_2587_ _1025_ _1020_ _1105_ VPWR VGND _1029_ sg13g2_nand3b_1
X_1538_ Inst_RegFile_ConfigMem.Inst_frame7_bit23.Q E2MID[0] W2MID[0] S2MID[0] Inst_RegFile_switch_matrix.JW2BEG5
+ Inst_RegFile_ConfigMem.Inst_frame7_bit22.Q _0180_ VPWR VGND sg13g2_mux4_1
X_3139_ FrameData[7] FrameStrobe[1] Inst_RegFile_ConfigMem.Inst_frame1_bit7.Q VPWR
+ VGND sg13g2_dlhq_1
X_3208_ _1275_ VGND VPWR _0080_ Inst_RegFile_32x4.mem\[29\]\[0\] clknet_5_12__leaf_UserCLK_regs
+ sg13g2_dfrbpq_1
XFILLER_23_485 VPWR VGND sg13g2_fill_1
X_3490_ FrameStrobe[18] net90 VPWR VGND sg13g2_buf_1
X_2510_ Inst_RegFile_ConfigMem.Inst_frame6_bit0.Q N2MID[7] E2MID[7] S2MID[7] W2MID[7]
+ Inst_RegFile_ConfigMem.Inst_frame6_bit1.Q _1064_ VPWR VGND sg13g2_mux4_1
XFILLER_14_485 VPWR VGND sg13g2_fill_1
X_2372_ Inst_RegFile_ConfigMem.Inst_frame11_bit26.Q _0956_ _0957_ _0959_ _0958_ Inst_RegFile_ConfigMem.Inst_frame11_bit27.Q
+ Inst_RegFile_switch_matrix.E6BEG1 VPWR VGND sg13g2_mux4_1
X_2441_ Inst_RegFile_ConfigMem.Inst_frame10_bit26.Q BD2 _0645_ Inst_RegFile_switch_matrix.JS2BEG0
+ _0137_ Inst_RegFile_ConfigMem.Inst_frame10_bit27.Q Inst_RegFile_switch_matrix.W1BEG1
+ VPWR VGND sg13g2_mux4_1
X_2708_ _1361_ VGND VPWR _0002_ Inst_RegFile_32x4.mem\[24\]\[2\] clknet_5_18__leaf_UserCLK_regs
+ sg13g2_dfrbpq_1
X_2639_ _1087_ Inst_RegFile_32x4.mem\[21\]\[3\] _1117_ _0075_ VPWR VGND sg13g2_mux2_1
Xoutput230 net230 W6BEG[2] VPWR VGND sg13g2_buf_1
Xoutput252 net252 WW4BEG[8] VPWR VGND sg13g2_buf_1
Xoutput241 net241 WW4BEG[12] VPWR VGND sg13g2_buf_1
XFILLER_23_85 VPWR VGND sg13g2_fill_2
XFILLER_3_0 VPWR VGND sg13g2_fill_1
X_2990_ FrameData[18] FrameStrobe[6] Inst_RegFile_ConfigMem.Inst_frame6_bit18.Q VPWR
+ VGND sg13g2_dlhq_1
X_1941_ _0560_ VPWR _0561_ VGND _0367_ _0559_ sg13g2_o21ai_1
X_1872_ B_ADR0 Inst_RegFile_32x4.mem\[24\]\[0\] _0498_ VPWR VGND sg13g2_nor2b_1
X_3473_ FrameStrobe[1] net92 VPWR VGND sg13g2_buf_1
X_3542_ Inst_RegFile_switch_matrix.NN4BEG2 net142 VPWR VGND sg13g2_buf_1
X_3611_ W2MID[2] net220 VPWR VGND sg13g2_buf_1
XFILLER_36_0 VPWR VGND sg13g2_fill_2
X_2424_ Inst_RegFile_ConfigMem.Inst_frame12_bit28.Q _1004_ _1005_ VPWR VGND sg13g2_nor2_1
X_2286_ Inst_RegFile_ConfigMem.Inst_frame4_bit1.Q VPWR _0885_ VGND Inst_RegFile_ConfigMem.Inst_frame4_bit0.Q
+ BD2 sg13g2_o21ai_1
X_2355_ _0943_ _0945_ Inst_RegFile_switch_matrix.SS4BEG2 VPWR VGND sg13g2_nor2_1
XFILLER_52_355 VPWR VGND sg13g2_fill_1
XFILLER_52_333 VPWR VGND sg13g2_fill_2
X_2140_ VGND VPWR E6END[0] Inst_RegFile_ConfigMem.Inst_frame3_bit4.Q _0748_ _0747_
+ sg13g2_a21oi_1
X_2071_ Inst_RegFile_ConfigMem.Inst_frame3_bit8.Q W6END[1] AD0 AD1 AD3 Inst_RegFile_ConfigMem.Inst_frame3_bit9.Q
+ _0683_ VPWR VGND sg13g2_mux4_1
X_1855_ _0481_ VPWR _0482_ VGND Inst_RegFile_ConfigMem.Inst_frame4_bit26.Q _0476_
+ sg13g2_o21ai_1
X_1924_ _0546_ _0368_ _0545_ VPWR VGND sg13g2_nand2_1
X_2973_ FrameData[1] FrameStrobe[6] Inst_RegFile_ConfigMem.Inst_frame6_bit1.Q VPWR
+ VGND sg13g2_dlhq_1
X_3456_ FrameData[16] net56 VPWR VGND sg13g2_buf_1
X_3525_ Inst_RegFile_switch_matrix.N4BEG1 net125 VPWR VGND sg13g2_buf_1
X_1786_ VGND VPWR _0415_ Inst_RegFile_ConfigMem.Inst_frame1_bit16.Q WW4END[3] sg13g2_or2_1
X_3387_ VPWR VGND _1369_ sg13g2_tiehi
X_2407_ Inst_RegFile_ConfigMem.Inst_frame11_bit11.Q N1END[3] E1END[3] S1END[3] AD2
+ Inst_RegFile_ConfigMem.Inst_frame11_bit12.Q _0991_ VPWR VGND sg13g2_mux4_1
X_2269_ VGND VPWR Inst_RegFile_ConfigMem.Inst_frame4_bit29.Q _0865_ _0869_ _0868_
+ sg13g2_a21oi_1
XFILLER_29_127 VPWR VGND sg13g2_fill_1
X_2338_ Inst_RegFile_ConfigMem.Inst_frame9_bit3.Q N1END[3] S1END[3] W1END[3] AD2 Inst_RegFile_ConfigMem.Inst_frame9_bit4.Q
+ _0932_ VPWR VGND sg13g2_mux4_1
XFILLER_0_421 VPWR VGND sg13g2_fill_1
XANTENNA_4 VPWR VGND EE4END[4] sg13g2_antennanp
X_1571_ _0212_ Inst_RegFile_ConfigMem.Inst_frame3_bit24.Q AD2 VPWR VGND sg13g2_nand2_1
X_1640_ A_ADR0 Inst_RegFile_32x4.mem\[18\]\[1\] Inst_RegFile_32x4.mem\[19\]\[1\] Inst_RegFile_32x4.mem\[16\]\[1\]
+ Inst_RegFile_32x4.mem\[17\]\[1\] _1210_ _0278_ VPWR VGND sg13g2_mux4_1
X_3310_ VPWR VGND _1292_ sg13g2_tiehi
X_3241_ _1242_ VGND VPWR _0113_ Inst_RegFile_32x4.mem\[0\]\[1\] clknet_5_16__leaf_UserCLK_regs
+ sg13g2_dfrbpq_1
X_3172_ FrameData[8] FrameStrobe[0] Inst_RegFile_ConfigMem.Inst_frame0_bit8.Q VPWR
+ VGND sg13g2_dlhq_1
X_2123_ _0732_ Inst_RegFile_ConfigMem.Inst_frame2_bit6.Q _0731_ VPWR VGND sg13g2_nand2_1
X_2054_ Inst_RegFile_ConfigMem.Inst_frame2_bit10.Q VPWR _0667_ VGND _0662_ _0663_
+ sg13g2_o21ai_1
X_1838_ Inst_RegFile_ConfigMem.Inst_frame4_bit24.Q W1END[3] _0465_ VPWR VGND sg13g2_nor2b_1
X_2956_ FrameData[16] FrameStrobe[7] Inst_RegFile_ConfigMem.Inst_frame7_bit16.Q VPWR
+ VGND sg13g2_dlhq_1
XFILLER_30_391 VPWR VGND sg13g2_fill_1
XFILLER_30_380 VPWR VGND sg13g2_fill_1
X_1907_ VPWR VGND _0530_ _0492_ _0528_ _0524_ _0531_ _0526_ sg13g2_a221oi_1
X_2887_ FrameData[11] FrameStrobe[9] Inst_RegFile_ConfigMem.Inst_frame9_bit11.Q VPWR
+ VGND sg13g2_dlhq_1
X_3508_ N2MID[4] net117 VPWR VGND sg13g2_buf_1
X_1769_ _0399_ AD3 Inst_RegFile_ConfigMem.Inst_frame2_bit16.Q VPWR VGND sg13g2_nand2b_1
X_3439_ Inst_RegFile_switch_matrix.EE4BEG3 net39 VPWR VGND sg13g2_buf_1
Xoutput52 net52 FrameData_O[12] VPWR VGND sg13g2_buf_1
Xoutput30 net30 E6BEG[7] VPWR VGND sg13g2_buf_1
Xoutput41 net41 EE4BEG[2] VPWR VGND sg13g2_buf_1
Xoutput6 net6 E2BEG[1] VPWR VGND sg13g2_buf_1
Xoutput85 net85 FrameStrobe_O[13] VPWR VGND sg13g2_buf_1
Xoutput96 net96 FrameStrobe_O[5] VPWR VGND sg13g2_buf_1
Xoutput63 net63 FrameData_O[22] VPWR VGND sg13g2_buf_1
Xoutput74 net74 FrameData_O[3] VPWR VGND sg13g2_buf_1
XFILLER_31_122 VPWR VGND sg13g2_fill_2
XFILLER_16_196 VPWR VGND sg13g2_fill_1
X_2672_ Inst_RegFile_32x4.mem\[6\]\[0\] _1065_ _1125_ _0100_ VPWR VGND sg13g2_mux2_1
X_2810_ FrameData[30] FrameStrobe[12] Inst_RegFile_ConfigMem.Inst_frame12_bit30.Q
+ VPWR VGND sg13g2_dlhq_1
XFILLER_31_144 VPWR VGND sg13g2_decap_8
X_2741_ _1328_ VGND VPWR _0035_ Inst_RegFile_32x4.mem\[13\]\[3\] clknet_5_26__leaf_UserCLK_regs
+ sg13g2_dfrbpq_1
XFILLER_12_391 VPWR VGND sg13g2_fill_2
X_3224_ _1259_ VGND VPWR _0096_ Inst_RegFile_32x4.mem\[5\]\[0\] clknet_5_29__leaf_UserCLK_regs
+ sg13g2_dfrbpq_1
X_1554_ VGND VPWR Inst_RegFile_ConfigMem.Inst_frame4_bit20.Q _1166_ _0196_ Inst_RegFile_ConfigMem.Inst_frame4_bit21.Q
+ sg13g2_a21oi_1
X_1623_ Inst_RegFile_32x4.AD_comb\[0\] Inst_RegFile_32x4.AD_reg\[0\] Inst_RegFile_ConfigMem.Inst_frame12_bit2.Q
+ AD0 VPWR VGND sg13g2_mux2_1
X_1485_ Inst_RegFile_ConfigMem.Inst_frame2_bit15.Q VPWR _0130_ VGND _1237_ _0129_
+ sg13g2_o21ai_1
.ends
