* NGSPICE file created from S_XIF.ext - technology: ihp-sg13g2

* Black-box entry subcircuit for sg13g2_decap_8 abstract view
.subckt sg13g2_decap_8 VDD VSS
.ends

* Black-box entry subcircuit for sg13g2_buf_1 abstract view
.subckt sg13g2_buf_1 A X VDD VSS
.ends

* Black-box entry subcircuit for sg13g2_dlhq_1 abstract view
.subckt sg13g2_dlhq_1 D GATE Q VDD VSS
.ends

* Black-box entry subcircuit for sg13g2_mux2_1 abstract view
.subckt sg13g2_mux2_1 A0 A1 S X VDD VSS
.ends

* Black-box entry subcircuit for sg13g2_fill_1 abstract view
.subckt sg13g2_fill_1 VDD VSS
.ends

* Black-box entry subcircuit for sg13g2_o21ai_1 abstract view
.subckt sg13g2_o21ai_1 B1 VDD Y VSS A1 A2
.ends

* Black-box entry subcircuit for sg13g2_decap_4 abstract view
.subckt sg13g2_decap_4 VDD VSS
.ends

* Black-box entry subcircuit for sg13g2_fill_2 abstract view
.subckt sg13g2_fill_2 VDD VSS
.ends

* Black-box entry subcircuit for sg13g2_antennanp abstract view
.subckt sg13g2_antennanp VDD VSS A
.ends

* Black-box entry subcircuit for sg13g2_nand2b_1 abstract view
.subckt sg13g2_nand2b_1 Y B A_N VDD VSS
.ends

* Black-box entry subcircuit for sg13g2_tielo abstract view
.subckt sg13g2_tielo VDD VSS L_LO
.ends

.subckt S_XIF ISSUE_ACCEPT_top ISSUE_ID_top0 ISSUE_ID_top1 ISSUE_ID_top2 ISSUE_ID_top3
+ ISSUE_INSTR_top0 ISSUE_INSTR_top1 ISSUE_INSTR_top10 ISSUE_INSTR_top11 ISSUE_INSTR_top12
+ ISSUE_INSTR_top13 ISSUE_INSTR_top14 ISSUE_INSTR_top15 ISSUE_INSTR_top16 ISSUE_INSTR_top17
+ ISSUE_INSTR_top18 ISSUE_INSTR_top19 ISSUE_INSTR_top2 ISSUE_INSTR_top20 ISSUE_INSTR_top21
+ ISSUE_INSTR_top22 ISSUE_INSTR_top23 ISSUE_INSTR_top24 ISSUE_INSTR_top25 ISSUE_INSTR_top26
+ ISSUE_INSTR_top27 ISSUE_INSTR_top28 ISSUE_INSTR_top29 ISSUE_INSTR_top3 ISSUE_INSTR_top30
+ ISSUE_INSTR_top31 ISSUE_INSTR_top4 ISSUE_INSTR_top5 ISSUE_INSTR_top6 ISSUE_INSTR_top7
+ ISSUE_INSTR_top8 ISSUE_INSTR_top9 ISSUE_OPA_top0 ISSUE_OPA_top1 ISSUE_OPA_top10
+ ISSUE_OPA_top11 ISSUE_OPA_top12 ISSUE_OPA_top13 ISSUE_OPA_top14 ISSUE_OPA_top15
+ ISSUE_OPA_top16 ISSUE_OPA_top17 ISSUE_OPA_top18 ISSUE_OPA_top19 ISSUE_OPA_top2 ISSUE_OPA_top20
+ ISSUE_OPA_top21 ISSUE_OPA_top22 ISSUE_OPA_top23 ISSUE_OPA_top24 ISSUE_OPA_top25
+ ISSUE_OPA_top26 ISSUE_OPA_top27 ISSUE_OPA_top28 ISSUE_OPA_top29 ISSUE_OPA_top3 ISSUE_OPA_top30
+ ISSUE_OPA_top31 ISSUE_OPA_top4 ISSUE_OPA_top5 ISSUE_OPA_top6 ISSUE_OPA_top7 ISSUE_OPA_top8
+ ISSUE_OPA_top9 ISSUE_OPB_top0 ISSUE_OPB_top1 ISSUE_OPB_top10 ISSUE_OPB_top11 ISSUE_OPB_top12
+ ISSUE_OPB_top13 ISSUE_OPB_top14 ISSUE_OPB_top15 ISSUE_OPB_top16 ISSUE_OPB_top17
+ ISSUE_OPB_top18 ISSUE_OPB_top19 ISSUE_OPB_top2 ISSUE_OPB_top20 ISSUE_OPB_top21 ISSUE_OPB_top22
+ ISSUE_OPB_top23 ISSUE_OPB_top24 ISSUE_OPB_top25 ISSUE_OPB_top26 ISSUE_OPB_top27
+ ISSUE_OPB_top28 ISSUE_OPB_top29 ISSUE_OPB_top3 ISSUE_OPB_top30 ISSUE_OPB_top31 ISSUE_OPB_top4
+ ISSUE_OPB_top5 ISSUE_OPB_top6 ISSUE_OPB_top7 ISSUE_OPB_top8 ISSUE_OPB_top9 ISSUE_READY_top
+ ISSUE_VALID_top RESULT_ID_top0 RESULT_ID_top1 RESULT_ID_top2 RESULT_ID_top3 RESULT_RD_top0
+ RESULT_RD_top1 RESULT_RD_top2 RESULT_RD_top3 RESULT_RD_top4 RESULT_VALID_top RESULT_top0
+ RESULT_top1 RESULT_top10 RESULT_top11 RESULT_top12 RESULT_top13 RESULT_top14 RESULT_top15
+ RESULT_top16 RESULT_top17 RESULT_top18 RESULT_top19 RESULT_top2 RESULT_top20 RESULT_top21
+ RESULT_top22 RESULT_top23 RESULT_top24 RESULT_top25 RESULT_top26 RESULT_top27 RESULT_top28
+ RESULT_top29 RESULT_top3 RESULT_top30 RESULT_top31 RESULT_top4 RESULT_top5 RESULT_top6
+ RESULT_top7 RESULT_top8 RESULT_top9 Tile_X0Y0_Co Tile_X0Y0_FrameData[0] Tile_X0Y0_FrameData[10]
+ Tile_X0Y0_FrameData[11] Tile_X0Y0_FrameData[12] Tile_X0Y0_FrameData[13] Tile_X0Y0_FrameData[14]
+ Tile_X0Y0_FrameData[15] Tile_X0Y0_FrameData[16] Tile_X0Y0_FrameData[17] Tile_X0Y0_FrameData[18]
+ Tile_X0Y0_FrameData[19] Tile_X0Y0_FrameData[1] Tile_X0Y0_FrameData[20] Tile_X0Y0_FrameData[21]
+ Tile_X0Y0_FrameData[22] Tile_X0Y0_FrameData[23] Tile_X0Y0_FrameData[24] Tile_X0Y0_FrameData[25]
+ Tile_X0Y0_FrameData[26] Tile_X0Y0_FrameData[27] Tile_X0Y0_FrameData[28] Tile_X0Y0_FrameData[29]
+ Tile_X0Y0_FrameData[2] Tile_X0Y0_FrameData[30] Tile_X0Y0_FrameData[31] Tile_X0Y0_FrameData[3]
+ Tile_X0Y0_FrameData[4] Tile_X0Y0_FrameData[5] Tile_X0Y0_FrameData[6] Tile_X0Y0_FrameData[7]
+ Tile_X0Y0_FrameData[8] Tile_X0Y0_FrameData[9] Tile_X0Y0_FrameStrobe[0] Tile_X0Y0_FrameStrobe[10]
+ Tile_X0Y0_FrameStrobe[11] Tile_X0Y0_FrameStrobe[12] Tile_X0Y0_FrameStrobe[13] Tile_X0Y0_FrameStrobe[14]
+ Tile_X0Y0_FrameStrobe[15] Tile_X0Y0_FrameStrobe[16] Tile_X0Y0_FrameStrobe[17] Tile_X0Y0_FrameStrobe[18]
+ Tile_X0Y0_FrameStrobe[19] Tile_X0Y0_FrameStrobe[1] Tile_X0Y0_FrameStrobe[2] Tile_X0Y0_FrameStrobe[3]
+ Tile_X0Y0_FrameStrobe[4] Tile_X0Y0_FrameStrobe[5] Tile_X0Y0_FrameStrobe[6] Tile_X0Y0_FrameStrobe[7]
+ Tile_X0Y0_FrameStrobe[8] Tile_X0Y0_FrameStrobe[9] Tile_X0Y0_FrameStrobe_O[0] Tile_X0Y0_FrameStrobe_O[10]
+ Tile_X0Y0_FrameStrobe_O[11] Tile_X0Y0_FrameStrobe_O[12] Tile_X0Y0_FrameStrobe_O[13]
+ Tile_X0Y0_FrameStrobe_O[14] Tile_X0Y0_FrameStrobe_O[15] Tile_X0Y0_FrameStrobe_O[16]
+ Tile_X0Y0_FrameStrobe_O[17] Tile_X0Y0_FrameStrobe_O[18] Tile_X0Y0_FrameStrobe_O[19]
+ Tile_X0Y0_FrameStrobe_O[1] Tile_X0Y0_FrameStrobe_O[2] Tile_X0Y0_FrameStrobe_O[3]
+ Tile_X0Y0_FrameStrobe_O[4] Tile_X0Y0_FrameStrobe_O[5] Tile_X0Y0_FrameStrobe_O[6]
+ Tile_X0Y0_FrameStrobe_O[7] Tile_X0Y0_FrameStrobe_O[8] Tile_X0Y0_FrameStrobe_O[9]
+ Tile_X0Y0_N1BEG[0] Tile_X0Y0_N1BEG[1] Tile_X0Y0_N1BEG[2] Tile_X0Y0_N1BEG[3] Tile_X0Y0_N2BEG[0]
+ Tile_X0Y0_N2BEG[1] Tile_X0Y0_N2BEG[2] Tile_X0Y0_N2BEG[3] Tile_X0Y0_N2BEG[4] Tile_X0Y0_N2BEG[5]
+ Tile_X0Y0_N2BEG[6] Tile_X0Y0_N2BEG[7] Tile_X0Y0_N2BEGb[0] Tile_X0Y0_N2BEGb[1] Tile_X0Y0_N2BEGb[2]
+ Tile_X0Y0_N2BEGb[3] Tile_X0Y0_N2BEGb[4] Tile_X0Y0_N2BEGb[5] Tile_X0Y0_N2BEGb[6]
+ Tile_X0Y0_N2BEGb[7] Tile_X0Y0_N4BEG[0] Tile_X0Y0_N4BEG[10] Tile_X0Y0_N4BEG[11] Tile_X0Y0_N4BEG[12]
+ Tile_X0Y0_N4BEG[13] Tile_X0Y0_N4BEG[14] Tile_X0Y0_N4BEG[15] Tile_X0Y0_N4BEG[1] Tile_X0Y0_N4BEG[2]
+ Tile_X0Y0_N4BEG[3] Tile_X0Y0_N4BEG[4] Tile_X0Y0_N4BEG[5] Tile_X0Y0_N4BEG[6] Tile_X0Y0_N4BEG[7]
+ Tile_X0Y0_N4BEG[8] Tile_X0Y0_N4BEG[9] Tile_X0Y0_NN4BEG[0] Tile_X0Y0_NN4BEG[10] Tile_X0Y0_NN4BEG[11]
+ Tile_X0Y0_NN4BEG[12] Tile_X0Y0_NN4BEG[13] Tile_X0Y0_NN4BEG[14] Tile_X0Y0_NN4BEG[15]
+ Tile_X0Y0_NN4BEG[1] Tile_X0Y0_NN4BEG[2] Tile_X0Y0_NN4BEG[3] Tile_X0Y0_NN4BEG[4]
+ Tile_X0Y0_NN4BEG[5] Tile_X0Y0_NN4BEG[6] Tile_X0Y0_NN4BEG[7] Tile_X0Y0_NN4BEG[8]
+ Tile_X0Y0_NN4BEG[9] Tile_X0Y0_S1END[0] Tile_X0Y0_S1END[1] Tile_X0Y0_S1END[2] Tile_X0Y0_S1END[3]
+ Tile_X0Y0_S2END[0] Tile_X0Y0_S2END[1] Tile_X0Y0_S2END[2] Tile_X0Y0_S2END[3] Tile_X0Y0_S2END[4]
+ Tile_X0Y0_S2END[5] Tile_X0Y0_S2END[6] Tile_X0Y0_S2END[7] Tile_X0Y0_S2MID[0] Tile_X0Y0_S2MID[1]
+ Tile_X0Y0_S2MID[2] Tile_X0Y0_S2MID[3] Tile_X0Y0_S2MID[4] Tile_X0Y0_S2MID[5] Tile_X0Y0_S2MID[6]
+ Tile_X0Y0_S2MID[7] Tile_X0Y0_S4END[0] Tile_X0Y0_S4END[10] Tile_X0Y0_S4END[11] Tile_X0Y0_S4END[12]
+ Tile_X0Y0_S4END[13] Tile_X0Y0_S4END[14] Tile_X0Y0_S4END[15] Tile_X0Y0_S4END[1] Tile_X0Y0_S4END[2]
+ Tile_X0Y0_S4END[3] Tile_X0Y0_S4END[4] Tile_X0Y0_S4END[5] Tile_X0Y0_S4END[6] Tile_X0Y0_S4END[7]
+ Tile_X0Y0_S4END[8] Tile_X0Y0_S4END[9] Tile_X0Y0_SS4END[0] Tile_X0Y0_SS4END[10] Tile_X0Y0_SS4END[11]
+ Tile_X0Y0_SS4END[12] Tile_X0Y0_SS4END[13] Tile_X0Y0_SS4END[14] Tile_X0Y0_SS4END[15]
+ Tile_X0Y0_SS4END[1] Tile_X0Y0_SS4END[2] Tile_X0Y0_SS4END[3] Tile_X0Y0_SS4END[4]
+ Tile_X0Y0_SS4END[5] Tile_X0Y0_SS4END[6] Tile_X0Y0_SS4END[7] Tile_X0Y0_SS4END[8]
+ Tile_X0Y0_SS4END[9] Tile_X0Y0_UserCLK Tile_X0Y0_UserCLKo Tile_X1Y0_Co Tile_X1Y0_FrameStrobe[0]
+ Tile_X1Y0_FrameStrobe[10] Tile_X1Y0_FrameStrobe[11] Tile_X1Y0_FrameStrobe[12] Tile_X1Y0_FrameStrobe[13]
+ Tile_X1Y0_FrameStrobe[14] Tile_X1Y0_FrameStrobe[15] Tile_X1Y0_FrameStrobe[16] Tile_X1Y0_FrameStrobe[17]
+ Tile_X1Y0_FrameStrobe[18] Tile_X1Y0_FrameStrobe[19] Tile_X1Y0_FrameStrobe[1] Tile_X1Y0_FrameStrobe[2]
+ Tile_X1Y0_FrameStrobe[3] Tile_X1Y0_FrameStrobe[4] Tile_X1Y0_FrameStrobe[5] Tile_X1Y0_FrameStrobe[6]
+ Tile_X1Y0_FrameStrobe[7] Tile_X1Y0_FrameStrobe[8] Tile_X1Y0_FrameStrobe[9] Tile_X1Y0_FrameStrobe_O[0]
+ Tile_X1Y0_FrameStrobe_O[10] Tile_X1Y0_FrameStrobe_O[11] Tile_X1Y0_FrameStrobe_O[12]
+ Tile_X1Y0_FrameStrobe_O[13] Tile_X1Y0_FrameStrobe_O[14] Tile_X1Y0_FrameStrobe_O[15]
+ Tile_X1Y0_FrameStrobe_O[16] Tile_X1Y0_FrameStrobe_O[17] Tile_X1Y0_FrameStrobe_O[18]
+ Tile_X1Y0_FrameStrobe_O[19] Tile_X1Y0_FrameStrobe_O[1] Tile_X1Y0_FrameStrobe_O[2]
+ Tile_X1Y0_FrameStrobe_O[3] Tile_X1Y0_FrameStrobe_O[4] Tile_X1Y0_FrameStrobe_O[5]
+ Tile_X1Y0_FrameStrobe_O[6] Tile_X1Y0_FrameStrobe_O[7] Tile_X1Y0_FrameStrobe_O[8]
+ Tile_X1Y0_FrameStrobe_O[9] Tile_X1Y0_N1BEG[0] Tile_X1Y0_N1BEG[1] Tile_X1Y0_N1BEG[2]
+ Tile_X1Y0_N1BEG[3] Tile_X1Y0_N2BEG[0] Tile_X1Y0_N2BEG[1] Tile_X1Y0_N2BEG[2] Tile_X1Y0_N2BEG[3]
+ Tile_X1Y0_N2BEG[4] Tile_X1Y0_N2BEG[5] Tile_X1Y0_N2BEG[6] Tile_X1Y0_N2BEG[7] Tile_X1Y0_N2BEGb[0]
+ Tile_X1Y0_N2BEGb[1] Tile_X1Y0_N2BEGb[2] Tile_X1Y0_N2BEGb[3] Tile_X1Y0_N2BEGb[4]
+ Tile_X1Y0_N2BEGb[5] Tile_X1Y0_N2BEGb[6] Tile_X1Y0_N2BEGb[7] Tile_X1Y0_N4BEG[0] Tile_X1Y0_N4BEG[10]
+ Tile_X1Y0_N4BEG[11] Tile_X1Y0_N4BEG[12] Tile_X1Y0_N4BEG[13] Tile_X1Y0_N4BEG[14]
+ Tile_X1Y0_N4BEG[15] Tile_X1Y0_N4BEG[1] Tile_X1Y0_N4BEG[2] Tile_X1Y0_N4BEG[3] Tile_X1Y0_N4BEG[4]
+ Tile_X1Y0_N4BEG[5] Tile_X1Y0_N4BEG[6] Tile_X1Y0_N4BEG[7] Tile_X1Y0_N4BEG[8] Tile_X1Y0_N4BEG[9]
+ Tile_X1Y0_NN4BEG[0] Tile_X1Y0_NN4BEG[10] Tile_X1Y0_NN4BEG[11] Tile_X1Y0_NN4BEG[12]
+ Tile_X1Y0_NN4BEG[13] Tile_X1Y0_NN4BEG[14] Tile_X1Y0_NN4BEG[15] Tile_X1Y0_NN4BEG[1]
+ Tile_X1Y0_NN4BEG[2] Tile_X1Y0_NN4BEG[3] Tile_X1Y0_NN4BEG[4] Tile_X1Y0_NN4BEG[5]
+ Tile_X1Y0_NN4BEG[6] Tile_X1Y0_NN4BEG[7] Tile_X1Y0_NN4BEG[8] Tile_X1Y0_NN4BEG[9]
+ Tile_X1Y0_S1END[0] Tile_X1Y0_S1END[1] Tile_X1Y0_S1END[2] Tile_X1Y0_S1END[3] Tile_X1Y0_S2END[0]
+ Tile_X1Y0_S2END[1] Tile_X1Y0_S2END[2] Tile_X1Y0_S2END[3] Tile_X1Y0_S2END[4] Tile_X1Y0_S2END[5]
+ Tile_X1Y0_S2END[6] Tile_X1Y0_S2END[7] Tile_X1Y0_S2MID[0] Tile_X1Y0_S2MID[1] Tile_X1Y0_S2MID[2]
+ Tile_X1Y0_S2MID[3] Tile_X1Y0_S2MID[4] Tile_X1Y0_S2MID[5] Tile_X1Y0_S2MID[6] Tile_X1Y0_S2MID[7]
+ Tile_X1Y0_S4END[0] Tile_X1Y0_S4END[10] Tile_X1Y0_S4END[11] Tile_X1Y0_S4END[12] Tile_X1Y0_S4END[13]
+ Tile_X1Y0_S4END[14] Tile_X1Y0_S4END[15] Tile_X1Y0_S4END[1] Tile_X1Y0_S4END[2] Tile_X1Y0_S4END[3]
+ Tile_X1Y0_S4END[4] Tile_X1Y0_S4END[5] Tile_X1Y0_S4END[6] Tile_X1Y0_S4END[7] Tile_X1Y0_S4END[8]
+ Tile_X1Y0_S4END[9] Tile_X1Y0_SS4END[0] Tile_X1Y0_SS4END[10] Tile_X1Y0_SS4END[11]
+ Tile_X1Y0_SS4END[12] Tile_X1Y0_SS4END[13] Tile_X1Y0_SS4END[14] Tile_X1Y0_SS4END[15]
+ Tile_X1Y0_SS4END[1] Tile_X1Y0_SS4END[2] Tile_X1Y0_SS4END[3] Tile_X1Y0_SS4END[4]
+ Tile_X1Y0_SS4END[5] Tile_X1Y0_SS4END[6] Tile_X1Y0_SS4END[7] Tile_X1Y0_SS4END[8]
+ Tile_X1Y0_SS4END[9] Tile_X1Y0_UserCLK Tile_X1Y0_UserCLKo Tile_X2Y0_Co Tile_X2Y0_FrameData_O[0]
+ Tile_X2Y0_FrameData_O[10] Tile_X2Y0_FrameData_O[11] Tile_X2Y0_FrameData_O[12] Tile_X2Y0_FrameData_O[13]
+ Tile_X2Y0_FrameData_O[14] Tile_X2Y0_FrameData_O[15] Tile_X2Y0_FrameData_O[16] Tile_X2Y0_FrameData_O[17]
+ Tile_X2Y0_FrameData_O[18] Tile_X2Y0_FrameData_O[19] Tile_X2Y0_FrameData_O[1] Tile_X2Y0_FrameData_O[20]
+ Tile_X2Y0_FrameData_O[21] Tile_X2Y0_FrameData_O[22] Tile_X2Y0_FrameData_O[23] Tile_X2Y0_FrameData_O[24]
+ Tile_X2Y0_FrameData_O[25] Tile_X2Y0_FrameData_O[26] Tile_X2Y0_FrameData_O[27] Tile_X2Y0_FrameData_O[28]
+ Tile_X2Y0_FrameData_O[29] Tile_X2Y0_FrameData_O[2] Tile_X2Y0_FrameData_O[30] Tile_X2Y0_FrameData_O[31]
+ Tile_X2Y0_FrameData_O[3] Tile_X2Y0_FrameData_O[4] Tile_X2Y0_FrameData_O[5] Tile_X2Y0_FrameData_O[6]
+ Tile_X2Y0_FrameData_O[7] Tile_X2Y0_FrameData_O[8] Tile_X2Y0_FrameData_O[9] Tile_X2Y0_FrameStrobe[0]
+ Tile_X2Y0_FrameStrobe[10] Tile_X2Y0_FrameStrobe[11] Tile_X2Y0_FrameStrobe[12] Tile_X2Y0_FrameStrobe[13]
+ Tile_X2Y0_FrameStrobe[14] Tile_X2Y0_FrameStrobe[15] Tile_X2Y0_FrameStrobe[16] Tile_X2Y0_FrameStrobe[17]
+ Tile_X2Y0_FrameStrobe[18] Tile_X2Y0_FrameStrobe[19] Tile_X2Y0_FrameStrobe[1] Tile_X2Y0_FrameStrobe[2]
+ Tile_X2Y0_FrameStrobe[3] Tile_X2Y0_FrameStrobe[4] Tile_X2Y0_FrameStrobe[5] Tile_X2Y0_FrameStrobe[6]
+ Tile_X2Y0_FrameStrobe[7] Tile_X2Y0_FrameStrobe[8] Tile_X2Y0_FrameStrobe[9] Tile_X2Y0_FrameStrobe_O[0]
+ Tile_X2Y0_FrameStrobe_O[10] Tile_X2Y0_FrameStrobe_O[11] Tile_X2Y0_FrameStrobe_O[12]
+ Tile_X2Y0_FrameStrobe_O[13] Tile_X2Y0_FrameStrobe_O[14] Tile_X2Y0_FrameStrobe_O[15]
+ Tile_X2Y0_FrameStrobe_O[16] Tile_X2Y0_FrameStrobe_O[17] Tile_X2Y0_FrameStrobe_O[18]
+ Tile_X2Y0_FrameStrobe_O[19] Tile_X2Y0_FrameStrobe_O[1] Tile_X2Y0_FrameStrobe_O[2]
+ Tile_X2Y0_FrameStrobe_O[3] Tile_X2Y0_FrameStrobe_O[4] Tile_X2Y0_FrameStrobe_O[5]
+ Tile_X2Y0_FrameStrobe_O[6] Tile_X2Y0_FrameStrobe_O[7] Tile_X2Y0_FrameStrobe_O[8]
+ Tile_X2Y0_FrameStrobe_O[9] Tile_X2Y0_N1BEG[0] Tile_X2Y0_N1BEG[1] Tile_X2Y0_N1BEG[2]
+ Tile_X2Y0_N1BEG[3] Tile_X2Y0_N2BEG[0] Tile_X2Y0_N2BEG[1] Tile_X2Y0_N2BEG[2] Tile_X2Y0_N2BEG[3]
+ Tile_X2Y0_N2BEG[4] Tile_X2Y0_N2BEG[5] Tile_X2Y0_N2BEG[6] Tile_X2Y0_N2BEG[7] Tile_X2Y0_N2BEGb[0]
+ Tile_X2Y0_N2BEGb[1] Tile_X2Y0_N2BEGb[2] Tile_X2Y0_N2BEGb[3] Tile_X2Y0_N2BEGb[4]
+ Tile_X2Y0_N2BEGb[5] Tile_X2Y0_N2BEGb[6] Tile_X2Y0_N2BEGb[7] Tile_X2Y0_N4BEG[0] Tile_X2Y0_N4BEG[10]
+ Tile_X2Y0_N4BEG[11] Tile_X2Y0_N4BEG[12] Tile_X2Y0_N4BEG[13] Tile_X2Y0_N4BEG[14]
+ Tile_X2Y0_N4BEG[15] Tile_X2Y0_N4BEG[1] Tile_X2Y0_N4BEG[2] Tile_X2Y0_N4BEG[3] Tile_X2Y0_N4BEG[4]
+ Tile_X2Y0_N4BEG[5] Tile_X2Y0_N4BEG[6] Tile_X2Y0_N4BEG[7] Tile_X2Y0_N4BEG[8] Tile_X2Y0_N4BEG[9]
+ Tile_X2Y0_NN4BEG[0] Tile_X2Y0_NN4BEG[10] Tile_X2Y0_NN4BEG[11] Tile_X2Y0_NN4BEG[12]
+ Tile_X2Y0_NN4BEG[13] Tile_X2Y0_NN4BEG[14] Tile_X2Y0_NN4BEG[15] Tile_X2Y0_NN4BEG[1]
+ Tile_X2Y0_NN4BEG[2] Tile_X2Y0_NN4BEG[3] Tile_X2Y0_NN4BEG[4] Tile_X2Y0_NN4BEG[5]
+ Tile_X2Y0_NN4BEG[6] Tile_X2Y0_NN4BEG[7] Tile_X2Y0_NN4BEG[8] Tile_X2Y0_NN4BEG[9]
+ Tile_X2Y0_S1END[0] Tile_X2Y0_S1END[1] Tile_X2Y0_S1END[2] Tile_X2Y0_S1END[3] Tile_X2Y0_S2END[0]
+ Tile_X2Y0_S2END[1] Tile_X2Y0_S2END[2] Tile_X2Y0_S2END[3] Tile_X2Y0_S2END[4] Tile_X2Y0_S2END[5]
+ Tile_X2Y0_S2END[6] Tile_X2Y0_S2END[7] Tile_X2Y0_S2MID[0] Tile_X2Y0_S2MID[1] Tile_X2Y0_S2MID[2]
+ Tile_X2Y0_S2MID[3] Tile_X2Y0_S2MID[4] Tile_X2Y0_S2MID[5] Tile_X2Y0_S2MID[6] Tile_X2Y0_S2MID[7]
+ Tile_X2Y0_S4END[0] Tile_X2Y0_S4END[10] Tile_X2Y0_S4END[11] Tile_X2Y0_S4END[12] Tile_X2Y0_S4END[13]
+ Tile_X2Y0_S4END[14] Tile_X2Y0_S4END[15] Tile_X2Y0_S4END[1] Tile_X2Y0_S4END[2] Tile_X2Y0_S4END[3]
+ Tile_X2Y0_S4END[4] Tile_X2Y0_S4END[5] Tile_X2Y0_S4END[6] Tile_X2Y0_S4END[7] Tile_X2Y0_S4END[8]
+ Tile_X2Y0_S4END[9] Tile_X2Y0_SS4END[0] Tile_X2Y0_SS4END[10] Tile_X2Y0_SS4END[11]
+ Tile_X2Y0_SS4END[12] Tile_X2Y0_SS4END[13] Tile_X2Y0_SS4END[14] Tile_X2Y0_SS4END[15]
+ Tile_X2Y0_SS4END[1] Tile_X2Y0_SS4END[2] Tile_X2Y0_SS4END[3] Tile_X2Y0_SS4END[4]
+ Tile_X2Y0_SS4END[5] Tile_X2Y0_SS4END[6] Tile_X2Y0_SS4END[7] Tile_X2Y0_SS4END[8]
+ Tile_X2Y0_SS4END[9] Tile_X2Y0_UserCLK Tile_X2Y0_UserCLKo VGND VPWR
XFILLER_2_505 VPWR VGND sg13g2_decap_8
XFILLER_7_7 VPWR VGND sg13g2_decap_8
X_501_ Tile_X0Y0_FrameStrobe[3] Tile_X0Y0_FrameStrobe_O[3] VPWR VGND sg13g2_buf_1
XFILLER_2_1265 VPWR VGND sg13g2_decap_8
X_432_ Tile_X0Y0_FrameData[15] Tile_X0Y0_FrameStrobe[0] Tile_X0Y0_S_XIF_left.Inst_S_XIF_left_ConfigMem.Inst_frame0_bit15.Q
+ VPWR VGND sg13g2_dlhq_1
X_294_ Tile_X1Y0_S1END[0] Tile_X1Y0_S2END[0] Tile_X1Y0_S_XIF_middle.Inst_S_XIF_middle_ConfigMem.Inst_frame0_bit26.Q
+ RESULT_ID_top3 VPWR VGND sg13g2_mux2_1
XFILLER_10_851 VPWR VGND sg13g2_decap_8
XFILLER_9_126 VPWR VGND sg13g2_fill_1
X_363_ Tile_X0Y0_FrameData[20] Tile_X2Y0_FrameStrobe[0] Tile_X2Y0_S_XIF_right.Inst_S_XIF_right_ConfigMem.Inst_frame0_bit20.Q
+ VPWR VGND sg13g2_dlhq_1
XFILLER_6_833 VPWR VGND sg13g2_decap_8
XFILLER_3_56 VPWR VGND sg13g2_decap_8
XFILLER_2_302 VPWR VGND sg13g2_decap_8
XFILLER_2_379 VPWR VGND sg13g2_decap_8
XFILLER_3_858 VPWR VGND sg13g2_decap_8
X_415_ Tile_X0Y0_FrameData[0] Tile_X2Y0_FrameStrobe[1] Tile_X2Y0_S_XIF_right.Inst_S_XIF_right_ConfigMem.Inst_frame1_bit0.Q
+ VPWR VGND sg13g2_dlhq_1
X_346_ Tile_X0Y0_FrameData[2] Tile_X1Y0_FrameStrobe[1] Tile_X1Y0_S_XIF_middle.Inst_S_XIF_middle_ConfigMem.Inst_frame1_bit2.Q
+ VPWR VGND sg13g2_dlhq_1
XFILLER_2_1095 VPWR VGND sg13g2_decap_8
X_277_ Tile_X1Y0_SS4END[4] ISSUE_INSTR_top20 Tile_X1Y0_S_XIF_middle.Inst_S_XIF_middle_ConfigMem.Inst_frame0_bit12.Q
+ Tile_X1Y0_S_XIF_middle.Inst_S_XIF_middle_switch_matrix.NN4BEG11 VPWR VGND sg13g2_mux2_1
XFILLER_5_140 VPWR VGND sg13g2_decap_8
XFILLER_1_390 VPWR VGND sg13g2_decap_8
XFILLER_5_195 VPWR VGND sg13g2_decap_8
X_200_ Tile_X0Y0_S_XIF_left.Inst_S_XIF_left_ConfigMem.Inst_frame0_bit12.Q VPWR _044_
+ VGND Tile_X0Y0_SS4END[6] Tile_X0Y0_S_XIF_left.Inst_S_XIF_left_ConfigMem.Inst_frame0_bit13.Q
+ sg13g2_o21ai_1
XFILLER_11_467 VPWR VGND sg13g2_decap_8
XFILLER_8_917 VPWR VGND sg13g2_decap_8
XFILLER_3_611 VPWR VGND sg13g2_decap_8
X_131_ _018_ VPWR RESULT_top9 VGND Tile_X2Y0_S_XIF_right.Inst_S_XIF_right_ConfigMem.Inst_frame0_bit19.Q
+ _019_ sg13g2_o21ai_1
XFILLER_2_154 VPWR VGND sg13g2_decap_8
XFILLER_3_699 VPWR VGND sg13g2_decap_4
XFILLER_0_35 VPWR VGND sg13g2_decap_8
X_329_ Tile_X0Y0_FrameData[19] Tile_X1Y0_FrameStrobe[1] Tile_X1Y0_S_XIF_middle.Inst_S_XIF_middle_ConfigMem.Inst_frame1_bit19.Q
+ VPWR VGND sg13g2_dlhq_1
XFILLER_9_77 VPWR VGND sg13g2_decap_8
XFILLER_7_983 VPWR VGND sg13g2_decap_8
XFILLER_6_471 VPWR VGND sg13g2_decap_8
XFILLER_9_1024 VPWR VGND sg13g2_fill_1
XFILLER_0_625 VPWR VGND sg13g2_decap_8
X_680_ Tile_X2Y0_FrameStrobe[4] Tile_X2Y0_FrameStrobe_O[4] VPWR VGND sg13g2_buf_1
XFILLER_1_1319 VPWR VGND sg13g2_fill_1
XFILLER_3_1190 VPWR VGND sg13g2_fill_1
X_114_ Tile_X2Y0_S_XIF_right.Inst_S_XIF_right_ConfigMem.Inst_frame0_bit8.Q VPWR _008_
+ VGND Tile_X2Y0_SS4END[4] Tile_X2Y0_S_XIF_right.Inst_S_XIF_right_ConfigMem.Inst_frame0_bit9.Q
+ sg13g2_o21ai_1
XFILLER_4_964 VPWR VGND sg13g2_decap_8
XFILLER_3_485 VPWR VGND sg13g2_decap_8
XFILLER_0_1330 VPWR VGND sg13g2_fill_2
X_732_ Tile_X2Y0_S_XIF_right.Inst_S_XIF_right_switch_matrix.NN4BEG0 Tile_X2Y0_NN4BEG[0]
+ VPWR VGND sg13g2_buf_1
XFILLER_1_967 VPWR VGND sg13g2_fill_1
XFILLER_1_956 VPWR VGND sg13g2_decap_8
XFILLER_0_499 VPWR VGND sg13g2_decap_8
XFILLER_0_422 VPWR VGND sg13g2_decap_8
X_594_ Tile_X1Y0_S_XIF_middle.Inst_S_XIF_middle_switch_matrix.N1BEG3 Tile_X1Y0_N1BEG[3]
+ VPWR VGND sg13g2_buf_1
X_663_ Tile_X0Y0_FrameData[19] Tile_X2Y0_FrameData_O[19] VPWR VGND sg13g2_buf_1
XFILLER_1_1116 VPWR VGND sg13g2_decap_8
XFILLER_5_1285 VPWR VGND sg13g2_decap_8
XFILLER_8_588 VPWR VGND sg13g2_fill_2
XANTENNA_5 VPWR VGND ISSUE_OPA_top11 sg13g2_antennanp
XFILLER_4_761 VPWR VGND sg13g2_decap_8
XFILLER_6_56 VPWR VGND sg13g2_decap_8
XFILLER_5_536 VPWR VGND sg13g2_decap_8
X_715_ Tile_X2Y0_S2END[0] Tile_X2Y0_N2BEGb[7] VPWR VGND sg13g2_buf_1
XFILLER_1_764 VPWR VGND sg13g2_decap_8
XFILLER_0_296 VPWR VGND sg13g2_decap_8
XFILLER_0_252 VPWR VGND sg13g2_fill_2
XFILLER_5_1060 VPWR VGND sg13g2_decap_8
XFILLER_5_1071 VPWR VGND sg13g2_fill_1
X_577_ Tile_X1Y0_FrameStrobe[6] Tile_X1Y0_FrameStrobe_O[6] VPWR VGND sg13g2_buf_1
X_646_ Tile_X0Y0_FrameData[2] Tile_X2Y0_FrameData_O[2] VPWR VGND sg13g2_buf_1
XFILLER_9_864 VPWR VGND sg13g2_decap_8
XFILLER_11_0 VPWR VGND sg13g2_decap_8
X_500_ Tile_X0Y0_FrameStrobe[2] Tile_X0Y0_FrameStrobe_O[2] VPWR VGND sg13g2_buf_1
XFILLER_2_1244 VPWR VGND sg13g2_decap_8
X_362_ Tile_X0Y0_FrameData[21] Tile_X2Y0_FrameStrobe[0] Tile_X2Y0_S_XIF_right.Inst_S_XIF_right_ConfigMem.Inst_frame0_bit21.Q
+ VPWR VGND sg13g2_dlhq_1
X_431_ Tile_X0Y0_FrameData[16] Tile_X0Y0_FrameStrobe[0] Tile_X0Y0_S_XIF_left.Inst_S_XIF_left_ConfigMem.Inst_frame0_bit16.Q
+ VPWR VGND sg13g2_dlhq_1
X_293_ Tile_X1Y0_S1END[1] Tile_X1Y0_S2END[1] Tile_X1Y0_S_XIF_middle.Inst_S_XIF_middle_ConfigMem.Inst_frame0_bit25.Q
+ RESULT_ID_top2 VPWR VGND sg13g2_mux2_1
XFILLER_6_812 VPWR VGND sg13g2_decap_8
XFILLER_1_583 VPWR VGND sg13g2_fill_1
XFILLER_1_572 VPWR VGND sg13g2_decap_8
XFILLER_3_35 VPWR VGND sg13g2_decap_8
XFILLER_6_889 VPWR VGND sg13g2_decap_8
X_629_ Tile_X1Y0_S_XIF_middle.Inst_S_XIF_middle_switch_matrix.NN4BEG2 Tile_X1Y0_NN4BEG[2]
+ VPWR VGND sg13g2_buf_1
XFILLER_7_1177 VPWR VGND sg13g2_fill_1
XFILLER_3_1019 VPWR VGND sg13g2_decap_8
XFILLER_8_193 VPWR VGND sg13g2_decap_8
XFILLER_11_627 VPWR VGND sg13g2_fill_2
XFILLER_6_119 VPWR VGND sg13g2_decap_8
XFILLER_7_609 VPWR VGND sg13g2_fill_2
XFILLER_2_358 VPWR VGND sg13g2_decap_8
XFILLER_3_837 VPWR VGND sg13g2_decap_8
XFILLER_2_1074 VPWR VGND sg13g2_decap_8
X_414_ Tile_X0Y0_FrameData[1] Tile_X2Y0_FrameStrobe[1] Tile_X2Y0_S_XIF_right.Inst_S_XIF_right_ConfigMem.Inst_frame1_bit1.Q
+ VPWR VGND sg13g2_dlhq_1
X_276_ Tile_X1Y0_SS4END[5] ISSUE_INSTR_top21 Tile_X1Y0_S_XIF_middle.Inst_S_XIF_middle_ConfigMem.Inst_frame0_bit11.Q
+ Tile_X1Y0_S_XIF_middle.Inst_S_XIF_middle_switch_matrix.NN4BEG10 VPWR VGND sg13g2_mux2_1
X_345_ Tile_X0Y0_FrameData[3] Tile_X1Y0_FrameStrobe[1] Tile_X1Y0_S_XIF_middle.Inst_S_XIF_middle_ConfigMem.Inst_frame1_bit3.Q
+ VPWR VGND sg13g2_dlhq_1
XFILLER_5_174 VPWR VGND sg13g2_decap_8
XFILLER_6_675 VPWR VGND sg13g2_fill_2
XFILLER_2_892 VPWR VGND sg13g2_decap_8
XFILLER_9_480 VPWR VGND sg13g2_decap_8
XFILLER_11_446 VPWR VGND sg13g2_decap_8
X_130_ _019_ Tile_X2Y0_S4END[9] Tile_X2Y0_S_XIF_right.Inst_S_XIF_right_ConfigMem.Inst_frame0_bit18.Q
+ VPWR VGND sg13g2_nand2b_1
XFILLER_7_406 VPWR VGND sg13g2_decap_8
XFILLER_7_439 VPWR VGND sg13g2_decap_8
XFILLER_2_133 VPWR VGND sg13g2_decap_8
XFILLER_0_14 VPWR VGND sg13g2_decap_8
XFILLER_11_991 VPWR VGND sg13g2_decap_8
X_259_ Tile_X1Y0_S4END[6] ISSUE_INSTR_top6 Tile_X1Y0_S_XIF_middle.Inst_S_XIF_middle_ConfigMem.Inst_frame1_bit26.Q
+ Tile_X1Y0_S_XIF_middle.Inst_S_XIF_middle_switch_matrix.N4BEG9 VPWR VGND sg13g2_mux2_1
XFILLER_9_56 VPWR VGND sg13g2_decap_8
XFILLER_7_962 VPWR VGND sg13g2_decap_8
X_328_ Tile_X0Y0_FrameData[20] Tile_X1Y0_FrameStrobe[1] Tile_X1Y0_S_XIF_middle.Inst_S_XIF_middle_ConfigMem.Inst_frame1_bit20.Q
+ VPWR VGND sg13g2_dlhq_1
XFILLER_6_450 VPWR VGND sg13g2_decap_8
XFILLER_0_604 VPWR VGND sg13g2_decap_8
X_113_ _006_ VPWR RESULT_top3 VGND Tile_X2Y0_S_XIF_right.Inst_S_XIF_right_ConfigMem.Inst_frame0_bit7.Q
+ _007_ sg13g2_o21ai_1
XFILLER_7_236 VPWR VGND sg13g2_fill_1
XFILLER_3_464 VPWR VGND sg13g2_decap_8
XFILLER_4_943 VPWR VGND sg13g2_decap_8
XFILLER_7_792 VPWR VGND sg13g2_decap_8
XFILLER_1_90 VPWR VGND sg13g2_decap_8
XFILLER_1_935 VPWR VGND sg13g2_fill_1
XFILLER_1_924 VPWR VGND sg13g2_decap_8
XFILLER_0_401 VPWR VGND sg13g2_decap_8
X_662_ Tile_X0Y0_FrameData[18] Tile_X2Y0_FrameData_O[18] VPWR VGND sg13g2_buf_1
X_731_ Tile_X2Y0_S_XIF_right.Inst_S_XIF_right_switch_matrix.N4BEG15 Tile_X2Y0_N4BEG[15]
+ VPWR VGND sg13g2_buf_1
XFILLER_1_979 VPWR VGND sg13g2_decap_4
XFILLER_0_478 VPWR VGND sg13g2_decap_8
XFILLER_5_1231 VPWR VGND sg13g2_decap_8
XFILLER_5_1264 VPWR VGND sg13g2_decap_8
X_593_ Tile_X1Y0_S_XIF_middle.Inst_S_XIF_middle_switch_matrix.N1BEG2 Tile_X1Y0_N1BEG[2]
+ VPWR VGND sg13g2_buf_1
XANTENNA_6 VPWR VGND ISSUE_OPA_top13 sg13g2_antennanp
XFILLER_8_545 VPWR VGND sg13g2_fill_2
XFILLER_6_35 VPWR VGND sg13g2_decap_8
XFILLER_3_272 VPWR VGND sg13g2_fill_1
XFILLER_0_1194 VPWR VGND sg13g2_decap_8
XFILLER_5_515 VPWR VGND sg13g2_decap_8
XFILLER_7_1326 VPWR VGND sg13g2_decap_4
XFILLER_1_743 VPWR VGND sg13g2_fill_1
XFILLER_1_732 VPWR VGND sg13g2_decap_8
XFILLER_0_231 VPWR VGND sg13g2_decap_8
X_714_ Tile_X2Y0_S2END[1] Tile_X2Y0_N2BEGb[6] VPWR VGND sg13g2_buf_1
XFILLER_0_275 VPWR VGND sg13g2_decap_8
X_645_ Tile_X0Y0_FrameData[1] Tile_X2Y0_FrameData_O[1] VPWR VGND sg13g2_buf_1
XFILLER_9_843 VPWR VGND sg13g2_decap_8
X_576_ Tile_X1Y0_FrameStrobe[5] Tile_X1Y0_FrameStrobe_O[5] VPWR VGND sg13g2_buf_1
XFILLER_8_353 VPWR VGND sg13g2_fill_2
XFILLER_11_1099 VPWR VGND sg13g2_fill_2
XFILLER_11_1044 VPWR VGND sg13g2_decap_8
XFILLER_2_1223 VPWR VGND sg13g2_decap_8
X_292_ Tile_X1Y0_S1END[2] Tile_X1Y0_S2END[2] Tile_X1Y0_S_XIF_middle.Inst_S_XIF_middle_ConfigMem.Inst_frame0_bit24.Q
+ RESULT_ID_top1 VPWR VGND sg13g2_mux2_1
X_361_ Tile_X0Y0_FrameData[22] Tile_X2Y0_FrameStrobe[0] Tile_X2Y0_S_XIF_right.Inst_S_XIF_right_ConfigMem.Inst_frame0_bit22.Q
+ VPWR VGND sg13g2_dlhq_1
X_430_ Tile_X0Y0_FrameData[17] Tile_X0Y0_FrameStrobe[0] Tile_X0Y0_S_XIF_left.Inst_S_XIF_left_ConfigMem.Inst_frame0_bit17.Q
+ VPWR VGND sg13g2_dlhq_1
XFILLER_10_886 VPWR VGND sg13g2_fill_2
XFILLER_5_301 VPWR VGND sg13g2_fill_2
XFILLER_5_367 VPWR VGND sg13g2_decap_8
XFILLER_6_868 VPWR VGND sg13g2_decap_8
XFILLER_1_595 VPWR VGND sg13g2_decap_8
XFILLER_1_551 VPWR VGND sg13g2_fill_1
XFILLER_1_540 VPWR VGND sg13g2_decap_8
XFILLER_3_14 VPWR VGND sg13g2_decap_8
X_628_ Tile_X1Y0_S_XIF_middle.Inst_S_XIF_middle_switch_matrix.NN4BEG1 Tile_X1Y0_NN4BEG[1]
+ VPWR VGND sg13g2_buf_1
XFILLER_8_172 VPWR VGND sg13g2_decap_8
X_559_ Tile_X0Y0_S_XIF_left.Inst_S_XIF_left_switch_matrix.NN4BEG5 Tile_X0Y0_NN4BEG[5]
+ VPWR VGND sg13g2_buf_1
XFILLER_3_816 VPWR VGND sg13g2_decap_8
XFILLER_2_337 VPWR VGND sg13g2_decap_8
X_413_ Tile_X0Y0_FrameData[2] Tile_X2Y0_FrameStrobe[1] Tile_X2Y0_S_XIF_right.Inst_S_XIF_right_ConfigMem.Inst_frame1_bit2.Q
+ VPWR VGND sg13g2_dlhq_1
XFILLER_2_1053 VPWR VGND sg13g2_decap_8
X_275_ Tile_X1Y0_SS4END[6] ISSUE_INSTR_top22 Tile_X1Y0_S_XIF_middle.Inst_S_XIF_middle_ConfigMem.Inst_frame0_bit10.Q
+ Tile_X1Y0_S_XIF_middle.Inst_S_XIF_middle_switch_matrix.NN4BEG9 VPWR VGND sg13g2_mux2_1
X_344_ Tile_X0Y0_FrameData[4] Tile_X1Y0_FrameStrobe[1] Tile_X1Y0_S_XIF_middle.Inst_S_XIF_middle_ConfigMem.Inst_frame1_bit4.Q
+ VPWR VGND sg13g2_dlhq_1
XFILLER_6_643 VPWR VGND sg13g2_fill_2
XFILLER_2_871 VPWR VGND sg13g2_decap_8
XFILLER_0_819 VPWR VGND sg13g2_decap_8
XFILLER_2_112 VPWR VGND sg13g2_decap_8
XFILLER_2_189 VPWR VGND sg13g2_decap_8
XFILLER_4_1104 VPWR VGND sg13g2_decap_4
XFILLER_9_35 VPWR VGND sg13g2_decap_8
XFILLER_11_970 VPWR VGND sg13g2_decap_8
X_258_ Tile_X1Y0_S4END[7] ISSUE_INSTR_top7 Tile_X1Y0_S_XIF_middle.Inst_S_XIF_middle_ConfigMem.Inst_frame1_bit25.Q
+ Tile_X1Y0_S_XIF_middle.Inst_S_XIF_middle_switch_matrix.N4BEG8 VPWR VGND sg13g2_mux2_1
XFILLER_7_941 VPWR VGND sg13g2_decap_8
X_189_ _037_ Tile_X0Y0_S4END[2] Tile_X0Y0_S_XIF_left.Inst_S_XIF_left_ConfigMem.Inst_frame0_bit4.Q
+ VPWR VGND sg13g2_nand2b_1
X_327_ Tile_X0Y0_FrameData[21] Tile_X1Y0_FrameStrobe[1] Tile_X1Y0_S_XIF_middle.Inst_S_XIF_middle_ConfigMem.Inst_frame1_bit21.Q
+ VPWR VGND sg13g2_dlhq_1
X_112_ _007_ Tile_X2Y0_S4END[3] Tile_X2Y0_S_XIF_right.Inst_S_XIF_right_ConfigMem.Inst_frame0_bit6.Q
+ VPWR VGND sg13g2_nand2b_1
XFILLER_1_0 VPWR VGND sg13g2_decap_8
XFILLER_3_443 VPWR VGND sg13g2_decap_8
XFILLER_4_922 VPWR VGND sg13g2_decap_8
XFILLER_4_999 VPWR VGND sg13g2_decap_8
XFILLER_0_1310 VPWR VGND sg13g2_fill_2
XFILLER_1_947 VPWR VGND sg13g2_decap_4
X_730_ Tile_X2Y0_S_XIF_right.Inst_S_XIF_right_switch_matrix.N4BEG14 Tile_X2Y0_N4BEG[14]
+ VPWR VGND sg13g2_buf_1
X_592_ Tile_X1Y0_S_XIF_middle.Inst_S_XIF_middle_switch_matrix.N1BEG1 Tile_X1Y0_N1BEG[1]
+ VPWR VGND sg13g2_buf_1
XFILLER_0_457 VPWR VGND sg13g2_decap_8
X_661_ Tile_X0Y0_FrameData[17] Tile_X2Y0_FrameData_O[17] VPWR VGND sg13g2_buf_1
XFILLER_8_513 VPWR VGND sg13g2_decap_8
XFILLER_6_14 VPWR VGND sg13g2_decap_8
XANTENNA_7 VPWR VGND ISSUE_OPA_top14 sg13g2_antennanp
XFILLER_0_980 VPWR VGND sg13g2_decap_8
XFILLER_4_796 VPWR VGND sg13g2_decap_8
XFILLER_6_1029 VPWR VGND sg13g2_decap_8
XFILLER_1_788 VPWR VGND sg13g2_decap_4
XFILLER_1_755 VPWR VGND sg13g2_decap_4
XFILLER_0_210 VPWR VGND sg13g2_decap_8
X_713_ Tile_X2Y0_S2END[2] Tile_X2Y0_N2BEGb[5] VPWR VGND sg13g2_buf_1
X_575_ Tile_X1Y0_FrameStrobe[4] Tile_X1Y0_FrameStrobe_O[4] VPWR VGND sg13g2_buf_1
X_644_ Tile_X0Y0_FrameData[0] Tile_X2Y0_FrameData_O[0] VPWR VGND sg13g2_buf_1
XFILLER_9_811 VPWR VGND sg13g2_fill_1
XFILLER_9_899 VPWR VGND sg13g2_decap_8
XFILLER_8_387 VPWR VGND sg13g2_decap_8
XFILLER_11_1012 VPWR VGND sg13g2_decap_8
XFILLER_2_519 VPWR VGND sg13g2_decap_8
XFILLER_2_1279 VPWR VGND sg13g2_decap_8
X_291_ Tile_X1Y0_S1END[3] Tile_X1Y0_S2END[3] Tile_X1Y0_S_XIF_middle.Inst_S_XIF_middle_ConfigMem.Inst_frame0_bit23.Q
+ RESULT_ID_top0 VPWR VGND sg13g2_mux2_1
X_360_ Tile_X0Y0_FrameData[23] Tile_X2Y0_FrameStrobe[0] Tile_X2Y0_S_XIF_right.Inst_S_XIF_right_ConfigMem.Inst_frame0_bit23.Q
+ VPWR VGND sg13g2_dlhq_1
XFILLER_10_865 VPWR VGND sg13g2_decap_8
XFILLER_5_335 VPWR VGND sg13g2_decap_8
XFILLER_6_847 VPWR VGND sg13g2_decap_8
XFILLER_1_563 VPWR VGND sg13g2_decap_4
X_627_ Tile_X1Y0_S_XIF_middle.Inst_S_XIF_middle_switch_matrix.NN4BEG0 Tile_X1Y0_NN4BEG[0]
+ VPWR VGND sg13g2_buf_1
X_558_ Tile_X0Y0_S_XIF_left.Inst_S_XIF_left_switch_matrix.NN4BEG4 Tile_X0Y0_NN4BEG[4]
+ VPWR VGND sg13g2_buf_1
XFILLER_9_641 VPWR VGND sg13g2_fill_1
XFILLER_8_140 VPWR VGND sg13g2_decap_8
X_489_ Tile_X0Y0_FrameData[22] Tile_X1Y0_FrameStrobe[0] Tile_X1Y0_S_XIF_middle.Inst_S_XIF_middle_ConfigMem.Inst_frame0_bit22.Q
+ VPWR VGND sg13g2_dlhq_1
XFILLER_5_880 VPWR VGND sg13g2_decap_8
XFILLER_11_629 VPWR VGND sg13g2_fill_1
XFILLER_11_618 VPWR VGND sg13g2_fill_1
XFILLER_2_316 VPWR VGND sg13g2_decap_8
XFILLER_5_7 VPWR VGND sg13g2_decap_8
X_412_ Tile_X0Y0_FrameData[3] Tile_X2Y0_FrameStrobe[1] Tile_X2Y0_S_XIF_right.Inst_S_XIF_right_ConfigMem.Inst_frame1_bit3.Q
+ VPWR VGND sg13g2_dlhq_1
XFILLER_2_1032 VPWR VGND sg13g2_decap_8
XFILLER_10_651 VPWR VGND sg13g2_fill_2
X_343_ Tile_X0Y0_FrameData[5] Tile_X1Y0_FrameStrobe[1] Tile_X1Y0_S_XIF_middle.Inst_S_XIF_middle_ConfigMem.Inst_frame1_bit5.Q
+ VPWR VGND sg13g2_dlhq_1
X_274_ Tile_X1Y0_SS4END[7] ISSUE_INSTR_top23 Tile_X1Y0_S_XIF_middle.Inst_S_XIF_middle_ConfigMem.Inst_frame0_bit9.Q
+ Tile_X1Y0_S_XIF_middle.Inst_S_XIF_middle_switch_matrix.NN4BEG8 VPWR VGND sg13g2_mux2_1
XFILLER_2_850 VPWR VGND sg13g2_decap_8
XFILLER_5_154 VPWR VGND sg13g2_fill_2
XFILLER_6_677 VPWR VGND sg13g2_fill_1
XFILLER_6_688 VPWR VGND sg13g2_fill_1
XFILLER_4_91 VPWR VGND sg13g2_decap_8
XFILLER_3_1330 VPWR VGND sg13g2_fill_2
XFILLER_2_168 VPWR VGND sg13g2_decap_8
XFILLER_3_625 VPWR VGND sg13g2_decap_8
XFILLER_8_1285 VPWR VGND sg13g2_decap_8
XFILLER_8_1252 VPWR VGND sg13g2_fill_1
XFILLER_0_49 VPWR VGND sg13g2_decap_8
XFILLER_9_14 VPWR VGND sg13g2_decap_8
X_326_ Tile_X0Y0_FrameData[22] Tile_X1Y0_FrameStrobe[1] Tile_X1Y0_S_XIF_middle.Inst_S_XIF_middle_ConfigMem.Inst_frame1_bit22.Q
+ VPWR VGND sg13g2_dlhq_1
X_257_ Tile_X1Y0_S4END[8] ISSUE_INSTR_top8 Tile_X1Y0_S_XIF_middle.Inst_S_XIF_middle_ConfigMem.Inst_frame1_bit24.Q
+ Tile_X1Y0_S_XIF_middle.Inst_S_XIF_middle_switch_matrix.N4BEG7 VPWR VGND sg13g2_mux2_1
XFILLER_7_997 VPWR VGND sg13g2_decap_8
XFILLER_7_920 VPWR VGND sg13g2_decap_8
X_188_ Tile_X0Y0_S_XIF_left.Inst_S_XIF_left_ConfigMem.Inst_frame0_bit4.Q VPWR _036_
+ VGND Tile_X0Y0_SS4END[2] Tile_X0Y0_S_XIF_left.Inst_S_XIF_left_ConfigMem.Inst_frame0_bit5.Q
+ sg13g2_o21ai_1
XFILLER_6_485 VPWR VGND sg13g2_decap_8
XFILLER_9_1049 VPWR VGND sg13g2_fill_2
XFILLER_0_639 VPWR VGND sg13g2_decap_8
X_111_ Tile_X2Y0_S_XIF_right.Inst_S_XIF_right_ConfigMem.Inst_frame0_bit6.Q VPWR _006_
+ VGND Tile_X2Y0_SS4END[3] Tile_X2Y0_S_XIF_right.Inst_S_XIF_right_ConfigMem.Inst_frame0_bit7.Q
+ sg13g2_o21ai_1
XFILLER_4_901 VPWR VGND sg13g2_decap_8
XFILLER_8_1060 VPWR VGND sg13g2_decap_4
XFILLER_3_422 VPWR VGND sg13g2_decap_8
XFILLER_3_499 VPWR VGND sg13g2_decap_8
XFILLER_4_978 VPWR VGND sg13g2_decap_8
X_309_ Tile_X0Y0_FrameData[7] Tile_X1Y0_FrameStrobe[0] Tile_X1Y0_S_XIF_middle.Inst_S_XIF_middle_ConfigMem.Inst_frame0_bit7.Q
+ VPWR VGND sg13g2_dlhq_1
XFILLER_1_915 VPWR VGND sg13g2_decap_4
XFILLER_0_436 VPWR VGND sg13g2_decap_8
X_591_ Tile_X1Y0_S_XIF_middle.Inst_S_XIF_middle_switch_matrix.N1BEG0 Tile_X1Y0_N1BEG[0]
+ VPWR VGND sg13g2_buf_1
XFILLER_5_1299 VPWR VGND sg13g2_decap_8
X_660_ Tile_X0Y0_FrameData[16] Tile_X2Y0_FrameData_O[16] VPWR VGND sg13g2_buf_1
XANTENNA_8 VPWR VGND ISSUE_OPA_top15 sg13g2_antennanp
XFILLER_3_252 VPWR VGND sg13g2_decap_8
XFILLER_4_775 VPWR VGND sg13g2_decap_8
XFILLER_6_1008 VPWR VGND sg13g2_decap_8
XFILLER_11_1216 VPWR VGND sg13g2_decap_8
XFILLER_0_1141 VPWR VGND sg13g2_decap_8
XFILLER_0_1152 VPWR VGND sg13g2_fill_2
XFILLER_0_1174 VPWR VGND sg13g2_fill_1
X_712_ Tile_X2Y0_S2END[3] Tile_X2Y0_N2BEGb[4] VPWR VGND sg13g2_buf_1
XFILLER_1_712 VPWR VGND sg13g2_decap_8
XFILLER_5_1041 VPWR VGND sg13g2_fill_2
X_574_ Tile_X1Y0_FrameStrobe[3] Tile_X1Y0_FrameStrobe_O[3] VPWR VGND sg13g2_buf_1
X_643_ Tile_X1Y0_UserCLK Tile_X1Y0_UserCLKo VPWR VGND sg13g2_buf_1
XFILLER_9_878 VPWR VGND sg13g2_decap_8
XFILLER_9_801 VPWR VGND sg13g2_decap_4
XFILLER_4_583 VPWR VGND sg13g2_decap_8
XFILLER_7_91 VPWR VGND sg13g2_decap_8
XFILLER_2_1258 VPWR VGND sg13g2_decap_8
X_290_ _068_ VPWR RESULT_VALID_top VGND Tile_X1Y0_S_XIF_middle.Inst_S_XIF_middle_ConfigMem.Inst_frame0_bit22.Q
+ _069_ sg13g2_o21ai_1
XFILLER_6_826 VPWR VGND sg13g2_decap_8
XFILLER_10_899 VPWR VGND sg13g2_decap_8
XFILLER_7_1114 VPWR VGND sg13g2_decap_8
XFILLER_3_49 VPWR VGND sg13g2_decap_8
X_626_ Tile_X1Y0_S_XIF_middle.Inst_S_XIF_middle_switch_matrix.N4BEG15 Tile_X1Y0_N4BEG[15]
+ VPWR VGND sg13g2_buf_1
X_557_ Tile_X0Y0_S_XIF_left.Inst_S_XIF_left_switch_matrix.NN4BEG3 Tile_X0Y0_NN4BEG[3]
+ VPWR VGND sg13g2_buf_1
X_488_ Tile_X0Y0_FrameData[23] Tile_X1Y0_FrameStrobe[0] Tile_X1Y0_S_XIF_middle.Inst_S_XIF_middle_ConfigMem.Inst_frame0_bit23.Q
+ VPWR VGND sg13g2_dlhq_1
XFILLER_4_380 VPWR VGND sg13g2_decap_8
XFILLER_2_1011 VPWR VGND sg13g2_decap_8
XFILLER_4_1309 VPWR VGND sg13g2_fill_2
X_342_ Tile_X0Y0_FrameData[6] Tile_X1Y0_FrameStrobe[1] Tile_X1Y0_S_XIF_middle.Inst_S_XIF_middle_ConfigMem.Inst_frame1_bit6.Q
+ VPWR VGND sg13g2_dlhq_1
XFILLER_2_1088 VPWR VGND sg13g2_decap_8
X_411_ Tile_X0Y0_FrameData[4] Tile_X2Y0_FrameStrobe[1] Tile_X2Y0_S_XIF_right.Inst_S_XIF_right_ConfigMem.Inst_frame1_bit4.Q
+ VPWR VGND sg13g2_dlhq_1
X_273_ Tile_X1Y0_SS4END[8] ISSUE_INSTR_top24 Tile_X1Y0_S_XIF_middle.Inst_S_XIF_middle_ConfigMem.Inst_frame0_bit8.Q
+ Tile_X1Y0_S_XIF_middle.Inst_S_XIF_middle_switch_matrix.NN4BEG7 VPWR VGND sg13g2_mux2_1
XFILLER_5_133 VPWR VGND sg13g2_decap_8
XFILLER_1_383 VPWR VGND sg13g2_decap_8
XFILLER_5_188 VPWR VGND sg13g2_decap_8
X_609_ Tile_X1Y0_S_XIF_middle.Inst_S_XIF_middle_switch_matrix.N2BEGb6 Tile_X1Y0_N2BEGb[6]
+ VPWR VGND sg13g2_buf_1
XFILLER_9_494 VPWR VGND sg13g2_decap_4
XFILLER_4_70 VPWR VGND sg13g2_decap_8
XFILLER_2_147 VPWR VGND sg13g2_decap_8
XFILLER_3_604 VPWR VGND sg13g2_decap_8
XFILLER_0_28 VPWR VGND sg13g2_decap_8
XFILLER_4_1128 VPWR VGND sg13g2_fill_2
X_325_ Tile_X0Y0_FrameData[23] Tile_X1Y0_FrameStrobe[1] Tile_X1Y0_S_XIF_middle.Inst_S_XIF_middle_ConfigMem.Inst_frame1_bit23.Q
+ VPWR VGND sg13g2_dlhq_1
X_187_ _034_ VPWR RESULT_top17 VGND Tile_X0Y0_S_XIF_left.Inst_S_XIF_left_ConfigMem.Inst_frame0_bit3.Q
+ _035_ sg13g2_o21ai_1
XFILLER_10_471 VPWR VGND sg13g2_fill_1
X_256_ Tile_X1Y0_S4END[9] ISSUE_INSTR_top9 Tile_X1Y0_S_XIF_middle.Inst_S_XIF_middle_ConfigMem.Inst_frame1_bit23.Q
+ Tile_X1Y0_S_XIF_middle.Inst_S_XIF_middle_switch_matrix.N4BEG6 VPWR VGND sg13g2_mux2_1
XFILLER_7_976 VPWR VGND sg13g2_decap_8
XFILLER_6_464 VPWR VGND sg13g2_decap_8
XFILLER_1_180 VPWR VGND sg13g2_decap_4
XFILLER_0_618 VPWR VGND sg13g2_decap_8
XFILLER_11_246 VPWR VGND sg13g2_decap_4
X_110_ _004_ VPWR RESULT_top2 VGND Tile_X2Y0_S_XIF_right.Inst_S_XIF_right_ConfigMem.Inst_frame0_bit5.Q
+ _005_ sg13g2_o21ai_1
XFILLER_3_401 VPWR VGND sg13g2_decap_8
XFILLER_4_957 VPWR VGND sg13g2_decap_8
XFILLER_7_206 VPWR VGND sg13g2_fill_2
XFILLER_7_228 VPWR VGND sg13g2_decap_4
XFILLER_3_478 VPWR VGND sg13g2_decap_8
X_239_ Tile_X1Y0_S2MID[2] ISSUE_VALID_top Tile_X1Y0_S_XIF_middle.Inst_S_XIF_middle_ConfigMem.Inst_frame1_bit6.Q
+ Tile_X1Y0_S_XIF_middle.Inst_S_XIF_middle_switch_matrix.N2BEG5 VPWR VGND sg13g2_mux2_1
X_308_ Tile_X0Y0_FrameData[8] Tile_X1Y0_FrameStrobe[0] Tile_X1Y0_S_XIF_middle.Inst_S_XIF_middle_ConfigMem.Inst_frame0_bit8.Q
+ VPWR VGND sg13g2_dlhq_1
XFILLER_1_60 VPWR VGND sg13g2_decap_8
XFILLER_1_71 VPWR VGND sg13g2_fill_1
XFILLER_0_1323 VPWR VGND sg13g2_decap_8
XFILLER_0_415 VPWR VGND sg13g2_decap_8
XFILLER_1_1109 VPWR VGND sg13g2_decap_8
X_590_ Tile_X1Y0_FrameStrobe[19] Tile_X1Y0_FrameStrobe_O[19] VPWR VGND sg13g2_buf_1
XFILLER_5_1278 VPWR VGND sg13g2_decap_8
XFILLER_4_743 VPWR VGND sg13g2_fill_1
XFILLER_6_49 VPWR VGND sg13g2_decap_8
XANTENNA_9 VPWR VGND ISSUE_OPA_top16 sg13g2_antennanp
XFILLER_0_1120 VPWR VGND sg13g2_decap_8
XFILLER_5_529 VPWR VGND sg13g2_decap_8
X_711_ Tile_X2Y0_S2END[4] Tile_X2Y0_N2BEGb[3] VPWR VGND sg13g2_buf_1
X_642_ Tile_X1Y0_S_XIF_middle.Inst_S_XIF_middle_switch_matrix.NN4BEG15 Tile_X1Y0_NN4BEG[15]
+ VPWR VGND sg13g2_buf_1
XFILLER_7_1307 VPWR VGND sg13g2_decap_4
XFILLER_0_245 VPWR VGND sg13g2_decap_8
XFILLER_0_289 VPWR VGND sg13g2_decap_8
XFILLER_5_1020 VPWR VGND sg13g2_decap_8
X_573_ Tile_X1Y0_FrameStrobe[2] Tile_X1Y0_FrameStrobe_O[2] VPWR VGND sg13g2_buf_1
XFILLER_9_857 VPWR VGND sg13g2_decap_8
XFILLER_4_540 VPWR VGND sg13g2_fill_2
XFILLER_4_562 VPWR VGND sg13g2_decap_8
XFILLER_11_1058 VPWR VGND sg13g2_decap_4
XFILLER_7_70 VPWR VGND sg13g2_decap_8
XFILLER_2_1237 VPWR VGND sg13g2_decap_8
XFILLER_6_805 VPWR VGND sg13g2_decap_8
XFILLER_1_532 VPWR VGND sg13g2_decap_4
XFILLER_3_28 VPWR VGND sg13g2_decap_8
X_625_ Tile_X1Y0_S_XIF_middle.Inst_S_XIF_middle_switch_matrix.N4BEG14 Tile_X1Y0_N4BEG[14]
+ VPWR VGND sg13g2_buf_1
X_487_ Tile_X0Y0_FrameData[24] Tile_X1Y0_FrameStrobe[0] Tile_X1Y0_S_XIF_middle.Inst_S_XIF_middle_ConfigMem.Inst_frame0_bit24.Q
+ VPWR VGND sg13g2_dlhq_1
XFILLER_9_610 VPWR VGND sg13g2_fill_1
X_556_ Tile_X0Y0_S_XIF_left.Inst_S_XIF_left_switch_matrix.NN4BEG2 Tile_X0Y0_NN4BEG[2]
+ VPWR VGND sg13g2_buf_1
XFILLER_8_186 VPWR VGND sg13g2_decap_8
XFILLER_1_1281 VPWR VGND sg13g2_decap_8
X_272_ Tile_X1Y0_SS4END[9] ISSUE_INSTR_top25 Tile_X1Y0_S_XIF_middle.Inst_S_XIF_middle_ConfigMem.Inst_frame0_bit7.Q
+ Tile_X1Y0_S_XIF_middle.Inst_S_XIF_middle_switch_matrix.NN4BEG6 VPWR VGND sg13g2_mux2_1
X_341_ Tile_X0Y0_FrameData[7] Tile_X1Y0_FrameStrobe[1] Tile_X1Y0_S_XIF_middle.Inst_S_XIF_middle_ConfigMem.Inst_frame1_bit7.Q
+ VPWR VGND sg13g2_dlhq_1
XFILLER_2_1067 VPWR VGND sg13g2_decap_8
X_410_ Tile_X0Y0_FrameData[5] Tile_X2Y0_FrameStrobe[1] Tile_X2Y0_S_XIF_right.Inst_S_XIF_right_ConfigMem.Inst_frame1_bit5.Q
+ VPWR VGND sg13g2_dlhq_1
XFILLER_10_697 VPWR VGND sg13g2_decap_8
XFILLER_5_112 VPWR VGND sg13g2_decap_8
XFILLER_5_167 VPWR VGND sg13g2_decap_8
XFILLER_6_602 VPWR VGND sg13g2_decap_4
XFILLER_1_362 VPWR VGND sg13g2_decap_8
XFILLER_2_885 VPWR VGND sg13g2_decap_8
X_608_ Tile_X1Y0_S_XIF_middle.Inst_S_XIF_middle_switch_matrix.N2BEGb5 Tile_X1Y0_N2BEGb[5]
+ VPWR VGND sg13g2_buf_1
XFILLER_9_473 VPWR VGND sg13g2_decap_8
X_539_ Tile_X0Y0_S_XIF_left.Inst_S_XIF_left_switch_matrix.N4BEG1 Tile_X0Y0_N4BEG[1]
+ VPWR VGND sg13g2_buf_1
XFILLER_2_126 VPWR VGND sg13g2_decap_8
XFILLER_11_984 VPWR VGND sg13g2_decap_8
X_324_ Tile_X0Y0_FrameData[24] Tile_X1Y0_FrameStrobe[1] Tile_X1Y0_S_XIF_middle.Inst_S_XIF_middle_ConfigMem.Inst_frame1_bit24.Q
+ VPWR VGND sg13g2_dlhq_1
X_255_ Tile_X1Y0_S4END[10] ISSUE_INSTR_top10 Tile_X1Y0_S_XIF_middle.Inst_S_XIF_middle_ConfigMem.Inst_frame1_bit22.Q
+ Tile_X1Y0_S_XIF_middle.Inst_S_XIF_middle_switch_matrix.N4BEG5 VPWR VGND sg13g2_mux2_1
XFILLER_9_49 VPWR VGND sg13g2_decap_8
X_186_ _035_ Tile_X0Y0_S4END[1] Tile_X0Y0_S_XIF_left.Inst_S_XIF_left_ConfigMem.Inst_frame0_bit2.Q
+ VPWR VGND sg13g2_nand2b_1
XFILLER_9_1029 VPWR VGND sg13g2_fill_1
XFILLER_10_483 VPWR VGND sg13g2_decap_4
XFILLER_7_955 VPWR VGND sg13g2_decap_8
XFILLER_6_443 VPWR VGND sg13g2_decap_8
XFILLER_3_457 VPWR VGND sg13g2_decap_8
XFILLER_4_936 VPWR VGND sg13g2_decap_8
X_169_ Tile_X0Y0_SS4END[12] ISSUE_OPA_top28 Tile_X0Y0_S_XIF_left.Inst_S_XIF_left_ConfigMem.Inst_frame1_bit19.Q
+ Tile_X0Y0_S_XIF_left.Inst_S_XIF_left_switch_matrix.NN4BEG3 VPWR VGND sg13g2_mux2_1
X_307_ Tile_X0Y0_FrameData[9] Tile_X1Y0_FrameStrobe[0] Tile_X1Y0_S_XIF_middle.Inst_S_XIF_middle_ConfigMem.Inst_frame0_bit9.Q
+ VPWR VGND sg13g2_dlhq_1
X_238_ Tile_X1Y0_S2MID[3] ISSUE_VALID_top Tile_X1Y0_S_XIF_middle.Inst_S_XIF_middle_ConfigMem.Inst_frame1_bit5.Q
+ Tile_X1Y0_S_XIF_middle.Inst_S_XIF_middle_switch_matrix.N2BEG4 VPWR VGND sg13g2_mux2_1
XFILLER_3_991 VPWR VGND sg13g2_decap_8
XFILLER_1_83 VPWR VGND sg13g2_decap_8
XFILLER_5_1202 VPWR VGND sg13g2_fill_2
XFILLER_6_28 VPWR VGND sg13g2_decap_8
XFILLER_10_70 VPWR VGND sg13g2_decap_8
XFILLER_3_210 VPWR VGND sg13g2_decap_8
XFILLER_0_994 VPWR VGND sg13g2_decap_8
XFILLER_0_1187 VPWR VGND sg13g2_decap_8
XFILLER_5_508 VPWR VGND sg13g2_decap_8
XFILLER_0_224 VPWR VGND sg13g2_decap_8
X_710_ Tile_X2Y0_S2END[5] Tile_X2Y0_N2BEGb[2] VPWR VGND sg13g2_buf_1
X_572_ Tile_X1Y0_FrameStrobe[1] Tile_X1Y0_FrameStrobe_O[1] VPWR VGND sg13g2_buf_1
XFILLER_5_1043 VPWR VGND sg13g2_fill_1
X_641_ Tile_X1Y0_S_XIF_middle.Inst_S_XIF_middle_switch_matrix.NN4BEG14 Tile_X1Y0_NN4BEG[14]
+ VPWR VGND sg13g2_buf_1
XFILLER_8_346 VPWR VGND sg13g2_fill_2
XFILLER_8_313 VPWR VGND sg13g2_fill_2
XFILLER_0_791 VPWR VGND sg13g2_decap_8
XFILLER_11_1037 VPWR VGND sg13g2_decap_8
XFILLER_2_1216 VPWR VGND sg13g2_decap_8
XFILLER_6_1330 VPWR VGND sg13g2_fill_2
XFILLER_10_879 VPWR VGND sg13g2_decap_8
XFILLER_7_1138 VPWR VGND sg13g2_fill_2
XFILLER_1_588 VPWR VGND sg13g2_decap_8
X_624_ Tile_X1Y0_S_XIF_middle.Inst_S_XIF_middle_switch_matrix.N4BEG13 Tile_X1Y0_N4BEG[13]
+ VPWR VGND sg13g2_buf_1
X_555_ Tile_X0Y0_S_XIF_left.Inst_S_XIF_left_switch_matrix.NN4BEG1 Tile_X0Y0_NN4BEG[1]
+ VPWR VGND sg13g2_buf_1
X_486_ Tile_X0Y0_FrameData[25] Tile_X1Y0_FrameStrobe[0] Tile_X1Y0_S_XIF_middle.Inst_S_XIF_middle_ConfigMem.Inst_frame0_bit25.Q
+ VPWR VGND sg13g2_dlhq_1
XFILLER_8_165 VPWR VGND sg13g2_decap_8
XFILLER_5_894 VPWR VGND sg13g2_decap_8
XFILLER_1_1260 VPWR VGND sg13g2_decap_8
XFILLER_3_809 VPWR VGND sg13g2_decap_8
XFILLER_2_1046 VPWR VGND sg13g2_decap_8
X_271_ Tile_X1Y0_SS4END[10] ISSUE_INSTR_top26 Tile_X1Y0_S_XIF_middle.Inst_S_XIF_middle_ConfigMem.Inst_frame0_bit6.Q
+ Tile_X1Y0_S_XIF_middle.Inst_S_XIF_middle_switch_matrix.NN4BEG5 VPWR VGND sg13g2_mux2_1
X_340_ Tile_X0Y0_FrameData[8] Tile_X1Y0_FrameStrobe[1] Tile_X1Y0_S_XIF_middle.Inst_S_XIF_middle_ConfigMem.Inst_frame1_bit8.Q
+ VPWR VGND sg13g2_dlhq_1
XFILLER_1_341 VPWR VGND sg13g2_fill_2
XFILLER_2_864 VPWR VGND sg13g2_decap_8
X_538_ Tile_X0Y0_S_XIF_left.Inst_S_XIF_left_switch_matrix.N4BEG0 Tile_X0Y0_N4BEG[0]
+ VPWR VGND sg13g2_buf_1
X_607_ Tile_X1Y0_S_XIF_middle.Inst_S_XIF_middle_switch_matrix.N2BEGb4 Tile_X1Y0_N2BEGb[4]
+ VPWR VGND sg13g2_buf_1
XFILLER_9_452 VPWR VGND sg13g2_decap_8
X_469_ Tile_X0Y0_FrameData[10] Tile_X0Y0_FrameStrobe[1] Tile_X0Y0_S_XIF_left.Inst_S_XIF_left_ConfigMem.Inst_frame1_bit10.Q
+ VPWR VGND sg13g2_dlhq_1
XFILLER_5_691 VPWR VGND sg13g2_fill_1
XFILLER_2_105 VPWR VGND sg13g2_decap_8
XFILLER_3_7 VPWR VGND sg13g2_decap_8
XFILLER_8_1299 VPWR VGND sg13g2_decap_8
XFILLER_11_963 VPWR VGND sg13g2_decap_8
X_185_ Tile_X0Y0_S_XIF_left.Inst_S_XIF_left_ConfigMem.Inst_frame0_bit2.Q VPWR _034_
+ VGND Tile_X0Y0_SS4END[1] Tile_X0Y0_S_XIF_left.Inst_S_XIF_left_ConfigMem.Inst_frame0_bit3.Q
+ sg13g2_o21ai_1
XFILLER_10_462 VPWR VGND sg13g2_decap_8
XFILLER_9_28 VPWR VGND sg13g2_decap_8
X_323_ Tile_X0Y0_FrameData[25] Tile_X1Y0_FrameStrobe[1] Tile_X1Y0_S_XIF_middle.Inst_S_XIF_middle_ConfigMem.Inst_frame1_bit25.Q
+ VPWR VGND sg13g2_dlhq_1
XFILLER_7_934 VPWR VGND sg13g2_decap_8
X_254_ Tile_X1Y0_S4END[11] ISSUE_INSTR_top11 Tile_X1Y0_S_XIF_middle.Inst_S_XIF_middle_ConfigMem.Inst_frame1_bit21.Q
+ Tile_X1Y0_S_XIF_middle.Inst_S_XIF_middle_switch_matrix.N4BEG4 VPWR VGND sg13g2_mux2_1
XFILLER_6_499 VPWR VGND sg13g2_decap_8
XFILLER_3_436 VPWR VGND sg13g2_decap_8
XFILLER_4_915 VPWR VGND sg13g2_decap_8
X_306_ Tile_X0Y0_FrameData[10] Tile_X1Y0_FrameStrobe[0] Tile_X1Y0_S_XIF_middle.Inst_S_XIF_middle_ConfigMem.Inst_frame0_bit10.Q
+ VPWR VGND sg13g2_dlhq_1
XFILLER_11_771 VPWR VGND sg13g2_fill_2
X_168_ Tile_X0Y0_SS4END[13] ISSUE_OPA_top29 Tile_X0Y0_S_XIF_left.Inst_S_XIF_left_ConfigMem.Inst_frame1_bit18.Q
+ Tile_X0Y0_S_XIF_left.Inst_S_XIF_left_switch_matrix.NN4BEG2 VPWR VGND sg13g2_mux2_1
X_237_ Tile_X1Y0_S2MID[4] ISSUE_ID_top3 Tile_X1Y0_S_XIF_middle.Inst_S_XIF_middle_ConfigMem.Inst_frame1_bit4.Q
+ Tile_X1Y0_S_XIF_middle.Inst_S_XIF_middle_switch_matrix.N2BEG3 VPWR VGND sg13g2_mux2_1
XFILLER_2_491 VPWR VGND sg13g2_decap_8
XFILLER_3_970 VPWR VGND sg13g2_decap_8
X_099_ Tile_X2Y0_SS4END[2] ISSUE_OPB_top18 Tile_X2Y0_S_XIF_right.Inst_S_XIF_right_ConfigMem.Inst_frame1_bit29.Q
+ Tile_X2Y0_S_XIF_right.Inst_S_XIF_right_switch_matrix.NN4BEG13 VPWR VGND sg13g2_mux2_1
XFILLER_8_506 VPWR VGND sg13g2_decap_8
XFILLER_0_973 VPWR VGND sg13g2_decap_8
XFILLER_4_789 VPWR VGND sg13g2_decap_8
XFILLER_1_759 VPWR VGND sg13g2_fill_1
XFILLER_1_748 VPWR VGND sg13g2_decap_8
XFILLER_1_726 VPWR VGND sg13g2_fill_2
XFILLER_0_203 VPWR VGND sg13g2_decap_8
X_571_ Tile_X1Y0_FrameStrobe[0] Tile_X1Y0_FrameStrobe_O[0] VPWR VGND sg13g2_buf_1
X_640_ Tile_X1Y0_S_XIF_middle.Inst_S_XIF_middle_switch_matrix.NN4BEG13 Tile_X1Y0_NN4BEG[13]
+ VPWR VGND sg13g2_buf_1
XFILLER_4_597 VPWR VGND sg13g2_decap_8
XFILLER_11_1005 VPWR VGND sg13g2_decap_8
XFILLER_7_391 VPWR VGND sg13g2_fill_2
XFILLER_10_858 VPWR VGND sg13g2_decap_8
XFILLER_5_328 VPWR VGND sg13g2_decap_8
XFILLER_1_567 VPWR VGND sg13g2_fill_1
XFILLER_1_556 VPWR VGND sg13g2_decap_8
X_623_ Tile_X1Y0_S_XIF_middle.Inst_S_XIF_middle_switch_matrix.N4BEG12 Tile_X1Y0_N4BEG[12]
+ VPWR VGND sg13g2_buf_1
X_485_ Tile_X0Y0_FrameData[26] Tile_X1Y0_FrameStrobe[0] Tile_X1Y0_S_XIF_middle.Inst_S_XIF_middle_ConfigMem.Inst_frame0_bit26.Q
+ VPWR VGND sg13g2_dlhq_1
X_554_ Tile_X0Y0_S_XIF_left.Inst_S_XIF_left_switch_matrix.NN4BEG0 Tile_X0Y0_NN4BEG[0]
+ VPWR VGND sg13g2_buf_1
XFILLER_8_133 VPWR VGND sg13g2_decap_8
XFILLER_5_873 VPWR VGND sg13g2_decap_8
XFILLER_2_309 VPWR VGND sg13g2_decap_8
XFILLER_2_1025 VPWR VGND sg13g2_decap_8
XFILLER_10_644 VPWR VGND sg13g2_decap_8
X_270_ Tile_X1Y0_SS4END[11] ISSUE_INSTR_top27 Tile_X1Y0_S_XIF_middle.Inst_S_XIF_middle_ConfigMem.Inst_frame0_bit5.Q
+ Tile_X1Y0_S_XIF_middle.Inst_S_XIF_middle_switch_matrix.NN4BEG4 VPWR VGND sg13g2_mux2_1
XFILLER_2_843 VPWR VGND sg13g2_decap_8
XFILLER_5_147 VPWR VGND sg13g2_decap_8
XFILLER_1_397 VPWR VGND sg13g2_decap_8
X_606_ Tile_X1Y0_S_XIF_middle.Inst_S_XIF_middle_switch_matrix.N2BEGb3 Tile_X1Y0_N2BEGb[3]
+ VPWR VGND sg13g2_buf_1
X_537_ Tile_X0Y0_S2END[0] Tile_X0Y0_N2BEGb[7] VPWR VGND sg13g2_buf_1
X_468_ Tile_X0Y0_FrameData[11] Tile_X0Y0_FrameStrobe[1] Tile_X0Y0_S_XIF_left.Inst_S_XIF_left_ConfigMem.Inst_frame1_bit11.Q
+ VPWR VGND sg13g2_dlhq_1
X_399_ Tile_X0Y0_FrameData[16] Tile_X2Y0_FrameStrobe[1] Tile_X2Y0_S_XIF_right.Inst_S_XIF_right_ConfigMem.Inst_frame1_bit16.Q
+ VPWR VGND sg13g2_dlhq_1
XFILLER_4_84 VPWR VGND sg13g2_decap_8
XFILLER_3_1323 VPWR VGND sg13g2_decap_8
XFILLER_3_618 VPWR VGND sg13g2_decap_8
X_322_ Tile_X0Y0_FrameData[26] Tile_X1Y0_FrameStrobe[1] Tile_X1Y0_S_XIF_middle.Inst_S_XIF_middle_ConfigMem.Inst_frame1_bit26.Q
+ VPWR VGND sg13g2_dlhq_1
XFILLER_11_942 VPWR VGND sg13g2_decap_8
XFILLER_7_913 VPWR VGND sg13g2_decap_8
X_253_ Tile_X1Y0_S4END[12] ISSUE_INSTR_top12 Tile_X1Y0_S_XIF_middle.Inst_S_XIF_middle_ConfigMem.Inst_frame1_bit20.Q
+ Tile_X1Y0_S_XIF_middle.Inst_S_XIF_middle_switch_matrix.N4BEG3 VPWR VGND sg13g2_mux2_1
X_184_ _032_ VPWR RESULT_top16 VGND Tile_X0Y0_S_XIF_left.Inst_S_XIF_left_ConfigMem.Inst_frame0_bit1.Q
+ _033_ sg13g2_o21ai_1
XFILLER_6_478 VPWR VGND sg13g2_decap_8
XFILLER_2_673 VPWR VGND sg13g2_fill_1
XFILLER_3_1142 VPWR VGND sg13g2_decap_4
XFILLER_3_415 VPWR VGND sg13g2_decap_8
XFILLER_8_1064 VPWR VGND sg13g2_fill_1
XFILLER_8_1053 VPWR VGND sg13g2_decap_8
X_305_ Tile_X0Y0_FrameData[11] Tile_X1Y0_FrameStrobe[0] Tile_X1Y0_S_XIF_middle.Inst_S_XIF_middle_ConfigMem.Inst_frame0_bit11.Q
+ VPWR VGND sg13g2_dlhq_1
X_098_ Tile_X2Y0_SS4END[3] ISSUE_OPB_top19 Tile_X2Y0_S_XIF_right.Inst_S_XIF_right_ConfigMem.Inst_frame1_bit28.Q
+ Tile_X2Y0_S_XIF_right.Inst_S_XIF_right_switch_matrix.NN4BEG12 VPWR VGND sg13g2_mux2_1
X_167_ Tile_X0Y0_SS4END[14] ISSUE_OPA_top30 Tile_X0Y0_S_XIF_left.Inst_S_XIF_left_ConfigMem.Inst_frame1_bit17.Q
+ Tile_X0Y0_S_XIF_left.Inst_S_XIF_left_switch_matrix.NN4BEG1 VPWR VGND sg13g2_mux2_1
X_236_ Tile_X1Y0_S2MID[5] ISSUE_ID_top2 Tile_X1Y0_S_XIF_middle.Inst_S_XIF_middle_ConfigMem.Inst_frame1_bit3.Q
+ Tile_X1Y0_S_XIF_middle.Inst_S_XIF_middle_switch_matrix.N2BEG2 VPWR VGND sg13g2_mux2_1
XFILLER_2_470 VPWR VGND sg13g2_decap_8
XFILLER_1_919 VPWR VGND sg13g2_fill_1
XFILLER_1_908 VPWR VGND sg13g2_decap_8
XFILLER_0_429 VPWR VGND sg13g2_decap_8
XFILLER_4_768 VPWR VGND sg13g2_decap_8
XFILLER_0_952 VPWR VGND sg13g2_decap_8
X_219_ _057_ Tile_X0Y0_S4END[12] Tile_X0Y0_S_XIF_left.Inst_S_XIF_left_ConfigMem.Inst_frame0_bit24.Q
+ VPWR VGND sg13g2_nand2b_1
XFILLER_0_1134 VPWR VGND sg13g2_decap_8
XFILLER_4_1281 VPWR VGND sg13g2_decap_8
XFILLER_1_705 VPWR VGND sg13g2_decap_8
X_570_ Tile_X0Y0_UserCLK Tile_X0Y0_UserCLKo VPWR VGND sg13g2_buf_1
XFILLER_5_1034 VPWR VGND sg13g2_decap_8
XFILLER_5_1067 VPWR VGND sg13g2_decap_4
XFILLER_9_805 VPWR VGND sg13g2_fill_2
XFILLER_8_315 VPWR VGND sg13g2_fill_1
XFILLER_4_576 VPWR VGND sg13g2_decap_8
XFILLER_11_7 VPWR VGND sg13g2_decap_8
X_699_ Tile_X2Y0_S1END[0] Tile_X2Y0_N1BEG[3] VPWR VGND sg13g2_buf_1
XFILLER_8_882 VPWR VGND sg13g2_decap_8
XFILLER_7_84 VPWR VGND sg13g2_decap_8
XFILLER_6_1310 VPWR VGND sg13g2_fill_1
XFILLER_6_819 VPWR VGND sg13g2_decap_8
X_622_ Tile_X1Y0_S_XIF_middle.Inst_S_XIF_middle_switch_matrix.N4BEG11 Tile_X1Y0_N4BEG[11]
+ VPWR VGND sg13g2_buf_1
XFILLER_7_1107 VPWR VGND sg13g2_decap_8
XFILLER_1_579 VPWR VGND sg13g2_decap_4
X_553_ Tile_X0Y0_S_XIF_left.Inst_S_XIF_left_switch_matrix.N4BEG15 Tile_X0Y0_N4BEG[15]
+ VPWR VGND sg13g2_buf_1
X_484_ Tile_X0Y0_FrameData[27] Tile_X1Y0_FrameStrobe[0] Tile_X1Y0_S_XIF_middle.Inst_S_XIF_middle_ConfigMem.Inst_frame0_bit27.Q
+ VPWR VGND sg13g2_dlhq_1
XFILLER_8_112 VPWR VGND sg13g2_decap_8
XFILLER_4_373 VPWR VGND sg13g2_decap_8
XFILLER_5_852 VPWR VGND sg13g2_decap_8
XFILLER_0_590 VPWR VGND sg13g2_decap_8
XFILLER_1_1295 VPWR VGND sg13g2_decap_8
XFILLER_2_1004 VPWR VGND sg13g2_decap_8
XFILLER_5_126 VPWR VGND sg13g2_decap_8
XFILLER_1_376 VPWR VGND sg13g2_decap_8
XFILLER_1_343 VPWR VGND sg13g2_fill_1
XFILLER_1_310 VPWR VGND sg13g2_decap_4
XFILLER_2_822 VPWR VGND sg13g2_decap_8
XFILLER_2_899 VPWR VGND sg13g2_decap_8
X_605_ Tile_X1Y0_S_XIF_middle.Inst_S_XIF_middle_switch_matrix.N2BEGb2 Tile_X1Y0_N2BEGb[2]
+ VPWR VGND sg13g2_buf_1
X_467_ Tile_X0Y0_FrameData[12] Tile_X0Y0_FrameStrobe[1] Tile_X0Y0_S_XIF_left.Inst_S_XIF_left_ConfigMem.Inst_frame1_bit12.Q
+ VPWR VGND sg13g2_dlhq_1
X_536_ Tile_X0Y0_S2END[1] Tile_X0Y0_N2BEGb[6] VPWR VGND sg13g2_buf_1
X_398_ Tile_X0Y0_FrameData[17] Tile_X2Y0_FrameStrobe[1] Tile_X2Y0_S_XIF_right.Inst_S_XIF_right_ConfigMem.Inst_frame1_bit17.Q
+ VPWR VGND sg13g2_dlhq_1
XFILLER_9_498 VPWR VGND sg13g2_fill_1
XFILLER_9_487 VPWR VGND sg13g2_decap_8
XFILLER_4_63 VPWR VGND sg13g2_decap_8
XFILLER_1_1081 VPWR VGND sg13g2_decap_8
XFILLER_8_1213 VPWR VGND sg13g2_decap_8
XFILLER_11_921 VPWR VGND sg13g2_decap_8
X_252_ Tile_X1Y0_S4END[13] ISSUE_INSTR_top13 Tile_X1Y0_S_XIF_middle.Inst_S_XIF_middle_ConfigMem.Inst_frame1_bit19.Q
+ Tile_X1Y0_S_XIF_middle.Inst_S_XIF_middle_switch_matrix.N4BEG2 VPWR VGND sg13g2_mux2_1
X_321_ Tile_X0Y0_FrameData[27] Tile_X1Y0_FrameStrobe[1] Tile_X1Y0_S_XIF_middle.Inst_S_XIF_middle_ConfigMem.Inst_frame1_bit27.Q
+ VPWR VGND sg13g2_dlhq_1
XFILLER_11_998 VPWR VGND sg13g2_decap_8
XFILLER_7_969 VPWR VGND sg13g2_decap_8
X_183_ _033_ Tile_X0Y0_S4END[0] Tile_X0Y0_S_XIF_left.Inst_S_XIF_left_ConfigMem.Inst_frame0_bit0.Q
+ VPWR VGND sg13g2_nand2b_1
XFILLER_6_457 VPWR VGND sg13g2_decap_8
XFILLER_1_140 VPWR VGND sg13g2_decap_8
XFILLER_1_151 VPWR VGND sg13g2_fill_1
XFILLER_1_173 VPWR VGND sg13g2_decap_8
XFILLER_1_184 VPWR VGND sg13g2_fill_1
XFILLER_2_652 VPWR VGND sg13g2_decap_8
XFILLER_2_696 VPWR VGND sg13g2_decap_8
X_519_ Tile_X0Y0_S1END[2] Tile_X0Y0_N1BEG[1] VPWR VGND sg13g2_buf_1
XFILLER_6_980 VPWR VGND sg13g2_decap_8
XFILLER_8_1043 VPWR VGND sg13g2_decap_4
X_235_ Tile_X1Y0_S2MID[6] ISSUE_ID_top1 Tile_X1Y0_S_XIF_middle.Inst_S_XIF_middle_ConfigMem.Inst_frame1_bit2.Q
+ Tile_X1Y0_S_XIF_middle.Inst_S_XIF_middle_switch_matrix.N2BEG1 VPWR VGND sg13g2_mux2_1
X_304_ Tile_X0Y0_FrameData[12] Tile_X1Y0_FrameStrobe[0] Tile_X1Y0_S_XIF_middle.Inst_S_XIF_middle_ConfigMem.Inst_frame0_bit12.Q
+ VPWR VGND sg13g2_dlhq_1
X_097_ Tile_X2Y0_SS4END[4] ISSUE_OPB_top20 Tile_X2Y0_S_XIF_right.Inst_S_XIF_right_ConfigMem.Inst_frame1_bit27.Q
+ Tile_X2Y0_S_XIF_right.Inst_S_XIF_right_switch_matrix.NN4BEG11 VPWR VGND sg13g2_mux2_1
X_166_ Tile_X0Y0_SS4END[15] ISSUE_OPA_top31 Tile_X0Y0_S_XIF_left.Inst_S_XIF_left_ConfigMem.Inst_frame1_bit16.Q
+ Tile_X0Y0_S_XIF_left.Inst_S_XIF_left_switch_matrix.NN4BEG0 VPWR VGND sg13g2_mux2_1
XFILLER_7_799 VPWR VGND sg13g2_decap_4
XFILLER_7_744 VPWR VGND sg13g2_fill_1
XFILLER_6_221 VPWR VGND sg13g2_decap_8
XFILLER_1_42 VPWR VGND sg13g2_decap_8
XFILLER_1_97 VPWR VGND sg13g2_decap_8
XFILLER_9_1330 VPWR VGND sg13g2_fill_2
XFILLER_0_408 VPWR VGND sg13g2_decap_8
XFILLER_5_1238 VPWR VGND sg13g2_decap_4
XFILLER_10_84 VPWR VGND sg13g2_fill_1
XFILLER_0_931 VPWR VGND sg13g2_decap_8
X_149_ _030_ VPWR RESULT_top15 VGND Tile_X2Y0_S_XIF_right.Inst_S_XIF_right_ConfigMem.Inst_frame0_bit31.Q
+ _031_ sg13g2_o21ai_1
X_218_ Tile_X0Y0_S_XIF_left.Inst_S_XIF_left_ConfigMem.Inst_frame0_bit24.Q VPWR _056_
+ VGND Tile_X0Y0_SS4END[12] Tile_X0Y0_S_XIF_left.Inst_S_XIF_left_ConfigMem.Inst_frame0_bit25.Q
+ sg13g2_o21ai_1
XFILLER_7_530 VPWR VGND sg13g2_fill_1
XFILLER_0_1113 VPWR VGND sg13g2_decap_8
XFILLER_4_1260 VPWR VGND sg13g2_decap_8
XFILLER_1_739 VPWR VGND sg13g2_decap_4
XFILLER_0_238 VPWR VGND sg13g2_decap_8
XFILLER_5_1013 VPWR VGND sg13g2_decap_8
XANTENNA_90 VPWR VGND Tile_X0Y0_FrameData[5] sg13g2_antennanp
XFILLER_10_1221 VPWR VGND sg13g2_fill_2
XFILLER_4_533 VPWR VGND sg13g2_decap_8
XFILLER_0_772 VPWR VGND sg13g2_decap_8
X_698_ Tile_X2Y0_S1END[1] Tile_X2Y0_N1BEG[2] VPWR VGND sg13g2_buf_1
XFILLER_8_861 VPWR VGND sg13g2_decap_8
XFILLER_7_63 VPWR VGND sg13g2_decap_8
XFILLER_1_547 VPWR VGND sg13g2_decap_4
XFILLER_1_525 VPWR VGND sg13g2_decap_8
XFILLER_1_503 VPWR VGND sg13g2_fill_1
X_621_ Tile_X1Y0_S_XIF_middle.Inst_S_XIF_middle_switch_matrix.N4BEG10 Tile_X1Y0_N4BEG[10]
+ VPWR VGND sg13g2_buf_1
X_483_ Tile_X0Y0_FrameData[28] Tile_X1Y0_FrameStrobe[0] Tile_X1Y0_S_XIF_middle.Inst_S_XIF_middle_ConfigMem.Inst_frame0_bit28.Q
+ VPWR VGND sg13g2_dlhq_1
X_552_ Tile_X0Y0_S_XIF_left.Inst_S_XIF_left_switch_matrix.N4BEG14 Tile_X0Y0_N4BEG[14]
+ VPWR VGND sg13g2_buf_1
XFILLER_8_179 VPWR VGND sg13g2_decap_8
XFILLER_4_352 VPWR VGND sg13g2_decap_8
XFILLER_5_831 VPWR VGND sg13g2_decap_8
XFILLER_10_1062 VPWR VGND sg13g2_fill_1
XFILLER_1_1274 VPWR VGND sg13g2_decap_8
XFILLER_8_680 VPWR VGND sg13g2_fill_2
XFILLER_5_105 VPWR VGND sg13g2_decap_8
XFILLER_1_355 VPWR VGND sg13g2_decap_8
XFILLER_2_801 VPWR VGND sg13g2_decap_8
XFILLER_2_878 VPWR VGND sg13g2_decap_8
X_604_ Tile_X1Y0_S_XIF_middle.Inst_S_XIF_middle_switch_matrix.N2BEGb1 Tile_X1Y0_N2BEGb[1]
+ VPWR VGND sg13g2_buf_1
X_535_ Tile_X0Y0_S2END[2] Tile_X0Y0_N2BEGb[5] VPWR VGND sg13g2_buf_1
X_397_ Tile_X0Y0_FrameData[18] Tile_X2Y0_FrameStrobe[1] Tile_X2Y0_S_XIF_right.Inst_S_XIF_right_ConfigMem.Inst_frame1_bit18.Q
+ VPWR VGND sg13g2_dlhq_1
XFILLER_9_466 VPWR VGND sg13g2_decap_8
X_466_ Tile_X0Y0_FrameData[13] Tile_X0Y0_FrameStrobe[1] Tile_X0Y0_S_XIF_left.Inst_S_XIF_left_ConfigMem.Inst_frame1_bit13.Q
+ VPWR VGND sg13g2_dlhq_1
XFILLER_4_42 VPWR VGND sg13g2_decap_8
XFILLER_4_182 VPWR VGND sg13g2_decap_8
XFILLER_1_1060 VPWR VGND sg13g2_decap_8
XFILLER_2_119 VPWR VGND sg13g2_decap_8
XFILLER_11_977 VPWR VGND sg13g2_decap_8
XFILLER_11_900 VPWR VGND sg13g2_decap_8
X_251_ Tile_X1Y0_S4END[14] ISSUE_INSTR_top14 Tile_X1Y0_S_XIF_middle.Inst_S_XIF_middle_ConfigMem.Inst_frame1_bit18.Q
+ Tile_X1Y0_S_XIF_middle.Inst_S_XIF_middle_switch_matrix.N4BEG1 VPWR VGND sg13g2_mux2_1
X_320_ Tile_X0Y0_FrameData[28] Tile_X1Y0_FrameStrobe[1] Tile_X1Y0_S_XIF_middle.Inst_S_XIF_middle_ConfigMem.Inst_frame1_bit28.Q
+ VPWR VGND sg13g2_dlhq_1
X_182_ Tile_X0Y0_S_XIF_left.Inst_S_XIF_left_ConfigMem.Inst_frame0_bit0.Q VPWR _032_
+ VGND Tile_X0Y0_SS4END[0] Tile_X0Y0_S_XIF_left.Inst_S_XIF_left_ConfigMem.Inst_frame0_bit1.Q
+ sg13g2_o21ai_1
XFILLER_10_476 VPWR VGND sg13g2_decap_8
XFILLER_8_0 VPWR VGND sg13g2_decap_8
XFILLER_7_948 VPWR VGND sg13g2_decap_8
XFILLER_2_631 VPWR VGND sg13g2_decap_8
XFILLER_6_436 VPWR VGND sg13g2_decap_8
XFILLER_1_163 VPWR VGND sg13g2_decap_4
XFILLER_1_196 VPWR VGND sg13g2_decap_4
X_518_ Tile_X0Y0_S1END[3] Tile_X0Y0_N1BEG[0] VPWR VGND sg13g2_buf_1
X_449_ Tile_X0Y0_FrameData[30] Tile_X0Y0_FrameStrobe[1] Tile_X0Y0_S_XIF_left.Inst_S_XIF_left_ConfigMem.Inst_frame1_bit30.Q
+ VPWR VGND sg13g2_dlhq_1
XFILLER_5_480 VPWR VGND sg13g2_decap_8
XFILLER_3_1111 VPWR VGND sg13g2_fill_1
XFILLER_4_929 VPWR VGND sg13g2_decap_8
XFILLER_8_1022 VPWR VGND sg13g2_decap_8
XFILLER_1_7 VPWR VGND sg13g2_decap_8
X_303_ Tile_X0Y0_FrameData[13] Tile_X1Y0_FrameStrobe[0] Tile_X1Y0_S_XIF_middle.Inst_S_XIF_middle_ConfigMem.Inst_frame0_bit13.Q
+ VPWR VGND sg13g2_dlhq_1
X_234_ Tile_X1Y0_S2MID[7] ISSUE_ID_top0 Tile_X1Y0_S_XIF_middle.Inst_S_XIF_middle_ConfigMem.Inst_frame1_bit1.Q
+ Tile_X1Y0_S_XIF_middle.Inst_S_XIF_middle_switch_matrix.N2BEG0 VPWR VGND sg13g2_mux2_1
X_165_ Tile_X0Y0_S4END[0] ISSUE_OPA_top0 Tile_X0Y0_S_XIF_left.Inst_S_XIF_left_ConfigMem.Inst_frame1_bit15.Q
+ Tile_X0Y0_S_XIF_left.Inst_S_XIF_left_switch_matrix.N4BEG15 VPWR VGND sg13g2_mux2_1
XFILLER_3_984 VPWR VGND sg13g2_decap_8
XFILLER_6_288 VPWR VGND sg13g2_fill_2
X_096_ Tile_X2Y0_SS4END[5] ISSUE_OPB_top21 Tile_X2Y0_S_XIF_right.Inst_S_XIF_right_ConfigMem.Inst_frame1_bit26.Q
+ Tile_X2Y0_S_XIF_right.Inst_S_XIF_right_switch_matrix.NN4BEG10 VPWR VGND sg13g2_mux2_1
XFILLER_1_21 VPWR VGND sg13g2_decap_8
XFILLER_1_76 VPWR VGND sg13g2_decap_8
XFILLER_0_1306 VPWR VGND sg13g2_decap_4
XFILLER_10_63 VPWR VGND sg13g2_decap_8
XFILLER_0_910 VPWR VGND sg13g2_decap_8
XFILLER_3_203 VPWR VGND sg13g2_decap_8
XFILLER_0_987 VPWR VGND sg13g2_decap_8
X_148_ _031_ Tile_X2Y0_S4END[15] Tile_X2Y0_S_XIF_right.Inst_S_XIF_right_ConfigMem.Inst_frame0_bit30.Q
+ VPWR VGND sg13g2_nand2b_1
X_217_ _054_ VPWR RESULT_top27 VGND Tile_X0Y0_S_XIF_left.Inst_S_XIF_left_ConfigMem.Inst_frame0_bit23.Q
+ _055_ sg13g2_o21ai_1
X_079_ Tile_X2Y0_S4END[6] ISSUE_OPB_top6 Tile_X2Y0_S_XIF_right.Inst_S_XIF_right_ConfigMem.Inst_frame1_bit9.Q
+ Tile_X2Y0_S_XIF_right.Inst_S_XIF_right_switch_matrix.N4BEG9 VPWR VGND sg13g2_mux2_1
XFILLER_3_781 VPWR VGND sg13g2_decap_8
XFILLER_0_217 VPWR VGND sg13g2_decap_8
XANTENNA_80 VPWR VGND Tile_X0Y0_FrameData[31] sg13g2_antennanp
XFILLER_8_306 VPWR VGND sg13g2_decap_8
XFILLER_4_512 VPWR VGND sg13g2_decap_8
XANTENNA_91 VPWR VGND ISSUE_OPA_top26 sg13g2_antennanp
XFILLER_0_751 VPWR VGND sg13g2_decap_8
X_697_ Tile_X2Y0_S1END[2] Tile_X2Y0_N1BEG[1] VPWR VGND sg13g2_buf_1
XFILLER_0_784 VPWR VGND sg13g2_decap_8
XFILLER_8_840 VPWR VGND sg13g2_decap_8
XFILLER_11_1019 VPWR VGND sg13g2_decap_8
XFILLER_7_42 VPWR VGND sg13g2_decap_8
XFILLER_2_1209 VPWR VGND sg13g2_decap_8
XFILLER_6_1301 VPWR VGND sg13g2_decap_8
XFILLER_1_515 VPWR VGND sg13g2_decap_4
X_620_ Tile_X1Y0_S_XIF_middle.Inst_S_XIF_middle_switch_matrix.N4BEG9 Tile_X1Y0_N4BEG[9]
+ VPWR VGND sg13g2_buf_1
X_551_ Tile_X0Y0_S_XIF_left.Inst_S_XIF_left_switch_matrix.N4BEG13 Tile_X0Y0_N4BEG[13]
+ VPWR VGND sg13g2_buf_1
XFILLER_9_659 VPWR VGND sg13g2_decap_4
X_482_ Tile_X0Y0_FrameData[29] Tile_X1Y0_FrameStrobe[0] Tile_X1Y0_S_XIF_middle.Inst_S_XIF_middle_ConfigMem.Inst_frame0_bit29.Q
+ VPWR VGND sg13g2_dlhq_1
XFILLER_8_158 VPWR VGND sg13g2_decap_8
XFILLER_8_147 VPWR VGND sg13g2_decap_8
XFILLER_5_810 VPWR VGND sg13g2_decap_8
XFILLER_5_887 VPWR VGND sg13g2_decap_8
XFILLER_1_1253 VPWR VGND sg13g2_decap_8
XFILLER_8_692 VPWR VGND sg13g2_decap_8
XFILLER_2_1039 VPWR VGND sg13g2_decap_8
XFILLER_6_1175 VPWR VGND sg13g2_decap_4
XFILLER_1_334 VPWR VGND sg13g2_decap_8
XFILLER_2_857 VPWR VGND sg13g2_decap_8
X_603_ Tile_X1Y0_S_XIF_middle.Inst_S_XIF_middle_switch_matrix.N2BEGb0 Tile_X1Y0_N2BEGb[0]
+ VPWR VGND sg13g2_buf_1
X_465_ Tile_X0Y0_FrameData[14] Tile_X0Y0_FrameStrobe[1] Tile_X0Y0_S_XIF_left.Inst_S_XIF_left_ConfigMem.Inst_frame1_bit14.Q
+ VPWR VGND sg13g2_dlhq_1
X_534_ Tile_X0Y0_S2END[3] Tile_X0Y0_N2BEGb[4] VPWR VGND sg13g2_buf_1
X_396_ Tile_X0Y0_FrameData[19] Tile_X2Y0_FrameStrobe[1] Tile_X2Y0_S_XIF_right.Inst_S_XIF_right_ConfigMem.Inst_frame1_bit19.Q
+ VPWR VGND sg13g2_dlhq_1
XFILLER_4_21 VPWR VGND sg13g2_decap_8
XFILLER_4_161 VPWR VGND sg13g2_fill_2
XFILLER_1_890 VPWR VGND sg13g2_decap_8
XFILLER_4_98 VPWR VGND sg13g2_decap_8
XFILLER_9_990 VPWR VGND sg13g2_decap_8
XFILLER_11_956 VPWR VGND sg13g2_decap_8
XFILLER_10_455 VPWR VGND sg13g2_decap_8
X_250_ Tile_X1Y0_S4END[15] ISSUE_INSTR_top15 Tile_X1Y0_S_XIF_middle.Inst_S_XIF_middle_ConfigMem.Inst_frame1_bit17.Q
+ Tile_X1Y0_S_XIF_middle.Inst_S_XIF_middle_switch_matrix.N4BEG0 VPWR VGND sg13g2_mux2_1
XFILLER_7_927 VPWR VGND sg13g2_decap_8
X_181_ Tile_X0Y0_SS4END[0] ISSUE_OPA_top16 Tile_X0Y0_S_XIF_left.Inst_S_XIF_left_ConfigMem.Inst_frame1_bit31.Q
+ Tile_X0Y0_S_XIF_left.Inst_S_XIF_left_switch_matrix.NN4BEG15 VPWR VGND sg13g2_mux2_1
XFILLER_2_610 VPWR VGND sg13g2_decap_8
X_517_ Tile_X0Y0_FrameStrobe[19] Tile_X0Y0_FrameStrobe_O[19] VPWR VGND sg13g2_buf_1
X_448_ Tile_X0Y0_FrameData[31] Tile_X0Y0_FrameStrobe[1] Tile_X0Y0_S_XIF_left.Inst_S_XIF_left_ConfigMem.Inst_frame1_bit31.Q
+ VPWR VGND sg13g2_dlhq_1
X_379_ Tile_X0Y0_FrameData[4] Tile_X2Y0_FrameStrobe[0] Tile_X2Y0_S_XIF_right.Inst_S_XIF_right_ConfigMem.Inst_frame0_bit4.Q
+ VPWR VGND sg13g2_dlhq_1
XFILLER_11_219 VPWR VGND sg13g2_decap_4
XFILLER_3_429 VPWR VGND sg13g2_decap_8
XFILLER_4_908 VPWR VGND sg13g2_decap_8
XFILLER_8_1001 VPWR VGND sg13g2_decap_8
X_302_ Tile_X0Y0_FrameData[14] Tile_X1Y0_FrameStrobe[0] Tile_X1Y0_S_XIF_middle.Inst_S_XIF_middle_ConfigMem.Inst_frame0_bit14.Q
+ VPWR VGND sg13g2_dlhq_1
X_164_ Tile_X0Y0_S4END[1] ISSUE_OPA_top1 Tile_X0Y0_S_XIF_left.Inst_S_XIF_left_ConfigMem.Inst_frame1_bit14.Q
+ Tile_X0Y0_S_XIF_left.Inst_S_XIF_left_switch_matrix.N4BEG14 VPWR VGND sg13g2_mux2_1
X_233_ Tile_X1Y0_S1END[0] ISSUE_VALID_top Tile_X1Y0_S_XIF_middle.Inst_S_XIF_middle_ConfigMem.Inst_frame1_bit0.Q
+ Tile_X1Y0_S_XIF_middle.Inst_S_XIF_middle_switch_matrix.N1BEG3 VPWR VGND sg13g2_mux2_1
X_095_ Tile_X2Y0_SS4END[6] ISSUE_OPB_top22 Tile_X2Y0_S_XIF_right.Inst_S_XIF_right_ConfigMem.Inst_frame1_bit25.Q
+ Tile_X2Y0_S_XIF_right.Inst_S_XIF_right_switch_matrix.NN4BEG9 VPWR VGND sg13g2_mux2_1
XFILLER_7_724 VPWR VGND sg13g2_fill_2
XFILLER_2_484 VPWR VGND sg13g2_decap_8
XFILLER_3_963 VPWR VGND sg13g2_decap_8
XFILLER_9_1310 VPWR VGND sg13g2_fill_2
XFILLER_4_716 VPWR VGND sg13g2_fill_1
XFILLER_10_42 VPWR VGND sg13g2_decap_8
XFILLER_0_966 VPWR VGND sg13g2_decap_8
XFILLER_3_259 VPWR VGND sg13g2_fill_2
XFILLER_11_561 VPWR VGND sg13g2_fill_1
X_147_ Tile_X2Y0_S_XIF_right.Inst_S_XIF_right_ConfigMem.Inst_frame0_bit30.Q VPWR _030_
+ VGND Tile_X2Y0_SS4END[15] Tile_X2Y0_S_XIF_right.Inst_S_XIF_right_ConfigMem.Inst_frame0_bit31.Q
+ sg13g2_o21ai_1
X_078_ Tile_X2Y0_S4END[7] ISSUE_OPB_top7 Tile_X2Y0_S_XIF_right.Inst_S_XIF_right_ConfigMem.Inst_frame1_bit8.Q
+ Tile_X2Y0_S_XIF_right.Inst_S_XIF_right_switch_matrix.N4BEG8 VPWR VGND sg13g2_mux2_1
X_216_ _055_ Tile_X0Y0_S4END[11] Tile_X0Y0_S_XIF_left.Inst_S_XIF_left_ConfigMem.Inst_frame0_bit22.Q
+ VPWR VGND sg13g2_nand2b_1
XFILLER_7_576 VPWR VGND sg13g2_fill_1
XFILLER_3_760 VPWR VGND sg13g2_decap_8
XFILLER_0_1148 VPWR VGND sg13g2_decap_4
XFILLER_4_1295 VPWR VGND sg13g2_decap_8
XFILLER_1_719 VPWR VGND sg13g2_decap_8
XFILLER_9_1195 VPWR VGND sg13g2_fill_2
XFILLER_9_1173 VPWR VGND sg13g2_fill_2
XFILLER_5_1048 VPWR VGND sg13g2_decap_4
XANTENNA_70 VPWR VGND Tile_X0Y0_FrameData[27] sg13g2_antennanp
XANTENNA_81 VPWR VGND Tile_X0Y0_FrameData[31] sg13g2_antennanp
XANTENNA_92 VPWR VGND Tile_X0Y0_FrameData[11] sg13g2_antennanp
XFILLER_0_730 VPWR VGND sg13g2_decap_8
X_696_ Tile_X2Y0_S1END[3] Tile_X2Y0_N1BEG[0] VPWR VGND sg13g2_buf_1
XFILLER_7_21 VPWR VGND sg13g2_decap_8
XFILLER_8_896 VPWR VGND sg13g2_decap_8
XFILLER_3_590 VPWR VGND sg13g2_decap_8
XFILLER_7_98 VPWR VGND sg13g2_decap_8
X_550_ Tile_X0Y0_S_XIF_left.Inst_S_XIF_left_switch_matrix.N4BEG12 Tile_X0Y0_N4BEG[12]
+ VPWR VGND sg13g2_buf_1
X_481_ Tile_X0Y0_FrameData[30] Tile_X1Y0_FrameStrobe[0] Tile_X1Y0_S_XIF_middle.Inst_S_XIF_middle_ConfigMem.Inst_frame0_bit30.Q
+ VPWR VGND sg13g2_dlhq_1
XFILLER_8_126 VPWR VGND sg13g2_decap_8
XFILLER_4_387 VPWR VGND sg13g2_decap_8
XFILLER_5_866 VPWR VGND sg13g2_decap_8
X_679_ Tile_X2Y0_FrameStrobe[3] Tile_X2Y0_FrameStrobe_O[3] VPWR VGND sg13g2_buf_1
X_748_ Tile_X2Y0_UserCLK Tile_X2Y0_UserCLKo VPWR VGND sg13g2_buf_1
XFILLER_1_1232 VPWR VGND sg13g2_decap_8
XFILLER_7_192 VPWR VGND sg13g2_decap_8
XFILLER_6_1121 VPWR VGND sg13g2_decap_8
XFILLER_2_1018 VPWR VGND sg13g2_decap_8
XFILLER_2_836 VPWR VGND sg13g2_decap_8
X_602_ Tile_X1Y0_S_XIF_middle.Inst_S_XIF_middle_switch_matrix.N2BEG7 Tile_X1Y0_N2BEG[7]
+ VPWR VGND sg13g2_buf_1
X_533_ Tile_X0Y0_S2END[4] Tile_X0Y0_N2BEGb[3] VPWR VGND sg13g2_buf_1
X_464_ Tile_X0Y0_FrameData[15] Tile_X0Y0_FrameStrobe[1] Tile_X0Y0_S_XIF_left.Inst_S_XIF_left_ConfigMem.Inst_frame1_bit15.Q
+ VPWR VGND sg13g2_dlhq_1
X_395_ Tile_X0Y0_FrameData[20] Tile_X2Y0_FrameStrobe[1] Tile_X2Y0_S_XIF_right.Inst_S_XIF_right_ConfigMem.Inst_frame1_bit20.Q
+ VPWR VGND sg13g2_dlhq_1
XFILLER_4_77 VPWR VGND sg13g2_decap_8
XFILLER_4_140 VPWR VGND sg13g2_decap_8
XFILLER_1_1095 VPWR VGND sg13g2_decap_8
XFILLER_11_935 VPWR VGND sg13g2_decap_8
X_180_ Tile_X0Y0_SS4END[1] ISSUE_OPA_top17 Tile_X0Y0_S_XIF_left.Inst_S_XIF_left_ConfigMem.Inst_frame1_bit30.Q
+ Tile_X0Y0_S_XIF_left.Inst_S_XIF_left_switch_matrix.NN4BEG14 VPWR VGND sg13g2_mux2_1
XFILLER_7_906 VPWR VGND sg13g2_decap_8
XFILLER_11_1192 VPWR VGND sg13g2_fill_2
XFILLER_1_132 VPWR VGND sg13g2_decap_4
XFILLER_2_666 VPWR VGND sg13g2_decap_8
XFILLER_2_677 VPWR VGND sg13g2_fill_2
X_516_ Tile_X0Y0_FrameStrobe[18] Tile_X0Y0_FrameStrobe_O[18] VPWR VGND sg13g2_buf_1
X_378_ Tile_X0Y0_FrameData[5] Tile_X2Y0_FrameStrobe[0] Tile_X2Y0_S_XIF_right.Inst_S_XIF_right_ConfigMem.Inst_frame0_bit5.Q
+ VPWR VGND sg13g2_dlhq_1
X_447_ Tile_X0Y0_FrameData[0] Tile_X0Y0_FrameStrobe[0] Tile_X0Y0_S_XIF_left.Inst_S_XIF_left_ConfigMem.Inst_frame0_bit0.Q
+ VPWR VGND sg13g2_dlhq_1
XFILLER_10_990 VPWR VGND sg13g2_decap_4
XFILLER_6_994 VPWR VGND sg13g2_decap_8
XFILLER_7_1293 VPWR VGND sg13g2_decap_8
XFILLER_3_408 VPWR VGND sg13g2_decap_8
X_232_ Tile_X1Y0_S1END[1] ISSUE_VALID_top Tile_X1Y0_S_XIF_middle.Inst_S_XIF_middle_ConfigMem.Inst_frame2_bit31.Q
+ Tile_X1Y0_S_XIF_middle.Inst_S_XIF_middle_switch_matrix.N1BEG2 VPWR VGND sg13g2_mux2_1
X_301_ Tile_X0Y0_FrameData[15] Tile_X1Y0_FrameStrobe[0] Tile_X1Y0_S_XIF_middle.Inst_S_XIF_middle_ConfigMem.Inst_frame0_bit15.Q
+ VPWR VGND sg13g2_dlhq_1
X_094_ Tile_X2Y0_SS4END[7] ISSUE_OPB_top23 Tile_X2Y0_S_XIF_right.Inst_S_XIF_right_ConfigMem.Inst_frame1_bit24.Q
+ Tile_X2Y0_S_XIF_right.Inst_S_XIF_right_switch_matrix.NN4BEG8 VPWR VGND sg13g2_mux2_1
X_163_ Tile_X0Y0_S4END[2] ISSUE_OPA_top2 Tile_X0Y0_S_XIF_left.Inst_S_XIF_left_ConfigMem.Inst_frame1_bit13.Q
+ Tile_X0Y0_S_XIF_left.Inst_S_XIF_left_switch_matrix.N4BEG13 VPWR VGND sg13g2_mux2_1
XFILLER_2_463 VPWR VGND sg13g2_decap_8
XFILLER_3_942 VPWR VGND sg13g2_decap_8
XFILLER_1_67 VPWR VGND sg13g2_decap_4
XFILLER_6_791 VPWR VGND sg13g2_decap_8
XFILLER_10_21 VPWR VGND sg13g2_decap_8
XFILLER_0_945 VPWR VGND sg13g2_decap_8
X_215_ Tile_X0Y0_S_XIF_left.Inst_S_XIF_left_ConfigMem.Inst_frame0_bit22.Q VPWR _054_
+ VGND Tile_X0Y0_SS4END[11] Tile_X0Y0_S_XIF_left.Inst_S_XIF_left_ConfigMem.Inst_frame0_bit23.Q
+ sg13g2_o21ai_1
X_146_ _028_ VPWR RESULT_top14 VGND Tile_X2Y0_S_XIF_right.Inst_S_XIF_right_ConfigMem.Inst_frame0_bit29.Q
+ _029_ sg13g2_o21ai_1
X_077_ Tile_X2Y0_S4END[8] ISSUE_OPB_top8 Tile_X2Y0_S_XIF_right.Inst_S_XIF_right_ConfigMem.Inst_frame1_bit7.Q
+ Tile_X2Y0_S_XIF_right.Inst_S_XIF_right_switch_matrix.N4BEG7 VPWR VGND sg13g2_mux2_1
XFILLER_0_1127 VPWR VGND sg13g2_decap_8
XFILLER_4_1274 VPWR VGND sg13g2_decap_8
XFILLER_5_1027 VPWR VGND sg13g2_decap_8
XANTENNA_60 VPWR VGND Tile_X0Y0_FrameData[26] sg13g2_antennanp
XANTENNA_71 VPWR VGND Tile_X0Y0_FrameData[27] sg13g2_antennanp
XFILLER_4_569 VPWR VGND sg13g2_decap_8
XANTENNA_82 VPWR VGND Tile_X0Y0_FrameData[31] sg13g2_antennanp
XANTENNA_93 VPWR VGND Tile_X0Y0_FrameData[11] sg13g2_antennanp
X_695_ Tile_X2Y0_FrameStrobe[19] Tile_X2Y0_FrameStrobe_O[19] VPWR VGND sg13g2_buf_1
XFILLER_8_875 VPWR VGND sg13g2_decap_8
XFILLER_7_77 VPWR VGND sg13g2_decap_8
X_129_ Tile_X2Y0_S_XIF_right.Inst_S_XIF_right_ConfigMem.Inst_frame0_bit18.Q VPWR _018_
+ VGND Tile_X2Y0_SS4END[9] Tile_X2Y0_S_XIF_right.Inst_S_XIF_right_ConfigMem.Inst_frame0_bit19.Q
+ sg13g2_o21ai_1
X_480_ Tile_X0Y0_FrameData[31] Tile_X1Y0_FrameStrobe[0] Tile_X1Y0_S_XIF_middle.Inst_S_XIF_middle_ConfigMem.Inst_frame0_bit31.Q
+ VPWR VGND sg13g2_dlhq_1
XFILLER_8_105 VPWR VGND sg13g2_decap_8
XFILLER_10_1098 VPWR VGND sg13g2_fill_2
XFILLER_4_366 VPWR VGND sg13g2_decap_8
XFILLER_5_845 VPWR VGND sg13g2_decap_8
X_747_ Tile_X2Y0_S_XIF_right.Inst_S_XIF_right_switch_matrix.NN4BEG15 Tile_X2Y0_NN4BEG[15]
+ VPWR VGND sg13g2_buf_1
XFILLER_0_583 VPWR VGND sg13g2_decap_8
XFILLER_1_1211 VPWR VGND sg13g2_decap_8
X_678_ Tile_X2Y0_FrameStrobe[2] Tile_X2Y0_FrameStrobe_O[2] VPWR VGND sg13g2_buf_1
XFILLER_1_1288 VPWR VGND sg13g2_decap_8
XFILLER_5_119 VPWR VGND sg13g2_decap_8
XFILLER_11_1330 VPWR VGND sg13g2_fill_2
XFILLER_1_303 VPWR VGND sg13g2_decap_8
XFILLER_2_815 VPWR VGND sg13g2_decap_8
X_601_ Tile_X1Y0_S_XIF_middle.Inst_S_XIF_middle_switch_matrix.N2BEG6 Tile_X1Y0_N2BEG[6]
+ VPWR VGND sg13g2_buf_1
XFILLER_1_369 VPWR VGND sg13g2_decap_8
X_463_ Tile_X0Y0_FrameData[16] Tile_X0Y0_FrameStrobe[1] Tile_X0Y0_S_XIF_left.Inst_S_XIF_left_ConfigMem.Inst_frame1_bit16.Q
+ VPWR VGND sg13g2_dlhq_1
X_532_ Tile_X0Y0_S2END[5] Tile_X0Y0_N2BEGb[2] VPWR VGND sg13g2_buf_1
X_394_ Tile_X0Y0_FrameData[21] Tile_X2Y0_FrameStrobe[1] Tile_X2Y0_S_XIF_right.Inst_S_XIF_right_ConfigMem.Inst_frame1_bit21.Q
+ VPWR VGND sg13g2_dlhq_1
XFILLER_0_380 VPWR VGND sg13g2_decap_8
XFILLER_4_56 VPWR VGND sg13g2_decap_8
XFILLER_4_163 VPWR VGND sg13g2_fill_1
XFILLER_4_196 VPWR VGND sg13g2_decap_8
XFILLER_1_1074 VPWR VGND sg13g2_decap_8
XFILLER_11_914 VPWR VGND sg13g2_decap_8
XFILLER_1_111 VPWR VGND sg13g2_decap_8
XFILLER_2_645 VPWR VGND sg13g2_decap_8
XFILLER_2_689 VPWR VGND sg13g2_fill_2
X_515_ Tile_X0Y0_FrameStrobe[17] Tile_X0Y0_FrameStrobe_O[17] VPWR VGND sg13g2_buf_1
X_377_ Tile_X0Y0_FrameData[6] Tile_X2Y0_FrameStrobe[0] Tile_X2Y0_S_XIF_right.Inst_S_XIF_right_ConfigMem.Inst_frame0_bit6.Q
+ VPWR VGND sg13g2_dlhq_1
X_446_ Tile_X0Y0_FrameData[1] Tile_X0Y0_FrameStrobe[0] Tile_X0Y0_S_XIF_left.Inst_S_XIF_left_ConfigMem.Inst_frame0_bit1.Q
+ VPWR VGND sg13g2_dlhq_1
XFILLER_5_494 VPWR VGND sg13g2_decap_8
XFILLER_6_973 VPWR VGND sg13g2_decap_8
XFILLER_3_1103 VPWR VGND sg13g2_fill_1
XFILLER_8_1047 VPWR VGND sg13g2_fill_2
XFILLER_8_1036 VPWR VGND sg13g2_decap_8
X_300_ Tile_X0Y0_FrameData[16] Tile_X1Y0_FrameStrobe[0] Tile_X1Y0_S_XIF_middle.Inst_S_XIF_middle_ConfigMem.Inst_frame0_bit16.Q
+ VPWR VGND sg13g2_dlhq_1
X_231_ Tile_X1Y0_S1END[2] ISSUE_VALID_top Tile_X1Y0_S_XIF_middle.Inst_S_XIF_middle_ConfigMem.Inst_frame2_bit30.Q
+ Tile_X1Y0_S_XIF_middle.Inst_S_XIF_middle_switch_matrix.N1BEG1 VPWR VGND sg13g2_mux2_1
X_162_ Tile_X0Y0_S4END[3] ISSUE_OPA_top3 Tile_X0Y0_S_XIF_left.Inst_S_XIF_left_ConfigMem.Inst_frame1_bit12.Q
+ Tile_X0Y0_S_XIF_left.Inst_S_XIF_left_switch_matrix.N4BEG12 VPWR VGND sg13g2_mux2_1
X_093_ Tile_X2Y0_SS4END[8] ISSUE_OPB_top24 Tile_X2Y0_S_XIF_right.Inst_S_XIF_right_ConfigMem.Inst_frame1_bit23.Q
+ Tile_X2Y0_S_XIF_right.Inst_S_XIF_right_switch_matrix.NN4BEG7 VPWR VGND sg13g2_mux2_1
XFILLER_3_921 VPWR VGND sg13g2_decap_8
XFILLER_6_0 VPWR VGND sg13g2_decap_8
XFILLER_6_214 VPWR VGND sg13g2_decap_8
XFILLER_7_726 VPWR VGND sg13g2_fill_1
XFILLER_1_35 VPWR VGND sg13g2_decap_8
XFILLER_2_442 VPWR VGND sg13g2_decap_8
XFILLER_3_998 VPWR VGND sg13g2_decap_8
X_429_ Tile_X0Y0_FrameData[18] Tile_X0Y0_FrameStrobe[0] Tile_X0Y0_S_XIF_left.Inst_S_XIF_left_ConfigMem.Inst_frame0_bit18.Q
+ VPWR VGND sg13g2_dlhq_1
XFILLER_7_1091 VPWR VGND sg13g2_decap_4
XFILLER_3_217 VPWR VGND sg13g2_fill_2
XFILLER_10_77 VPWR VGND sg13g2_decap_8
XFILLER_0_924 VPWR VGND sg13g2_decap_8
XFILLER_11_574 VPWR VGND sg13g2_decap_4
X_145_ _029_ Tile_X2Y0_S4END[14] Tile_X2Y0_S_XIF_right.Inst_S_XIF_right_ConfigMem.Inst_frame0_bit28.Q
+ VPWR VGND sg13g2_nand2b_1
X_214_ _052_ VPWR RESULT_top26 VGND Tile_X0Y0_S_XIF_left.Inst_S_XIF_left_ConfigMem.Inst_frame0_bit21.Q
+ _053_ sg13g2_o21ai_1
XFILLER_7_523 VPWR VGND sg13g2_decap_8
XFILLER_2_250 VPWR VGND sg13g2_decap_8
XFILLER_3_795 VPWR VGND sg13g2_decap_8
X_076_ Tile_X2Y0_S4END[9] ISSUE_OPB_top9 Tile_X2Y0_S_XIF_right.Inst_S_XIF_right_ConfigMem.Inst_frame1_bit6.Q
+ Tile_X2Y0_S_XIF_right.Inst_S_XIF_right_switch_matrix.N4BEG6 VPWR VGND sg13g2_mux2_1
XFILLER_0_1106 VPWR VGND sg13g2_decap_8
XFILLER_5_1006 VPWR VGND sg13g2_decap_8
XANTENNA_83 VPWR VGND Tile_X0Y0_FrameData[31] sg13g2_antennanp
XANTENNA_61 VPWR VGND Tile_X0Y0_FrameData[26] sg13g2_antennanp
XANTENNA_72 VPWR VGND Tile_X0Y0_FrameData[27] sg13g2_antennanp
XANTENNA_50 VPWR VGND Tile_X0Y0_FrameData[21] sg13g2_antennanp
XFILLER_4_526 VPWR VGND sg13g2_decap_8
XANTENNA_94 VPWR VGND Tile_X0Y0_FrameData[11] sg13g2_antennanp
X_694_ Tile_X2Y0_FrameStrobe[18] Tile_X2Y0_FrameStrobe_O[18] VPWR VGND sg13g2_buf_1
XFILLER_0_798 VPWR VGND sg13g2_decap_8
XFILLER_0_765 VPWR VGND sg13g2_decap_8
XFILLER_8_854 VPWR VGND sg13g2_decap_8
X_128_ _016_ VPWR RESULT_top8 VGND Tile_X2Y0_S_XIF_right.Inst_S_XIF_right_ConfigMem.Inst_frame0_bit17.Q
+ _017_ sg13g2_o21ai_1
XFILLER_7_56 VPWR VGND sg13g2_decap_8
XFILLER_6_1326 VPWR VGND sg13g2_decap_4
XFILLER_4_1083 VPWR VGND sg13g2_decap_4
XFILLER_10_809 VPWR VGND sg13g2_fill_1
XFILLER_5_824 VPWR VGND sg13g2_decap_8
XFILLER_0_562 VPWR VGND sg13g2_decap_8
X_677_ Tile_X2Y0_FrameStrobe[1] Tile_X2Y0_FrameStrobe_O[1] VPWR VGND sg13g2_buf_1
X_746_ Tile_X2Y0_S_XIF_right.Inst_S_XIF_right_switch_matrix.NN4BEG14 Tile_X2Y0_NN4BEG[14]
+ VPWR VGND sg13g2_buf_1
XFILLER_1_1267 VPWR VGND sg13g2_decap_8
XFILLER_8_662 VPWR VGND sg13g2_fill_1
XFILLER_7_150 VPWR VGND sg13g2_decap_8
XFILLER_7_172 VPWR VGND sg13g2_decap_4
XFILLER_1_348 VPWR VGND sg13g2_decap_8
X_600_ Tile_X1Y0_S_XIF_middle.Inst_S_XIF_middle_switch_matrix.N2BEG5 Tile_X1Y0_N2BEG[5]
+ VPWR VGND sg13g2_buf_1
X_531_ Tile_X0Y0_S2END[6] Tile_X0Y0_N2BEGb[1] VPWR VGND sg13g2_buf_1
XFILLER_9_459 VPWR VGND sg13g2_decap_8
X_462_ Tile_X0Y0_FrameData[17] Tile_X0Y0_FrameStrobe[1] Tile_X0Y0_S_XIF_left.Inst_S_XIF_left_ConfigMem.Inst_frame1_bit17.Q
+ VPWR VGND sg13g2_dlhq_1
X_393_ Tile_X0Y0_FrameData[22] Tile_X2Y0_FrameStrobe[1] Tile_X2Y0_S_XIF_right.Inst_S_XIF_right_ConfigMem.Inst_frame1_bit22.Q
+ VPWR VGND sg13g2_dlhq_1
XFILLER_4_175 VPWR VGND sg13g2_decap_8
XFILLER_1_871 VPWR VGND sg13g2_fill_1
XFILLER_1_860 VPWR VGND sg13g2_decap_8
XFILLER_4_35 VPWR VGND sg13g2_decap_8
XFILLER_1_1053 VPWR VGND sg13g2_decap_8
X_729_ Tile_X2Y0_S_XIF_right.Inst_S_XIF_right_switch_matrix.N4BEG13 Tile_X2Y0_N4BEG[13]
+ VPWR VGND sg13g2_buf_1
XFILLER_8_492 VPWR VGND sg13g2_decap_8
XFILLER_10_469 VPWR VGND sg13g2_fill_2
XFILLER_2_624 VPWR VGND sg13g2_decap_8
XFILLER_6_429 VPWR VGND sg13g2_decap_8
XFILLER_11_1194 VPWR VGND sg13g2_fill_1
XFILLER_1_156 VPWR VGND sg13g2_decap_8
XFILLER_1_167 VPWR VGND sg13g2_fill_2
XFILLER_1_189 VPWR VGND sg13g2_decap_8
X_514_ Tile_X0Y0_FrameStrobe[16] Tile_X0Y0_FrameStrobe_O[16] VPWR VGND sg13g2_buf_1
X_445_ Tile_X0Y0_FrameData[2] Tile_X0Y0_FrameStrobe[0] Tile_X0Y0_S_XIF_left.Inst_S_XIF_left_ConfigMem.Inst_frame0_bit2.Q
+ VPWR VGND sg13g2_dlhq_1
X_376_ Tile_X0Y0_FrameData[7] Tile_X2Y0_FrameStrobe[0] Tile_X2Y0_S_XIF_right.Inst_S_XIF_right_ConfigMem.Inst_frame0_bit7.Q
+ VPWR VGND sg13g2_dlhq_1
XFILLER_5_473 VPWR VGND sg13g2_decap_8
XFILLER_6_952 VPWR VGND sg13g2_decap_8
XFILLER_7_1251 VPWR VGND sg13g2_fill_1
XFILLER_8_1015 VPWR VGND sg13g2_decap_8
XFILLER_11_701 VPWR VGND sg13g2_decap_4
X_230_ Tile_X0Y0_S4END[15] ISSUE_OPA_top15 Tile_X0Y0_S_XIF_left.Inst_S_XIF_left_ConfigMem.Inst_frame1_bit0.Q
+ Tile_X0Y0_S_XIF_left.Inst_S_XIF_left_switch_matrix.N4BEG0 VPWR VGND sg13g2_mux2_1
X_161_ Tile_X0Y0_S4END[4] ISSUE_OPA_top4 Tile_X0Y0_S_XIF_left.Inst_S_XIF_left_ConfigMem.Inst_frame1_bit11.Q
+ Tile_X0Y0_S_XIF_left.Inst_S_XIF_left_switch_matrix.N4BEG11 VPWR VGND sg13g2_mux2_1
XFILLER_2_421 VPWR VGND sg13g2_decap_8
XFILLER_3_900 VPWR VGND sg13g2_decap_8
XFILLER_3_977 VPWR VGND sg13g2_decap_8
X_092_ Tile_X2Y0_SS4END[9] ISSUE_OPB_top25 Tile_X2Y0_S_XIF_right.Inst_S_XIF_right_ConfigMem.Inst_frame1_bit22.Q
+ Tile_X2Y0_S_XIF_right.Inst_S_XIF_right_switch_matrix.NN4BEG6 VPWR VGND sg13g2_mux2_1
XFILLER_1_14 VPWR VGND sg13g2_decap_8
XFILLER_2_498 VPWR VGND sg13g2_decap_8
X_428_ Tile_X0Y0_FrameData[19] Tile_X0Y0_FrameStrobe[0] Tile_X0Y0_S_XIF_left.Inst_S_XIF_left_ConfigMem.Inst_frame0_bit19.Q
+ VPWR VGND sg13g2_dlhq_1
X_359_ Tile_X0Y0_FrameData[24] Tile_X2Y0_FrameStrobe[0] Tile_X2Y0_S_XIF_right.Inst_S_XIF_right_ConfigMem.Inst_frame0_bit24.Q
+ VPWR VGND sg13g2_dlhq_1
XFILLER_10_56 VPWR VGND sg13g2_decap_8
XFILLER_0_903 VPWR VGND sg13g2_decap_8
X_144_ Tile_X2Y0_S_XIF_right.Inst_S_XIF_right_ConfigMem.Inst_frame0_bit28.Q VPWR _028_
+ VGND Tile_X2Y0_SS4END[14] Tile_X2Y0_S_XIF_right.Inst_S_XIF_right_ConfigMem.Inst_frame0_bit29.Q
+ sg13g2_o21ai_1
X_075_ Tile_X2Y0_S4END[10] ISSUE_OPB_top10 Tile_X2Y0_S_XIF_right.Inst_S_XIF_right_ConfigMem.Inst_frame1_bit5.Q
+ Tile_X2Y0_S_XIF_right.Inst_S_XIF_right_switch_matrix.N4BEG5 VPWR VGND sg13g2_mux2_1
X_213_ _053_ Tile_X0Y0_S4END[10] Tile_X0Y0_S_XIF_left.Inst_S_XIF_left_ConfigMem.Inst_frame0_bit20.Q
+ VPWR VGND sg13g2_nand2b_1
XFILLER_7_502 VPWR VGND sg13g2_decap_8
XFILLER_2_295 VPWR VGND sg13g2_decap_8
XFILLER_3_774 VPWR VGND sg13g2_decap_8
XFILLER_4_1232 VPWR VGND sg13g2_fill_1
XANTENNA_62 VPWR VGND Tile_X0Y0_FrameData[26] sg13g2_antennanp
XANTENNA_73 VPWR VGND Tile_X0Y0_FrameData[27] sg13g2_antennanp
XANTENNA_51 VPWR VGND Tile_X0Y0_FrameData[21] sg13g2_antennanp
XFILLER_4_505 VPWR VGND sg13g2_decap_8
XANTENNA_40 VPWR VGND Tile_X0Y0_FrameData[21] sg13g2_antennanp
XANTENNA_84 VPWR VGND Tile_X0Y0_FrameData[5] sg13g2_antennanp
XANTENNA_95 VPWR VGND Tile_X0Y0_FrameData[11] sg13g2_antennanp
XFILLER_10_1248 VPWR VGND sg13g2_fill_2
XFILLER_0_744 VPWR VGND sg13g2_decap_8
X_693_ Tile_X2Y0_FrameStrobe[17] Tile_X2Y0_FrameStrobe_O[17] VPWR VGND sg13g2_buf_1
XFILLER_8_811 VPWR VGND sg13g2_decap_4
XFILLER_8_833 VPWR VGND sg13g2_decap_8
X_127_ _017_ Tile_X2Y0_S4END[8] Tile_X2Y0_S_XIF_right.Inst_S_XIF_right_ConfigMem.Inst_frame0_bit16.Q
+ VPWR VGND sg13g2_nand2b_1
XFILLER_7_35 VPWR VGND sg13g2_decap_8
XFILLER_7_310 VPWR VGND sg13g2_fill_1
XFILLER_7_387 VPWR VGND sg13g2_decap_4
XFILLER_4_1062 VPWR VGND sg13g2_decap_8
XFILLER_1_519 VPWR VGND sg13g2_fill_2
XFILLER_1_508 VPWR VGND sg13g2_decap_8
XFILLER_5_803 VPWR VGND sg13g2_decap_8
XFILLER_0_541 VPWR VGND sg13g2_decap_8
X_676_ Tile_X2Y0_FrameStrobe[0] Tile_X2Y0_FrameStrobe_O[0] VPWR VGND sg13g2_buf_1
X_745_ Tile_X2Y0_S_XIF_right.Inst_S_XIF_right_switch_matrix.NN4BEG13 Tile_X2Y0_NN4BEG[13]
+ VPWR VGND sg13g2_buf_1
XFILLER_1_1246 VPWR VGND sg13g2_decap_8
XFILLER_11_180 VPWR VGND sg13g2_fill_1
XFILLER_7_140 VPWR VGND sg13g2_decap_4
XFILLER_4_880 VPWR VGND sg13g2_decap_8
X_461_ Tile_X0Y0_FrameData[18] Tile_X0Y0_FrameStrobe[1] Tile_X0Y0_S_XIF_left.Inst_S_XIF_left_ConfigMem.Inst_frame1_bit18.Q
+ VPWR VGND sg13g2_dlhq_1
X_530_ Tile_X0Y0_S2END[7] Tile_X0Y0_N2BEGb[0] VPWR VGND sg13g2_buf_1
X_392_ Tile_X0Y0_FrameData[23] Tile_X2Y0_FrameStrobe[1] Tile_X2Y0_S_XIF_right.Inst_S_XIF_right_ConfigMem.Inst_frame1_bit23.Q
+ VPWR VGND sg13g2_dlhq_1
XFILLER_4_14 VPWR VGND sg13g2_decap_8
XFILLER_4_154 VPWR VGND sg13g2_decap_8
XFILLER_1_883 VPWR VGND sg13g2_decap_8
X_728_ Tile_X2Y0_S_XIF_right.Inst_S_XIF_right_switch_matrix.N4BEG12 Tile_X2Y0_N4BEG[12]
+ VPWR VGND sg13g2_buf_1
XFILLER_1_1032 VPWR VGND sg13g2_decap_8
X_659_ Tile_X0Y0_FrameData[15] Tile_X2Y0_FrameData_O[15] VPWR VGND sg13g2_buf_1
XFILLER_9_983 VPWR VGND sg13g2_decap_8
XFILLER_8_471 VPWR VGND sg13g2_decap_8
XFILLER_11_949 VPWR VGND sg13g2_decap_8
XFILLER_11_1140 VPWR VGND sg13g2_decap_4
XFILLER_2_603 VPWR VGND sg13g2_decap_8
X_444_ Tile_X0Y0_FrameData[3] Tile_X0Y0_FrameStrobe[0] Tile_X0Y0_S_XIF_left.Inst_S_XIF_left_ConfigMem.Inst_frame0_bit3.Q
+ VPWR VGND sg13g2_dlhq_1
X_513_ Tile_X0Y0_FrameStrobe[15] Tile_X0Y0_FrameStrobe_O[15] VPWR VGND sg13g2_buf_1
XFILLER_2_1330 VPWR VGND sg13g2_fill_2
X_375_ Tile_X0Y0_FrameData[8] Tile_X2Y0_FrameStrobe[0] Tile_X2Y0_S_XIF_right.Inst_S_XIF_right_ConfigMem.Inst_frame0_bit8.Q
+ VPWR VGND sg13g2_dlhq_1
XFILLER_6_931 VPWR VGND sg13g2_decap_8
XFILLER_5_452 VPWR VGND sg13g2_decap_8
XFILLER_1_691 VPWR VGND sg13g2_decap_8
X_091_ Tile_X2Y0_SS4END[10] ISSUE_OPB_top26 Tile_X2Y0_S_XIF_right.Inst_S_XIF_right_ConfigMem.Inst_frame1_bit21.Q
+ Tile_X2Y0_S_XIF_right.Inst_S_XIF_right_switch_matrix.NN4BEG5 VPWR VGND sg13g2_mux2_1
X_160_ Tile_X0Y0_S4END[5] ISSUE_OPA_top5 Tile_X0Y0_S_XIF_left.Inst_S_XIF_left_ConfigMem.Inst_frame1_bit10.Q
+ Tile_X0Y0_S_XIF_left.Inst_S_XIF_left_switch_matrix.N4BEG10 VPWR VGND sg13g2_mux2_1
XFILLER_2_400 VPWR VGND sg13g2_decap_8
XFILLER_2_477 VPWR VGND sg13g2_decap_8
XFILLER_3_956 VPWR VGND sg13g2_decap_8
X_358_ Tile_X0Y0_FrameData[25] Tile_X2Y0_FrameStrobe[0] Tile_X2Y0_S_XIF_right.Inst_S_XIF_right_ConfigMem.Inst_frame0_bit25.Q
+ VPWR VGND sg13g2_dlhq_1
X_427_ Tile_X0Y0_FrameData[20] Tile_X0Y0_FrameStrobe[0] Tile_X0Y0_S_XIF_left.Inst_S_XIF_left_ConfigMem.Inst_frame0_bit20.Q
+ VPWR VGND sg13g2_dlhq_1
X_289_ _069_ Tile_X1Y0_S2MID[4] Tile_X1Y0_S_XIF_middle.Inst_S_XIF_middle_ConfigMem.Inst_frame0_bit21.Q
+ VPWR VGND sg13g2_nand2b_1
XFILLER_9_1303 VPWR VGND sg13g2_decap_8
XFILLER_7_1060 VPWR VGND sg13g2_fill_2
XFILLER_10_35 VPWR VGND sg13g2_decap_8
XFILLER_0_959 VPWR VGND sg13g2_decap_8
X_212_ Tile_X0Y0_S_XIF_left.Inst_S_XIF_left_ConfigMem.Inst_frame0_bit20.Q VPWR _052_
+ VGND Tile_X0Y0_SS4END[10] Tile_X0Y0_S_XIF_left.Inst_S_XIF_left_ConfigMem.Inst_frame0_bit21.Q
+ sg13g2_o21ai_1
X_143_ _026_ VPWR RESULT_top13 VGND Tile_X2Y0_S_XIF_right.Inst_S_XIF_right_ConfigMem.Inst_frame0_bit27.Q
+ _027_ sg13g2_o21ai_1
X_074_ Tile_X2Y0_S4END[11] ISSUE_OPB_top11 Tile_X2Y0_S_XIF_right.Inst_S_XIF_right_ConfigMem.Inst_frame1_bit4.Q
+ Tile_X2Y0_S_XIF_right.Inst_S_XIF_right_switch_matrix.N4BEG4 VPWR VGND sg13g2_mux2_1
XFILLER_3_753 VPWR VGND sg13g2_decap_8
XFILLER_4_1288 VPWR VGND sg13g2_decap_8
XFILLER_9_1122 VPWR VGND sg13g2_fill_2
XFILLER_2_91 VPWR VGND sg13g2_decap_8
XANTENNA_52 VPWR VGND Tile_X0Y0_FrameData[24] sg13g2_antennanp
XANTENNA_63 VPWR VGND Tile_X0Y0_FrameData[26] sg13g2_antennanp
XANTENNA_30 VPWR VGND ISSUE_OPA_top8 sg13g2_antennanp
XANTENNA_41 VPWR VGND Tile_X0Y0_FrameData[21] sg13g2_antennanp
XANTENNA_85 VPWR VGND Tile_X0Y0_FrameData[5] sg13g2_antennanp
XANTENNA_96 VPWR VGND Tile_X0Y0_FrameData[11] sg13g2_antennanp
XANTENNA_74 VPWR VGND Tile_X0Y0_FrameData[27] sg13g2_antennanp
XFILLER_0_723 VPWR VGND sg13g2_decap_8
X_692_ Tile_X2Y0_FrameStrobe[16] Tile_X2Y0_FrameStrobe_O[16] VPWR VGND sg13g2_buf_1
XFILLER_11_340 VPWR VGND sg13g2_fill_1
XFILLER_7_14 VPWR VGND sg13g2_decap_8
XFILLER_8_889 VPWR VGND sg13g2_decap_8
X_126_ Tile_X2Y0_S_XIF_right.Inst_S_XIF_right_ConfigMem.Inst_frame0_bit16.Q VPWR _016_
+ VGND Tile_X2Y0_SS4END[8] Tile_X2Y0_S_XIF_right.Inst_S_XIF_right_ConfigMem.Inst_frame0_bit17.Q
+ sg13g2_o21ai_1
XFILLER_3_583 VPWR VGND sg13g2_decap_8
XFILLER_4_1041 VPWR VGND sg13g2_decap_8
XFILLER_8_119 VPWR VGND sg13g2_decap_8
XFILLER_4_325 VPWR VGND sg13g2_fill_2
XFILLER_5_859 VPWR VGND sg13g2_decap_8
X_744_ Tile_X2Y0_S_XIF_right.Inst_S_XIF_right_switch_matrix.NN4BEG12 Tile_X2Y0_NN4BEG[12]
+ VPWR VGND sg13g2_buf_1
XFILLER_0_597 VPWR VGND sg13g2_decap_8
XFILLER_0_520 VPWR VGND sg13g2_decap_8
X_675_ Tile_X0Y0_FrameData[31] Tile_X2Y0_FrameData_O[31] VPWR VGND sg13g2_buf_1
XFILLER_1_1225 VPWR VGND sg13g2_decap_8
X_109_ _005_ Tile_X2Y0_S4END[2] Tile_X2Y0_S_XIF_right.Inst_S_XIF_right_ConfigMem.Inst_frame0_bit4.Q
+ VPWR VGND sg13g2_nand2b_1
XFILLER_3_380 VPWR VGND sg13g2_decap_8
XFILLER_7_185 VPWR VGND sg13g2_decap_8
XFILLER_6_1114 VPWR VGND sg13g2_decap_8
XFILLER_10_619 VPWR VGND sg13g2_fill_1
XFILLER_10_608 VPWR VGND sg13g2_fill_1
XFILLER_2_829 VPWR VGND sg13g2_decap_8
X_460_ Tile_X0Y0_FrameData[19] Tile_X0Y0_FrameStrobe[1] Tile_X0Y0_S_XIF_left.Inst_S_XIF_left_ConfigMem.Inst_frame1_bit19.Q
+ VPWR VGND sg13g2_dlhq_1
X_391_ Tile_X0Y0_FrameData[24] Tile_X2Y0_FrameStrobe[1] Tile_X2Y0_S_XIF_right.Inst_S_XIF_right_ConfigMem.Inst_frame1_bit24.Q
+ VPWR VGND sg13g2_dlhq_1
XFILLER_1_851 VPWR VGND sg13g2_decap_4
XFILLER_4_133 VPWR VGND sg13g2_decap_8
XFILLER_5_645 VPWR VGND sg13g2_decap_8
XFILLER_5_689 VPWR VGND sg13g2_fill_2
XFILLER_1_1011 VPWR VGND sg13g2_decap_8
XFILLER_0_394 VPWR VGND sg13g2_decap_8
X_727_ Tile_X2Y0_S_XIF_right.Inst_S_XIF_right_switch_matrix.N4BEG11 Tile_X2Y0_N4BEG[11]
+ VPWR VGND sg13g2_buf_1
XFILLER_1_1088 VPWR VGND sg13g2_decap_8
X_589_ Tile_X1Y0_FrameStrobe[18] Tile_X1Y0_FrameStrobe_O[18] VPWR VGND sg13g2_buf_1
X_658_ Tile_X0Y0_FrameData[14] Tile_X2Y0_FrameData_O[14] VPWR VGND sg13g2_buf_1
XFILLER_9_962 VPWR VGND sg13g2_decap_8
XFILLER_8_450 VPWR VGND sg13g2_decap_8
XFILLER_11_928 VPWR VGND sg13g2_decap_8
XFILLER_1_125 VPWR VGND sg13g2_decap_8
XFILLER_1_147 VPWR VGND sg13g2_decap_4
XFILLER_2_659 VPWR VGND sg13g2_decap_8
X_512_ Tile_X0Y0_FrameStrobe[14] Tile_X0Y0_FrameStrobe_O[14] VPWR VGND sg13g2_buf_1
X_443_ Tile_X0Y0_FrameData[4] Tile_X0Y0_FrameStrobe[0] Tile_X0Y0_S_XIF_left.Inst_S_XIF_left_ConfigMem.Inst_frame0_bit4.Q
+ VPWR VGND sg13g2_dlhq_1
X_374_ Tile_X0Y0_FrameData[9] Tile_X2Y0_FrameStrobe[0] Tile_X2Y0_S_XIF_right.Inst_S_XIF_right_ConfigMem.Inst_frame0_bit9.Q
+ VPWR VGND sg13g2_dlhq_1
XFILLER_10_983 VPWR VGND sg13g2_decap_8
XFILLER_5_431 VPWR VGND sg13g2_decap_8
XFILLER_6_910 VPWR VGND sg13g2_decap_8
XFILLER_6_987 VPWR VGND sg13g2_decap_8
XFILLER_7_1286 VPWR VGND sg13g2_decap_8
XFILLER_5_91 VPWR VGND sg13g2_decap_8
X_090_ Tile_X2Y0_SS4END[11] ISSUE_OPB_top27 Tile_X2Y0_S_XIF_right.Inst_S_XIF_right_ConfigMem.Inst_frame1_bit20.Q
+ Tile_X2Y0_S_XIF_right.Inst_S_XIF_right_switch_matrix.NN4BEG4 VPWR VGND sg13g2_mux2_1
XFILLER_6_228 VPWR VGND sg13g2_fill_2
XFILLER_2_456 VPWR VGND sg13g2_decap_8
XFILLER_3_935 VPWR VGND sg13g2_decap_8
XFILLER_1_49 VPWR VGND sg13g2_decap_8
XFILLER_2_1150 VPWR VGND sg13g2_fill_1
XANTENNA_120 VPWR VGND Tile_X0Y0_FrameData[9] sg13g2_antennanp
X_357_ Tile_X0Y0_FrameData[26] Tile_X2Y0_FrameStrobe[0] Tile_X2Y0_S_XIF_right.Inst_S_XIF_right_ConfigMem.Inst_frame0_bit26.Q
+ VPWR VGND sg13g2_dlhq_1
X_426_ Tile_X0Y0_FrameData[21] Tile_X0Y0_FrameStrobe[0] Tile_X0Y0_S_XIF_left.Inst_S_XIF_left_ConfigMem.Inst_frame0_bit21.Q
+ VPWR VGND sg13g2_dlhq_1
X_288_ Tile_X1Y0_S_XIF_middle.Inst_S_XIF_middle_ConfigMem.Inst_frame0_bit21.Q VPWR
+ _068_ VGND Tile_X1Y0_S2MID[5] Tile_X1Y0_S_XIF_middle.Inst_S_XIF_middle_ConfigMem.Inst_frame0_bit22.Q
+ sg13g2_o21ai_1
XFILLER_6_784 VPWR VGND sg13g2_decap_8
XFILLER_9_1326 VPWR VGND sg13g2_decap_4
XFILLER_2_990 VPWR VGND sg13g2_decap_8
XFILLER_10_14 VPWR VGND sg13g2_decap_8
XFILLER_0_938 VPWR VGND sg13g2_decap_8
XFILLER_11_544 VPWR VGND sg13g2_fill_1
X_142_ _027_ Tile_X2Y0_S4END[13] Tile_X2Y0_S_XIF_right.Inst_S_XIF_right_ConfigMem.Inst_frame0_bit26.Q
+ VPWR VGND sg13g2_nand2b_1
X_211_ _050_ VPWR RESULT_top25 VGND Tile_X0Y0_S_XIF_left.Inst_S_XIF_left_ConfigMem.Inst_frame0_bit19.Q
+ _051_ sg13g2_o21ai_1
X_073_ Tile_X2Y0_S4END[12] ISSUE_OPB_top12 Tile_X2Y0_S_XIF_right.Inst_S_XIF_right_ConfigMem.Inst_frame1_bit3.Q
+ Tile_X2Y0_S_XIF_right.Inst_S_XIF_right_switch_matrix.N4BEG3 VPWR VGND sg13g2_mux2_1
XFILLER_3_732 VPWR VGND sg13g2_decap_8
XFILLER_4_0 VPWR VGND sg13g2_decap_8
XFILLER_4_1267 VPWR VGND sg13g2_decap_8
X_409_ Tile_X0Y0_FrameData[6] Tile_X2Y0_FrameStrobe[1] Tile_X2Y0_S_XIF_right.Inst_S_XIF_right_ConfigMem.Inst_frame1_bit6.Q
+ VPWR VGND sg13g2_dlhq_1
XFILLER_9_1134 VPWR VGND sg13g2_fill_2
XFILLER_6_581 VPWR VGND sg13g2_decap_4
XFILLER_2_70 VPWR VGND sg13g2_decap_8
XANTENNA_31 VPWR VGND ISSUE_OPA_top9 sg13g2_antennanp
XANTENNA_20 VPWR VGND ISSUE_OPA_top27 sg13g2_antennanp
XANTENNA_64 VPWR VGND Tile_X0Y0_FrameData[26] sg13g2_antennanp
XANTENNA_75 VPWR VGND Tile_X0Y0_FrameData[27] sg13g2_antennanp
XANTENNA_53 VPWR VGND Tile_X0Y0_FrameData[24] sg13g2_antennanp
XANTENNA_86 VPWR VGND Tile_X0Y0_FrameData[5] sg13g2_antennanp
XANTENNA_42 VPWR VGND Tile_X0Y0_FrameData[21] sg13g2_antennanp
XANTENNA_97 VPWR VGND Tile_X0Y0_FrameData[11] sg13g2_antennanp
XFILLER_0_779 VPWR VGND sg13g2_fill_1
XFILLER_0_702 VPWR VGND sg13g2_decap_8
X_691_ Tile_X2Y0_FrameStrobe[15] Tile_X2Y0_FrameStrobe_O[15] VPWR VGND sg13g2_buf_1
XFILLER_8_868 VPWR VGND sg13g2_decap_8
X_125_ _014_ VPWR RESULT_top7 VGND Tile_X2Y0_S_XIF_right.Inst_S_XIF_right_ConfigMem.Inst_frame0_bit15.Q
+ _015_ sg13g2_o21ai_1
XFILLER_3_562 VPWR VGND sg13g2_decap_8
XFILLER_4_1020 VPWR VGND sg13g2_decap_8
XFILLER_4_359 VPWR VGND sg13g2_decap_8
XFILLER_5_838 VPWR VGND sg13g2_decap_8
X_743_ Tile_X2Y0_S_XIF_right.Inst_S_XIF_right_switch_matrix.NN4BEG11 Tile_X2Y0_NN4BEG[11]
+ VPWR VGND sg13g2_buf_1
X_674_ Tile_X0Y0_FrameData[30] Tile_X2Y0_FrameData_O[30] VPWR VGND sg13g2_buf_1
XFILLER_0_576 VPWR VGND sg13g2_decap_8
XFILLER_1_1204 VPWR VGND sg13g2_decap_8
X_108_ Tile_X2Y0_S_XIF_right.Inst_S_XIF_right_ConfigMem.Inst_frame0_bit4.Q VPWR _004_
+ VGND Tile_X2Y0_SS4END[2] Tile_X2Y0_S_XIF_right.Inst_S_XIF_right_ConfigMem.Inst_frame0_bit5.Q
+ sg13g2_o21ai_1
XFILLER_7_164 VPWR VGND sg13g2_decap_4
XFILLER_8_91 VPWR VGND sg13g2_decap_8
XFILLER_2_808 VPWR VGND sg13g2_decap_8
X_390_ Tile_X0Y0_FrameData[25] Tile_X2Y0_FrameStrobe[1] Tile_X2Y0_S_XIF_right.Inst_S_XIF_right_ConfigMem.Inst_frame1_bit25.Q
+ VPWR VGND sg13g2_dlhq_1
XFILLER_0_1292 VPWR VGND sg13g2_decap_8
XFILLER_4_112 VPWR VGND sg13g2_decap_8
XFILLER_0_373 VPWR VGND sg13g2_decap_8
XFILLER_4_49 VPWR VGND sg13g2_decap_8
XFILLER_4_189 VPWR VGND sg13g2_decap_8
X_726_ Tile_X2Y0_S_XIF_right.Inst_S_XIF_right_switch_matrix.N4BEG10 Tile_X2Y0_N4BEG[10]
+ VPWR VGND sg13g2_buf_1
XFILLER_1_1067 VPWR VGND sg13g2_decap_8
X_657_ Tile_X0Y0_FrameData[13] Tile_X2Y0_FrameData_O[13] VPWR VGND sg13g2_buf_1
XFILLER_9_941 VPWR VGND sg13g2_decap_8
X_588_ Tile_X1Y0_FrameStrobe[17] Tile_X1Y0_FrameStrobe_O[17] VPWR VGND sg13g2_buf_1
XFILLER_11_907 VPWR VGND sg13g2_decap_8
XFILLER_8_7 VPWR VGND sg13g2_decap_8
XFILLER_1_104 VPWR VGND sg13g2_decap_8
XFILLER_2_638 VPWR VGND sg13g2_decap_8
X_511_ Tile_X0Y0_FrameStrobe[13] Tile_X0Y0_FrameStrobe_O[13] VPWR VGND sg13g2_buf_1
X_442_ Tile_X0Y0_FrameData[5] Tile_X0Y0_FrameStrobe[0] Tile_X0Y0_S_XIF_left.Inst_S_XIF_left_ConfigMem.Inst_frame0_bit5.Q
+ VPWR VGND sg13g2_dlhq_1
X_373_ Tile_X0Y0_FrameData[10] Tile_X2Y0_FrameStrobe[0] Tile_X2Y0_S_XIF_right.Inst_S_XIF_right_ConfigMem.Inst_frame0_bit10.Q
+ VPWR VGND sg13g2_dlhq_1
XFILLER_10_962 VPWR VGND sg13g2_decap_8
XFILLER_5_487 VPWR VGND sg13g2_decap_8
XFILLER_6_966 VPWR VGND sg13g2_decap_8
X_709_ Tile_X2Y0_S2END[6] Tile_X2Y0_N2BEGb[1] VPWR VGND sg13g2_buf_1
XFILLER_9_760 VPWR VGND sg13g2_fill_1
XFILLER_8_1029 VPWR VGND sg13g2_decap_8
XFILLER_5_70 VPWR VGND sg13g2_decap_8
XFILLER_11_737 VPWR VGND sg13g2_fill_2
XFILLER_3_914 VPWR VGND sg13g2_decap_8
XFILLER_1_28 VPWR VGND sg13g2_decap_8
XFILLER_2_435 VPWR VGND sg13g2_decap_8
XANTENNA_110 VPWR VGND Tile_X0Y0_FrameData[3] sg13g2_antennanp
XANTENNA_121 VPWR VGND Tile_X0Y0_FrameData[9] sg13g2_antennanp
X_356_ Tile_X0Y0_FrameData[27] Tile_X2Y0_FrameStrobe[0] Tile_X2Y0_S_XIF_right.Inst_S_XIF_right_ConfigMem.Inst_frame0_bit27.Q
+ VPWR VGND sg13g2_dlhq_1
X_425_ Tile_X0Y0_FrameData[22] Tile_X0Y0_FrameStrobe[0] Tile_X0Y0_S_XIF_left.Inst_S_XIF_left_ConfigMem.Inst_frame0_bit22.Q
+ VPWR VGND sg13g2_dlhq_1
X_287_ _066_ VPWR ISSUE_ACCEPT_top VGND Tile_X1Y0_S_XIF_middle.Inst_S_XIF_middle_ConfigMem.Inst_frame0_bit20.Q
+ _067_ sg13g2_o21ai_1
XFILLER_7_1095 VPWR VGND sg13g2_fill_2
XFILLER_7_1084 VPWR VGND sg13g2_decap_8
XFILLER_7_1062 VPWR VGND sg13g2_fill_1
XFILLER_0_917 VPWR VGND sg13g2_decap_8
XFILLER_11_578 VPWR VGND sg13g2_fill_2
X_141_ Tile_X2Y0_S_XIF_right.Inst_S_XIF_right_ConfigMem.Inst_frame0_bit26.Q VPWR _026_
+ VGND Tile_X2Y0_SS4END[13] Tile_X2Y0_S_XIF_right.Inst_S_XIF_right_ConfigMem.Inst_frame0_bit27.Q
+ sg13g2_o21ai_1
X_210_ _051_ Tile_X0Y0_S4END[9] Tile_X0Y0_S_XIF_left.Inst_S_XIF_left_ConfigMem.Inst_frame0_bit18.Q
+ VPWR VGND sg13g2_nand2b_1
XFILLER_7_516 VPWR VGND sg13g2_decap_8
X_072_ Tile_X2Y0_S4END[13] ISSUE_OPB_top13 Tile_X2Y0_S_XIF_right.Inst_S_XIF_right_ConfigMem.Inst_frame1_bit2.Q
+ Tile_X2Y0_S_XIF_right.Inst_S_XIF_right_switch_matrix.N4BEG2 VPWR VGND sg13g2_mux2_1
XFILLER_2_210 VPWR VGND sg13g2_decap_8
XFILLER_3_788 VPWR VGND sg13g2_decap_8
X_408_ Tile_X0Y0_FrameData[7] Tile_X2Y0_FrameStrobe[1] Tile_X2Y0_S_XIF_right.Inst_S_XIF_right_ConfigMem.Inst_frame1_bit7.Q
+ VPWR VGND sg13g2_dlhq_1
X_339_ Tile_X0Y0_FrameData[9] Tile_X1Y0_FrameStrobe[1] Tile_X1Y0_S_XIF_middle.Inst_S_XIF_middle_ConfigMem.Inst_frame1_bit9.Q
+ VPWR VGND sg13g2_dlhq_1
XFILLER_9_1102 VPWR VGND sg13g2_fill_2
XANTENNA_21 VPWR VGND ISSUE_OPA_top28 sg13g2_antennanp
XANTENNA_10 VPWR VGND ISSUE_OPA_top17 sg13g2_antennanp
XANTENNA_54 VPWR VGND Tile_X0Y0_FrameData[24] sg13g2_antennanp
XANTENNA_65 VPWR VGND Tile_X0Y0_FrameData[26] sg13g2_antennanp
XANTENNA_32 VPWR VGND Tile_X0Y0_FrameData[1] sg13g2_antennanp
XANTENNA_43 VPWR VGND Tile_X0Y0_FrameData[21] sg13g2_antennanp
XANTENNA_76 VPWR VGND Tile_X0Y0_FrameData[31] sg13g2_antennanp
XFILLER_4_519 VPWR VGND sg13g2_decap_8
XANTENNA_87 VPWR VGND Tile_X0Y0_FrameData[5] sg13g2_antennanp
XANTENNA_98 VPWR VGND Tile_X0Y0_FrameData[11] sg13g2_antennanp
X_690_ Tile_X2Y0_FrameStrobe[14] Tile_X2Y0_FrameStrobe_O[14] VPWR VGND sg13g2_buf_1
XFILLER_0_758 VPWR VGND sg13g2_decap_8
XFILLER_8_847 VPWR VGND sg13g2_decap_8
X_124_ _015_ Tile_X2Y0_S4END[7] Tile_X2Y0_S_XIF_right.Inst_S_XIF_right_ConfigMem.Inst_frame0_bit14.Q
+ VPWR VGND sg13g2_nand2b_1
XFILLER_7_49 VPWR VGND sg13g2_decap_8
XFILLER_7_346 VPWR VGND sg13g2_fill_2
XFILLER_11_91 VPWR VGND sg13g2_decap_8
XFILLER_3_541 VPWR VGND sg13g2_decap_8
XFILLER_6_1308 VPWR VGND sg13g2_fill_2
XFILLER_6_1319 VPWR VGND sg13g2_decap_8
XFILLER_4_1076 VPWR VGND sg13g2_decap_8
XFILLER_5_817 VPWR VGND sg13g2_decap_8
XFILLER_0_555 VPWR VGND sg13g2_decap_8
X_742_ Tile_X2Y0_S_XIF_right.Inst_S_XIF_right_switch_matrix.NN4BEG10 Tile_X2Y0_NN4BEG[10]
+ VPWR VGND sg13g2_buf_1
X_673_ Tile_X0Y0_FrameData[29] Tile_X2Y0_FrameData_O[29] VPWR VGND sg13g2_buf_1
XFILLER_5_1330 VPWR VGND sg13g2_fill_2
X_107_ _002_ VPWR RESULT_top1 VGND Tile_X2Y0_S_XIF_right.Inst_S_XIF_right_ConfigMem.Inst_frame0_bit3.Q
+ _003_ sg13g2_o21ai_1
XFILLER_8_655 VPWR VGND sg13g2_decap_8
XFILLER_7_176 VPWR VGND sg13g2_fill_1
XFILLER_4_894 VPWR VGND sg13g2_decap_8
XFILLER_8_70 VPWR VGND sg13g2_decap_8
XFILLER_0_1271 VPWR VGND sg13g2_decap_8
XFILLER_1_897 VPWR VGND sg13g2_decap_8
XFILLER_0_352 VPWR VGND sg13g2_decap_8
XFILLER_4_28 VPWR VGND sg13g2_decap_8
XFILLER_4_168 VPWR VGND sg13g2_decap_8
XFILLER_1_1046 VPWR VGND sg13g2_decap_8
X_587_ Tile_X1Y0_FrameStrobe[16] Tile_X1Y0_FrameStrobe_O[16] VPWR VGND sg13g2_buf_1
X_656_ Tile_X0Y0_FrameData[12] Tile_X2Y0_FrameData_O[12] VPWR VGND sg13g2_buf_1
X_725_ Tile_X2Y0_S_XIF_right.Inst_S_XIF_right_switch_matrix.N4BEG9 Tile_X2Y0_N4BEG[9]
+ VPWR VGND sg13g2_buf_1
XFILLER_5_1182 VPWR VGND sg13g2_fill_2
XFILLER_9_997 VPWR VGND sg13g2_decap_4
XFILLER_9_920 VPWR VGND sg13g2_decap_8
XFILLER_8_485 VPWR VGND sg13g2_decap_8
XFILLER_11_1165 VPWR VGND sg13g2_decap_8
XFILLER_2_617 VPWR VGND sg13g2_decap_8
X_441_ Tile_X0Y0_FrameData[6] Tile_X0Y0_FrameStrobe[0] Tile_X0Y0_S_XIF_left.Inst_S_XIF_left_ConfigMem.Inst_frame0_bit6.Q
+ VPWR VGND sg13g2_dlhq_1
X_510_ Tile_X0Y0_FrameStrobe[12] Tile_X0Y0_FrameStrobe_O[12] VPWR VGND sg13g2_buf_1
XFILLER_2_1300 VPWR VGND sg13g2_decap_8
XFILLER_10_941 VPWR VGND sg13g2_decap_8
X_372_ Tile_X0Y0_FrameData[11] Tile_X2Y0_FrameStrobe[0] Tile_X2Y0_S_XIF_right.Inst_S_XIF_right_ConfigMem.Inst_frame0_bit11.Q
+ VPWR VGND sg13g2_dlhq_1
XFILLER_5_466 VPWR VGND sg13g2_decap_8
XFILLER_6_945 VPWR VGND sg13g2_decap_8
XFILLER_1_672 VPWR VGND sg13g2_decap_8
XFILLER_0_182 VPWR VGND sg13g2_decap_8
X_708_ Tile_X2Y0_S2END[7] Tile_X2Y0_N2BEGb[0] VPWR VGND sg13g2_buf_1
X_639_ Tile_X1Y0_S_XIF_middle.Inst_S_XIF_middle_switch_matrix.NN4BEG12 Tile_X1Y0_NN4BEG[12]
+ VPWR VGND sg13g2_buf_1
XFILLER_8_1008 VPWR VGND sg13g2_decap_8
XFILLER_11_705 VPWR VGND sg13g2_fill_2
XFILLER_2_414 VPWR VGND sg13g2_decap_8
XANTENNA_111 VPWR VGND Tile_X0Y0_FrameData[3] sg13g2_antennanp
XANTENNA_100 VPWR VGND Tile_X0Y0_FrameData[14] sg13g2_antennanp
XANTENNA_122 VPWR VGND Tile_X0Y0_FrameData[13] sg13g2_antennanp
X_424_ Tile_X0Y0_FrameData[23] Tile_X0Y0_FrameStrobe[0] Tile_X0Y0_S_XIF_left.Inst_S_XIF_left_ConfigMem.Inst_frame0_bit23.Q
+ VPWR VGND sg13g2_dlhq_1
X_355_ Tile_X0Y0_FrameData[28] Tile_X2Y0_FrameStrobe[0] Tile_X2Y0_S_XIF_right.Inst_S_XIF_right_ConfigMem.Inst_frame0_bit28.Q
+ VPWR VGND sg13g2_dlhq_1
XFILLER_10_771 VPWR VGND sg13g2_fill_1
X_286_ _067_ Tile_X1Y0_S2MID[2] Tile_X1Y0_S_XIF_middle.Inst_S_XIF_middle_ConfigMem.Inst_frame0_bit19.Q
+ VPWR VGND sg13g2_nand2b_1
XFILLER_5_274 VPWR VGND sg13g2_fill_2
XFILLER_7_1041 VPWR VGND sg13g2_fill_1
XFILLER_10_49 VPWR VGND sg13g2_decap_8
X_140_ _024_ VPWR RESULT_top12 VGND Tile_X2Y0_S_XIF_right.Inst_S_XIF_right_ConfigMem.Inst_frame0_bit25.Q
+ _025_ sg13g2_o21ai_1
X_071_ Tile_X2Y0_S4END[14] ISSUE_OPB_top14 Tile_X2Y0_S_XIF_right.Inst_S_XIF_right_ConfigMem.Inst_frame1_bit1.Q
+ Tile_X2Y0_S_XIF_right.Inst_S_XIF_right_switch_matrix.N4BEG1 VPWR VGND sg13g2_mux2_1
XFILLER_2_288 VPWR VGND sg13g2_decap_8
XFILLER_3_767 VPWR VGND sg13g2_decap_8
X_338_ Tile_X0Y0_FrameData[10] Tile_X1Y0_FrameStrobe[1] Tile_X1Y0_S_XIF_middle.Inst_S_XIF_middle_ConfigMem.Inst_frame1_bit10.Q
+ VPWR VGND sg13g2_dlhq_1
X_407_ Tile_X0Y0_FrameData[8] Tile_X2Y0_FrameStrobe[1] Tile_X2Y0_S_XIF_right.Inst_S_XIF_right_ConfigMem.Inst_frame1_bit8.Q
+ VPWR VGND sg13g2_dlhq_1
X_269_ Tile_X1Y0_SS4END[12] ISSUE_INSTR_top28 Tile_X1Y0_S_XIF_middle.Inst_S_XIF_middle_ConfigMem.Inst_frame0_bit4.Q
+ Tile_X1Y0_S_XIF_middle.Inst_S_XIF_middle_switch_matrix.NN4BEG3 VPWR VGND sg13g2_mux2_1
XANTENNA_66 VPWR VGND Tile_X0Y0_FrameData[26] sg13g2_antennanp
XANTENNA_55 VPWR VGND Tile_X0Y0_FrameData[24] sg13g2_antennanp
XANTENNA_99 VPWR VGND Tile_X0Y0_FrameData[14] sg13g2_antennanp
XANTENNA_77 VPWR VGND Tile_X0Y0_FrameData[31] sg13g2_antennanp
XANTENNA_44 VPWR VGND Tile_X0Y0_FrameData[21] sg13g2_antennanp
XANTENNA_88 VPWR VGND Tile_X0Y0_FrameData[5] sg13g2_antennanp
XANTENNA_11 VPWR VGND ISSUE_OPA_top18 sg13g2_antennanp
XANTENNA_33 VPWR VGND Tile_X0Y0_FrameData[1] sg13g2_antennanp
XANTENNA_22 VPWR VGND ISSUE_OPA_top29 sg13g2_antennanp
XFILLER_0_737 VPWR VGND sg13g2_decap_8
XFILLER_3_1291 VPWR VGND sg13g2_decap_8
XFILLER_8_815 VPWR VGND sg13g2_fill_1
XFILLER_3_520 VPWR VGND sg13g2_decap_8
X_123_ Tile_X2Y0_S_XIF_right.Inst_S_XIF_right_ConfigMem.Inst_frame0_bit14.Q VPWR _014_
+ VGND Tile_X2Y0_SS4END[7] Tile_X2Y0_S_XIF_right.Inst_S_XIF_right_ConfigMem.Inst_frame0_bit15.Q
+ sg13g2_o21ai_1
XFILLER_7_28 VPWR VGND sg13g2_decap_8
XFILLER_11_70 VPWR VGND sg13g2_decap_8
XFILLER_3_597 VPWR VGND sg13g2_decap_8
XFILLER_4_1055 VPWR VGND sg13g2_decap_8
XFILLER_7_892 VPWR VGND sg13g2_decap_8
XFILLER_0_534 VPWR VGND sg13g2_decap_8
X_672_ Tile_X0Y0_FrameData[28] Tile_X2Y0_FrameData_O[28] VPWR VGND sg13g2_buf_1
X_741_ Tile_X2Y0_S_XIF_right.Inst_S_XIF_right_switch_matrix.NN4BEG9 Tile_X2Y0_NN4BEG[9]
+ VPWR VGND sg13g2_buf_1
XFILLER_1_1239 VPWR VGND sg13g2_decap_8
XFILLER_11_173 VPWR VGND sg13g2_decap_8
X_106_ _003_ Tile_X2Y0_S4END[1] Tile_X2Y0_S_XIF_right.Inst_S_XIF_right_ConfigMem.Inst_frame0_bit2.Q
+ VPWR VGND sg13g2_nand2b_1
XFILLER_4_873 VPWR VGND sg13g2_decap_8
XFILLER_7_133 VPWR VGND sg13g2_decap_8
XFILLER_7_144 VPWR VGND sg13g2_fill_2
XFILLER_7_199 VPWR VGND sg13g2_decap_8
XFILLER_3_394 VPWR VGND sg13g2_decap_8
XFILLER_0_1250 VPWR VGND sg13g2_decap_8
XFILLER_4_147 VPWR VGND sg13g2_decap_8
X_724_ Tile_X2Y0_S_XIF_right.Inst_S_XIF_right_switch_matrix.N4BEG8 Tile_X2Y0_N4BEG[8]
+ VPWR VGND sg13g2_buf_1
XFILLER_1_876 VPWR VGND sg13g2_decap_8
XFILLER_0_331 VPWR VGND sg13g2_decap_8
XFILLER_1_1025 VPWR VGND sg13g2_decap_8
X_586_ Tile_X1Y0_FrameStrobe[15] Tile_X1Y0_FrameStrobe_O[15] VPWR VGND sg13g2_buf_1
X_655_ Tile_X0Y0_FrameData[11] Tile_X2Y0_FrameData_O[11] VPWR VGND sg13g2_buf_1
XFILLER_9_976 VPWR VGND sg13g2_decap_8
XFILLER_8_464 VPWR VGND sg13g2_decap_8
XFILLER_11_1144 VPWR VGND sg13g2_fill_1
XFILLER_11_1133 VPWR VGND sg13g2_decap_8
X_440_ Tile_X0Y0_FrameData[7] Tile_X0Y0_FrameStrobe[0] Tile_X0Y0_S_XIF_left.Inst_S_XIF_left_ConfigMem.Inst_frame0_bit7.Q
+ VPWR VGND sg13g2_dlhq_1
XFILLER_2_1323 VPWR VGND sg13g2_decap_8
X_371_ Tile_X0Y0_FrameData[12] Tile_X2Y0_FrameStrobe[0] Tile_X2Y0_S_XIF_right.Inst_S_XIF_right_ConfigMem.Inst_frame0_bit12.Q
+ VPWR VGND sg13g2_dlhq_1
XFILLER_10_920 VPWR VGND sg13g2_decap_8
XFILLER_5_412 VPWR VGND sg13g2_fill_2
XFILLER_6_924 VPWR VGND sg13g2_decap_8
XFILLER_1_651 VPWR VGND sg13g2_decap_8
XFILLER_5_445 VPWR VGND sg13g2_decap_8
X_707_ Tile_X2Y0_S2MID[0] Tile_X2Y0_N2BEG[7] VPWR VGND sg13g2_buf_1
XFILLER_1_684 VPWR VGND sg13g2_decap_8
XFILLER_0_161 VPWR VGND sg13g2_decap_8
XFILLER_3_1109 VPWR VGND sg13g2_fill_2
X_569_ Tile_X0Y0_S_XIF_left.Inst_S_XIF_left_switch_matrix.NN4BEG15 Tile_X0Y0_NN4BEG[15]
+ VPWR VGND sg13g2_buf_1
X_638_ Tile_X1Y0_S_XIF_middle.Inst_S_XIF_middle_switch_matrix.NN4BEG11 Tile_X1Y0_NN4BEG[11]
+ VPWR VGND sg13g2_buf_1
XFILLER_8_294 VPWR VGND sg13g2_fill_2
XFILLER_11_739 VPWR VGND sg13g2_fill_1
XFILLER_3_949 VPWR VGND sg13g2_decap_8
X_423_ Tile_X0Y0_FrameData[24] Tile_X0Y0_FrameStrobe[0] Tile_X0Y0_S_XIF_left.Inst_S_XIF_left_ConfigMem.Inst_frame0_bit24.Q
+ VPWR VGND sg13g2_dlhq_1
X_354_ Tile_X0Y0_FrameData[29] Tile_X2Y0_FrameStrobe[0] Tile_X2Y0_S_XIF_right.Inst_S_XIF_right_ConfigMem.Inst_frame0_bit29.Q
+ VPWR VGND sg13g2_dlhq_1
XANTENNA_112 VPWR VGND Tile_X0Y0_FrameData[3] sg13g2_antennanp
XFILLER_2_1186 VPWR VGND sg13g2_fill_2
XANTENNA_123 VPWR VGND Tile_X0Y0_FrameData[13] sg13g2_antennanp
XANTENNA_101 VPWR VGND Tile_X0Y0_FrameData[14] sg13g2_antennanp
X_285_ Tile_X1Y0_S_XIF_middle.Inst_S_XIF_middle_ConfigMem.Inst_frame0_bit19.Q VPWR
+ _066_ VGND Tile_X1Y0_S2MID[3] Tile_X1Y0_S_XIF_middle.Inst_S_XIF_middle_ConfigMem.Inst_frame0_bit20.Q
+ sg13g2_o21ai_1
XFILLER_6_743 VPWR VGND sg13g2_fill_1
XFILLER_7_1053 VPWR VGND sg13g2_decap_8
XFILLER_1_492 VPWR VGND sg13g2_decap_8
XFILLER_1_481 VPWR VGND sg13g2_decap_8
XFILLER_6_798 VPWR VGND sg13g2_decap_8
XFILLER_10_28 VPWR VGND sg13g2_decap_8
X_070_ Tile_X1Y0_S1END[3] ISSUE_VALID_top Tile_X1Y0_S_XIF_middle.Inst_S_XIF_middle_ConfigMem.Inst_frame2_bit29.Q
+ Tile_X1Y0_S_XIF_middle.Inst_S_XIF_middle_switch_matrix.N1BEG0 VPWR VGND sg13g2_mux2_1
XFILLER_3_746 VPWR VGND sg13g2_decap_8
X_406_ Tile_X0Y0_FrameData[9] Tile_X2Y0_FrameStrobe[1] Tile_X2Y0_S_XIF_right.Inst_S_XIF_right_ConfigMem.Inst_frame1_bit9.Q
+ VPWR VGND sg13g2_dlhq_1
X_337_ Tile_X0Y0_FrameData[11] Tile_X1Y0_FrameStrobe[1] Tile_X1Y0_S_XIF_middle.Inst_S_XIF_middle_ConfigMem.Inst_frame1_bit11.Q
+ VPWR VGND sg13g2_dlhq_1
X_268_ Tile_X1Y0_SS4END[13] ISSUE_INSTR_top29 Tile_X1Y0_S_XIF_middle.Inst_S_XIF_middle_ConfigMem.Inst_frame0_bit3.Q
+ Tile_X1Y0_S_XIF_middle.Inst_S_XIF_middle_switch_matrix.NN4BEG2 VPWR VGND sg13g2_mux2_1
XFILLER_9_1104 VPWR VGND sg13g2_fill_1
X_199_ _042_ VPWR RESULT_top21 VGND Tile_X0Y0_S_XIF_left.Inst_S_XIF_left_ConfigMem.Inst_frame0_bit11.Q
+ _043_ sg13g2_o21ai_1
XFILLER_2_84 VPWR VGND sg13g2_decap_8
XANTENNA_78 VPWR VGND Tile_X0Y0_FrameData[31] sg13g2_antennanp
XANTENNA_56 VPWR VGND Tile_X0Y0_FrameData[24] sg13g2_antennanp
XANTENNA_67 VPWR VGND Tile_X0Y0_FrameData[27] sg13g2_antennanp
XANTENNA_23 VPWR VGND ISSUE_OPA_top3 sg13g2_antennanp
XANTENNA_12 VPWR VGND ISSUE_OPA_top18 sg13g2_antennanp
XANTENNA_89 VPWR VGND Tile_X0Y0_FrameData[5] sg13g2_antennanp
XANTENNA_45 VPWR VGND Tile_X0Y0_FrameData[21] sg13g2_antennanp
XANTENNA_34 VPWR VGND Tile_X0Y0_FrameData[1] sg13g2_antennanp
XFILLER_0_716 VPWR VGND sg13g2_decap_8
XFILLER_3_1270 VPWR VGND sg13g2_decap_8
XFILLER_11_399 VPWR VGND sg13g2_decap_8
XFILLER_2_0 VPWR VGND sg13g2_decap_8
X_122_ _012_ VPWR RESULT_top6 VGND Tile_X2Y0_S_XIF_right.Inst_S_XIF_right_ConfigMem.Inst_frame0_bit13.Q
+ _013_ sg13g2_o21ai_1
XFILLER_3_576 VPWR VGND sg13g2_decap_8
XFILLER_4_1034 VPWR VGND sg13g2_decap_8
XFILLER_7_871 VPWR VGND sg13g2_decap_8
XFILLER_4_318 VPWR VGND sg13g2_decap_8
X_740_ Tile_X2Y0_S_XIF_right.Inst_S_XIF_right_switch_matrix.NN4BEG8 Tile_X2Y0_NN4BEG[8]
+ VPWR VGND sg13g2_buf_1
XFILLER_0_513 VPWR VGND sg13g2_decap_8
X_671_ Tile_X0Y0_FrameData[27] Tile_X2Y0_FrameData_O[27] VPWR VGND sg13g2_buf_1
XFILLER_1_1218 VPWR VGND sg13g2_decap_8
XFILLER_11_152 VPWR VGND sg13g2_decap_8
X_105_ Tile_X2Y0_S_XIF_right.Inst_S_XIF_right_ConfigMem.Inst_frame0_bit2.Q VPWR _002_
+ VGND Tile_X2Y0_SS4END[1] Tile_X2Y0_S_XIF_right.Inst_S_XIF_right_ConfigMem.Inst_frame0_bit3.Q
+ sg13g2_o21ai_1
XFILLER_8_624 VPWR VGND sg13g2_decap_4
XFILLER_7_112 VPWR VGND sg13g2_decap_8
XFILLER_3_373 VPWR VGND sg13g2_decap_8
XFILLER_4_852 VPWR VGND sg13g2_decap_8
XFILLER_6_1107 VPWR VGND sg13g2_fill_2
XFILLER_11_1326 VPWR VGND sg13g2_decap_4
XFILLER_1_844 VPWR VGND sg13g2_decap_8
XFILLER_0_310 VPWR VGND sg13g2_decap_8
XFILLER_4_126 VPWR VGND sg13g2_decap_8
X_723_ Tile_X2Y0_S_XIF_right.Inst_S_XIF_right_switch_matrix.N4BEG7 Tile_X2Y0_N4BEG[7]
+ VPWR VGND sg13g2_buf_1
XFILLER_1_1004 VPWR VGND sg13g2_decap_8
XFILLER_1_855 VPWR VGND sg13g2_fill_1
XFILLER_0_387 VPWR VGND sg13g2_decap_8
X_654_ Tile_X0Y0_FrameData[10] Tile_X2Y0_FrameData_O[10] VPWR VGND sg13g2_buf_1
XFILLER_5_1184 VPWR VGND sg13g2_fill_1
X_585_ Tile_X1Y0_FrameStrobe[14] Tile_X1Y0_FrameStrobe_O[14] VPWR VGND sg13g2_buf_1
XFILLER_9_955 VPWR VGND sg13g2_decap_8
XFILLER_8_443 VPWR VGND sg13g2_decap_8
XFILLER_4_693 VPWR VGND sg13g2_fill_2
XFILLER_1_118 VPWR VGND sg13g2_decap_8
XFILLER_0_1092 VPWR VGND sg13g2_decap_8
X_370_ Tile_X0Y0_FrameData[13] Tile_X2Y0_FrameStrobe[0] Tile_X2Y0_S_XIF_right.Inst_S_XIF_right_ConfigMem.Inst_frame0_bit13.Q
+ VPWR VGND sg13g2_dlhq_1
XFILLER_10_976 VPWR VGND sg13g2_decap_8
XFILLER_5_424 VPWR VGND sg13g2_decap_8
XFILLER_6_903 VPWR VGND sg13g2_decap_8
XFILLER_1_630 VPWR VGND sg13g2_decap_8
XFILLER_0_140 VPWR VGND sg13g2_decap_8
X_637_ Tile_X1Y0_S_XIF_middle.Inst_S_XIF_middle_switch_matrix.NN4BEG10 Tile_X1Y0_NN4BEG[10]
+ VPWR VGND sg13g2_buf_1
X_706_ Tile_X2Y0_S2MID[1] Tile_X2Y0_N2BEG[6] VPWR VGND sg13g2_buf_1
XFILLER_7_1279 VPWR VGND sg13g2_decap_8
X_499_ Tile_X0Y0_FrameStrobe[1] Tile_X0Y0_FrameStrobe_O[1] VPWR VGND sg13g2_buf_1
X_568_ Tile_X0Y0_S_XIF_left.Inst_S_XIF_left_switch_matrix.NN4BEG14 Tile_X0Y0_NN4BEG[14]
+ VPWR VGND sg13g2_buf_1
XFILLER_5_84 VPWR VGND sg13g2_decap_8
XFILLER_2_449 VPWR VGND sg13g2_decap_8
XFILLER_3_928 VPWR VGND sg13g2_decap_8
XFILLER_6_7 VPWR VGND sg13g2_decap_8
XANTENNA_102 VPWR VGND Tile_X0Y0_FrameData[14] sg13g2_antennanp
XANTENNA_124 VPWR VGND Tile_X0Y0_FrameData[13] sg13g2_antennanp
XANTENNA_113 VPWR VGND Tile_X0Y0_FrameData[9] sg13g2_antennanp
X_353_ Tile_X0Y0_FrameData[30] Tile_X2Y0_FrameStrobe[0] Tile_X2Y0_S_XIF_right.Inst_S_XIF_right_ConfigMem.Inst_frame0_bit30.Q
+ VPWR VGND sg13g2_dlhq_1
X_422_ Tile_X0Y0_FrameData[25] Tile_X0Y0_FrameStrobe[0] Tile_X0Y0_S_XIF_left.Inst_S_XIF_left_ConfigMem.Inst_frame0_bit25.Q
+ VPWR VGND sg13g2_dlhq_1
X_284_ _064_ VPWR ISSUE_READY_top VGND Tile_X1Y0_S_XIF_middle.Inst_S_XIF_middle_ConfigMem.Inst_frame0_bit18.Q
+ _065_ sg13g2_o21ai_1
XFILLER_5_232 VPWR VGND sg13g2_fill_2
XFILLER_7_1032 VPWR VGND sg13g2_decap_8
XFILLER_1_460 VPWR VGND sg13g2_decap_8
XFILLER_2_983 VPWR VGND sg13g2_decap_8
XFILLER_9_571 VPWR VGND sg13g2_fill_1
XFILLER_11_559 VPWR VGND sg13g2_fill_2
XFILLER_3_703 VPWR VGND sg13g2_fill_2
XFILLER_3_725 VPWR VGND sg13g2_decap_8
XFILLER_8_1330 VPWR VGND sg13g2_fill_2
XFILLER_2_257 VPWR VGND sg13g2_fill_1
X_267_ Tile_X1Y0_SS4END[14] ISSUE_INSTR_top30 Tile_X1Y0_S_XIF_middle.Inst_S_XIF_middle_ConfigMem.Inst_frame0_bit2.Q
+ Tile_X1Y0_S_XIF_middle.Inst_S_XIF_middle_switch_matrix.NN4BEG1 VPWR VGND sg13g2_mux2_1
X_336_ Tile_X0Y0_FrameData[12] Tile_X1Y0_FrameStrobe[1] Tile_X1Y0_S_XIF_middle.Inst_S_XIF_middle_ConfigMem.Inst_frame1_bit12.Q
+ VPWR VGND sg13g2_dlhq_1
X_405_ Tile_X0Y0_FrameData[10] Tile_X2Y0_FrameStrobe[1] Tile_X2Y0_S_XIF_right.Inst_S_XIF_right_ConfigMem.Inst_frame1_bit10.Q
+ VPWR VGND sg13g2_dlhq_1
X_198_ _043_ Tile_X0Y0_S4END[5] Tile_X0Y0_S_XIF_left.Inst_S_XIF_left_ConfigMem.Inst_frame0_bit10.Q
+ VPWR VGND sg13g2_nand2b_1
XFILLER_6_541 VPWR VGND sg13g2_fill_1
XFILLER_2_63 VPWR VGND sg13g2_decap_8
XFILLER_2_780 VPWR VGND sg13g2_decap_8
XANTENNA_13 VPWR VGND ISSUE_OPA_top19 sg13g2_antennanp
XANTENNA_68 VPWR VGND Tile_X0Y0_FrameData[27] sg13g2_antennanp
XANTENNA_24 VPWR VGND ISSUE_OPA_top31 sg13g2_antennanp
XANTENNA_57 VPWR VGND Tile_X0Y0_FrameData[24] sg13g2_antennanp
XANTENNA_35 VPWR VGND Tile_X0Y0_FrameData[1] sg13g2_antennanp
XANTENNA_46 VPWR VGND Tile_X0Y0_FrameData[21] sg13g2_antennanp
XANTENNA_79 VPWR VGND Tile_X0Y0_FrameData[31] sg13g2_antennanp
X_121_ _013_ Tile_X2Y0_S4END[6] Tile_X2Y0_S_XIF_right.Inst_S_XIF_right_ConfigMem.Inst_frame0_bit12.Q
+ VPWR VGND sg13g2_nand2b_1
XFILLER_3_555 VPWR VGND sg13g2_decap_8
XFILLER_4_1013 VPWR VGND sg13g2_decap_8
X_319_ Tile_X0Y0_FrameData[29] Tile_X1Y0_FrameStrobe[1] Tile_X1Y0_S_XIF_middle.Inst_S_XIF_middle_ConfigMem.Inst_frame1_bit29.Q
+ VPWR VGND sg13g2_dlhq_1
XFILLER_7_850 VPWR VGND sg13g2_decap_8
XFILLER_6_360 VPWR VGND sg13g2_decap_8
X_670_ Tile_X0Y0_FrameData[26] Tile_X2Y0_FrameData_O[26] VPWR VGND sg13g2_buf_1
XFILLER_0_569 VPWR VGND sg13g2_decap_8
XFILLER_11_131 VPWR VGND sg13g2_decap_8
X_104_ _000_ VPWR RESULT_top0 VGND Tile_X2Y0_S_XIF_right.Inst_S_XIF_right_ConfigMem.Inst_frame0_bit1.Q
+ _001_ sg13g2_o21ai_1
XFILLER_7_157 VPWR VGND sg13g2_decap_8
XFILLER_3_352 VPWR VGND sg13g2_decap_8
XFILLER_4_831 VPWR VGND sg13g2_decap_8
XFILLER_11_1305 VPWR VGND sg13g2_decap_4
XFILLER_8_84 VPWR VGND sg13g2_decap_8
XFILLER_0_1285 VPWR VGND sg13g2_decap_8
XFILLER_4_105 VPWR VGND sg13g2_decap_8
XFILLER_1_867 VPWR VGND sg13g2_decap_4
XFILLER_1_823 VPWR VGND sg13g2_fill_1
XFILLER_1_812 VPWR VGND sg13g2_decap_8
X_722_ Tile_X2Y0_S_XIF_right.Inst_S_XIF_right_switch_matrix.N4BEG6 Tile_X2Y0_N4BEG[6]
+ VPWR VGND sg13g2_buf_1
XFILLER_0_366 VPWR VGND sg13g2_decap_8
X_653_ Tile_X0Y0_FrameData[9] Tile_X2Y0_FrameData_O[9] VPWR VGND sg13g2_buf_1
XFILLER_9_934 VPWR VGND sg13g2_decap_8
X_584_ Tile_X1Y0_FrameStrobe[13] Tile_X1Y0_FrameStrobe_O[13] VPWR VGND sg13g2_buf_1
XFILLER_8_499 VPWR VGND sg13g2_decap_8
XFILLER_3_182 VPWR VGND sg13g2_decap_8
XFILLER_0_1071 VPWR VGND sg13g2_decap_8
XFILLER_10_955 VPWR VGND sg13g2_decap_8
XFILLER_6_959 VPWR VGND sg13g2_decap_8
XFILLER_0_196 VPWR VGND sg13g2_decap_8
X_705_ Tile_X2Y0_S2MID[2] Tile_X2Y0_N2BEG[5] VPWR VGND sg13g2_buf_1
X_636_ Tile_X1Y0_S_XIF_middle.Inst_S_XIF_middle_switch_matrix.NN4BEG9 Tile_X1Y0_NN4BEG[9]
+ VPWR VGND sg13g2_buf_1
X_567_ Tile_X0Y0_S_XIF_left.Inst_S_XIF_left_switch_matrix.NN4BEG13 Tile_X0Y0_NN4BEG[13]
+ VPWR VGND sg13g2_buf_1
X_498_ Tile_X0Y0_FrameStrobe[0] Tile_X0Y0_FrameStrobe_O[0] VPWR VGND sg13g2_buf_1
XFILLER_9_775 VPWR VGND sg13g2_fill_2
XFILLER_4_491 VPWR VGND sg13g2_decap_8
XFILLER_5_63 VPWR VGND sg13g2_decap_8
XFILLER_5_992 VPWR VGND sg13g2_decap_8
XFILLER_10_0 VPWR VGND sg13g2_decap_8
XFILLER_3_907 VPWR VGND sg13g2_decap_8
XFILLER_2_428 VPWR VGND sg13g2_decap_8
X_421_ Tile_X0Y0_FrameData[26] Tile_X0Y0_FrameStrobe[0] Tile_X0Y0_S_XIF_left.Inst_S_XIF_left_ConfigMem.Inst_frame0_bit26.Q
+ VPWR VGND sg13g2_dlhq_1
XANTENNA_125 VPWR VGND Tile_X0Y0_FrameData[13] sg13g2_antennanp
XFILLER_2_1188 VPWR VGND sg13g2_fill_1
XANTENNA_114 VPWR VGND Tile_X0Y0_FrameData[9] sg13g2_antennanp
XFILLER_6_1280 VPWR VGND sg13g2_decap_8
XANTENNA_103 VPWR VGND Tile_X0Y0_FrameData[14] sg13g2_antennanp
X_352_ Tile_X0Y0_FrameData[31] Tile_X2Y0_FrameStrobe[0] Tile_X2Y0_S_XIF_right.Inst_S_XIF_right_ConfigMem.Inst_frame0_bit31.Q
+ VPWR VGND sg13g2_dlhq_1
X_283_ _065_ Tile_X1Y0_S2MID[0] Tile_X1Y0_S_XIF_middle.Inst_S_XIF_middle_ConfigMem.Inst_frame0_bit17.Q
+ VPWR VGND sg13g2_nand2b_1
XFILLER_7_1011 VPWR VGND sg13g2_decap_8
XFILLER_2_962 VPWR VGND sg13g2_decap_8
X_619_ Tile_X1Y0_S_XIF_middle.Inst_S_XIF_middle_switch_matrix.N4BEG8 Tile_X1Y0_N4BEG[8]
+ VPWR VGND sg13g2_buf_1
XFILLER_11_538 VPWR VGND sg13g2_fill_2
XFILLER_7_509 VPWR VGND sg13g2_decap_8
XFILLER_2_203 VPWR VGND sg13g2_decap_8
XFILLER_4_1228 VPWR VGND sg13g2_decap_4
X_404_ Tile_X0Y0_FrameData[11] Tile_X2Y0_FrameStrobe[1] Tile_X2Y0_S_XIF_right.Inst_S_XIF_right_ConfigMem.Inst_frame1_bit11.Q
+ VPWR VGND sg13g2_dlhq_1
X_266_ Tile_X1Y0_SS4END[15] ISSUE_INSTR_top31 Tile_X1Y0_S_XIF_middle.Inst_S_XIF_middle_ConfigMem.Inst_frame0_bit1.Q
+ Tile_X1Y0_S_XIF_middle.Inst_S_XIF_middle_switch_matrix.NN4BEG0 VPWR VGND sg13g2_mux2_1
X_197_ Tile_X0Y0_S_XIF_left.Inst_S_XIF_left_ConfigMem.Inst_frame0_bit10.Q VPWR _042_
+ VGND Tile_X0Y0_SS4END[5] Tile_X0Y0_S_XIF_left.Inst_S_XIF_left_ConfigMem.Inst_frame0_bit11.Q
+ sg13g2_o21ai_1
X_335_ Tile_X0Y0_FrameData[13] Tile_X1Y0_FrameStrobe[1] Tile_X1Y0_S_XIF_middle.Inst_S_XIF_middle_ConfigMem.Inst_frame1_bit13.Q
+ VPWR VGND sg13g2_dlhq_1
XFILLER_6_520 VPWR VGND sg13g2_decap_8
XFILLER_1_280 VPWR VGND sg13g2_fill_1
XFILLER_2_42 VPWR VGND sg13g2_decap_8
XANTENNA_14 VPWR VGND ISSUE_OPA_top2 sg13g2_antennanp
XANTENNA_47 VPWR VGND Tile_X0Y0_FrameData[21] sg13g2_antennanp
XANTENNA_25 VPWR VGND ISSUE_OPA_top4 sg13g2_antennanp
XANTENNA_36 VPWR VGND Tile_X0Y0_FrameData[1] sg13g2_antennanp
XANTENNA_69 VPWR VGND Tile_X0Y0_FrameData[27] sg13g2_antennanp
XANTENNA_58 VPWR VGND Tile_X0Y0_FrameData[24] sg13g2_antennanp
X_120_ Tile_X2Y0_S_XIF_right.Inst_S_XIF_right_ConfigMem.Inst_frame0_bit12.Q VPWR _012_
+ VGND Tile_X2Y0_SS4END[6] Tile_X2Y0_S_XIF_right.Inst_S_XIF_right_ConfigMem.Inst_frame0_bit13.Q
+ sg13g2_o21ai_1
XFILLER_11_84 VPWR VGND sg13g2_decap_8
XFILLER_3_534 VPWR VGND sg13g2_decap_8
XFILLER_4_1069 VPWR VGND sg13g2_decap_8
X_318_ Tile_X0Y0_FrameData[30] Tile_X1Y0_FrameStrobe[1] Tile_X1Y0_S_XIF_middle.Inst_S_XIF_middle_ConfigMem.Inst_frame1_bit30.Q
+ VPWR VGND sg13g2_dlhq_1
X_249_ Tile_X1Y0_S2END[0] ISSUE_ID_top3 Tile_X1Y0_S_XIF_middle.Inst_S_XIF_middle_ConfigMem.Inst_frame1_bit16.Q
+ Tile_X1Y0_S_XIF_middle.Inst_S_XIF_middle_switch_matrix.N2BEGb7 VPWR VGND sg13g2_mux2_1
XFILLER_0_548 VPWR VGND sg13g2_decap_8
XFILLER_4_810 VPWR VGND sg13g2_decap_8
X_103_ _001_ Tile_X2Y0_S4END[0] Tile_X2Y0_S_XIF_right.Inst_S_XIF_right_ConfigMem.Inst_frame0_bit0.Q
+ VPWR VGND sg13g2_nand2b_1
XFILLER_4_887 VPWR VGND sg13g2_decap_8
XFILLER_8_63 VPWR VGND sg13g2_decap_8
XFILLER_0_1264 VPWR VGND sg13g2_decap_8
XFILLER_1_835 VPWR VGND sg13g2_decap_4
XFILLER_0_345 VPWR VGND sg13g2_decap_8
XFILLER_1_1039 VPWR VGND sg13g2_decap_8
X_583_ Tile_X1Y0_FrameStrobe[12] Tile_X1Y0_FrameStrobe_O[12] VPWR VGND sg13g2_buf_1
X_652_ Tile_X0Y0_FrameData[8] Tile_X2Y0_FrameData_O[8] VPWR VGND sg13g2_buf_1
X_721_ Tile_X2Y0_S_XIF_right.Inst_S_XIF_right_switch_matrix.N4BEG5 Tile_X2Y0_N4BEG[5]
+ VPWR VGND sg13g2_buf_1
XFILLER_9_913 VPWR VGND sg13g2_decap_8
XFILLER_8_478 VPWR VGND sg13g2_decap_8
XFILLER_3_161 VPWR VGND sg13g2_decap_8
XFILLER_10_934 VPWR VGND sg13g2_decap_8
XFILLER_0_1050 VPWR VGND sg13g2_decap_8
XFILLER_5_459 VPWR VGND sg13g2_decap_8
XFILLER_6_938 VPWR VGND sg13g2_decap_8
X_704_ Tile_X2Y0_S2MID[3] Tile_X2Y0_N2BEG[4] VPWR VGND sg13g2_buf_1
XFILLER_7_1215 VPWR VGND sg13g2_decap_8
XFILLER_1_698 VPWR VGND sg13g2_decap_8
XFILLER_1_665 VPWR VGND sg13g2_decap_8
XFILLER_0_175 VPWR VGND sg13g2_decap_8
X_635_ Tile_X1Y0_S_XIF_middle.Inst_S_XIF_middle_switch_matrix.NN4BEG8 Tile_X1Y0_NN4BEG[8]
+ VPWR VGND sg13g2_buf_1
X_566_ Tile_X0Y0_S_XIF_left.Inst_S_XIF_left_switch_matrix.NN4BEG12 Tile_X0Y0_NN4BEG[12]
+ VPWR VGND sg13g2_buf_1
X_497_ VPWR VGND Tile_X0Y0_Co sg13g2_tielo
XFILLER_8_220 VPWR VGND sg13g2_fill_1
XFILLER_4_470 VPWR VGND sg13g2_decap_8
XFILLER_5_42 VPWR VGND sg13g2_decap_8
XFILLER_5_971 VPWR VGND sg13g2_decap_8
XFILLER_2_407 VPWR VGND sg13g2_decap_8
X_351_ Tile_X0Y0_FrameData[29] Tile_X1Y0_FrameStrobe[2] Tile_X1Y0_S_XIF_middle.Inst_S_XIF_middle_ConfigMem.Inst_frame2_bit29.Q
+ VPWR VGND sg13g2_dlhq_1
X_420_ Tile_X0Y0_FrameData[27] Tile_X0Y0_FrameStrobe[0] Tile_X0Y0_S_XIF_left.Inst_S_XIF_left_ConfigMem.Inst_frame0_bit27.Q
+ VPWR VGND sg13g2_dlhq_1
XANTENNA_104 VPWR VGND Tile_X0Y0_FrameData[14] sg13g2_antennanp
XANTENNA_126 VPWR VGND Tile_X0Y0_FrameData[13] sg13g2_antennanp
XANTENNA_115 VPWR VGND Tile_X0Y0_FrameData[9] sg13g2_antennanp
X_282_ Tile_X1Y0_S_XIF_middle.Inst_S_XIF_middle_ConfigMem.Inst_frame0_bit17.Q VPWR
+ _064_ VGND Tile_X1Y0_S2MID[1] Tile_X1Y0_S_XIF_middle.Inst_S_XIF_middle_ConfigMem.Inst_frame0_bit18.Q
+ sg13g2_o21ai_1
XFILLER_1_451 VPWR VGND sg13g2_decap_4
XFILLER_2_941 VPWR VGND sg13g2_decap_8
XFILLER_5_267 VPWR VGND sg13g2_fill_2
X_618_ Tile_X1Y0_S_XIF_middle.Inst_S_XIF_middle_switch_matrix.N4BEG7 Tile_X1Y0_N4BEG[7]
+ VPWR VGND sg13g2_buf_1
X_549_ Tile_X0Y0_S_XIF_left.Inst_S_XIF_left_switch_matrix.N4BEG11 Tile_X0Y0_N4BEG[11]
+ VPWR VGND sg13g2_buf_1
X_403_ Tile_X0Y0_FrameData[12] Tile_X2Y0_FrameStrobe[1] Tile_X2Y0_S_XIF_right.Inst_S_XIF_right_ConfigMem.Inst_frame1_bit12.Q
+ VPWR VGND sg13g2_dlhq_1
X_334_ Tile_X0Y0_FrameData[14] Tile_X1Y0_FrameStrobe[1] Tile_X1Y0_S_XIF_middle.Inst_S_XIF_middle_ConfigMem.Inst_frame1_bit14.Q
+ VPWR VGND sg13g2_dlhq_1
X_265_ Tile_X1Y0_S4END[0] ISSUE_INSTR_top0 Tile_X1Y0_S_XIF_middle.Inst_S_XIF_middle_ConfigMem.Inst_frame0_bit0.Q
+ Tile_X1Y0_S_XIF_middle.Inst_S_XIF_middle_switch_matrix.N4BEG15 VPWR VGND sg13g2_mux2_1
X_196_ _040_ VPWR RESULT_top20 VGND Tile_X0Y0_S_XIF_left.Inst_S_XIF_left_ConfigMem.Inst_frame0_bit9.Q
+ _041_ sg13g2_o21ai_1
XFILLER_6_576 VPWR VGND sg13g2_fill_1
XFILLER_2_21 VPWR VGND sg13g2_decap_8
XFILLER_2_98 VPWR VGND sg13g2_decap_8
XANTENNA_15 VPWR VGND ISSUE_OPA_top20 sg13g2_antennanp
XANTENNA_59 VPWR VGND Tile_X0Y0_FrameData[24] sg13g2_antennanp
XANTENNA_37 VPWR VGND Tile_X0Y0_FrameData[1] sg13g2_antennanp
XANTENNA_48 VPWR VGND Tile_X0Y0_FrameData[21] sg13g2_antennanp
XANTENNA_26 VPWR VGND ISSUE_OPA_top5 sg13g2_antennanp
XFILLER_3_1284 VPWR VGND sg13g2_decap_8
XFILLER_11_63 VPWR VGND sg13g2_decap_8
XFILLER_3_513 VPWR VGND sg13g2_decap_8
XFILLER_4_1048 VPWR VGND sg13g2_decap_8
X_317_ Tile_X0Y0_FrameData[31] Tile_X1Y0_FrameStrobe[1] Tile_X1Y0_S_XIF_middle.Inst_S_XIF_middle_ConfigMem.Inst_frame1_bit31.Q
+ VPWR VGND sg13g2_dlhq_1
XFILLER_7_885 VPWR VGND sg13g2_decap_8
X_179_ Tile_X0Y0_SS4END[2] ISSUE_OPA_top18 Tile_X0Y0_S_XIF_left.Inst_S_XIF_left_ConfigMem.Inst_frame1_bit29.Q
+ Tile_X0Y0_S_XIF_left.Inst_S_XIF_left_switch_matrix.NN4BEG13 VPWR VGND sg13g2_mux2_1
X_248_ Tile_X1Y0_S2END[1] ISSUE_ID_top2 Tile_X1Y0_S_XIF_middle.Inst_S_XIF_middle_ConfigMem.Inst_frame1_bit15.Q
+ Tile_X1Y0_S_XIF_middle.Inst_S_XIF_middle_switch_matrix.N2BEGb6 VPWR VGND sg13g2_mux2_1
XFILLER_0_527 VPWR VGND sg13g2_decap_8
XFILLER_3_1092 VPWR VGND sg13g2_decap_8
XFILLER_11_166 VPWR VGND sg13g2_decap_8
XFILLER_3_310 VPWR VGND sg13g2_decap_8
X_102_ Tile_X2Y0_S_XIF_right.Inst_S_XIF_right_ConfigMem.Inst_frame0_bit0.Q VPWR _000_
+ VGND Tile_X2Y0_SS4END[0] Tile_X2Y0_S_XIF_right.Inst_S_XIF_right_ConfigMem.Inst_frame0_bit1.Q
+ sg13g2_o21ai_1
XFILLER_4_866 VPWR VGND sg13g2_decap_8
XFILLER_7_126 VPWR VGND sg13g2_decap_8
XFILLER_0_0 VPWR VGND sg13g2_decap_8
XFILLER_3_387 VPWR VGND sg13g2_decap_8
XFILLER_8_42 VPWR VGND sg13g2_decap_8
XFILLER_6_192 VPWR VGND sg13g2_fill_2
XFILLER_7_693 VPWR VGND sg13g2_decap_4
XFILLER_0_1243 VPWR VGND sg13g2_decap_8
X_720_ Tile_X2Y0_S_XIF_right.Inst_S_XIF_right_switch_matrix.N4BEG4 Tile_X2Y0_N4BEG[4]
+ VPWR VGND sg13g2_buf_1
XFILLER_1_803 VPWR VGND sg13g2_decap_4
XFILLER_0_324 VPWR VGND sg13g2_decap_8
XFILLER_1_1018 VPWR VGND sg13g2_decap_8
X_582_ Tile_X1Y0_FrameStrobe[11] Tile_X1Y0_FrameStrobe_O[11] VPWR VGND sg13g2_buf_1
X_651_ Tile_X0Y0_FrameData[7] Tile_X2Y0_FrameData_O[7] VPWR VGND sg13g2_buf_1
XFILLER_9_969 VPWR VGND sg13g2_decap_8
XFILLER_8_457 VPWR VGND sg13g2_decap_8
XFILLER_3_140 VPWR VGND sg13g2_decap_8
XFILLER_8_980 VPWR VGND sg13g2_decap_8
XFILLER_10_913 VPWR VGND sg13g2_decap_8
XFILLER_6_917 VPWR VGND sg13g2_decap_8
XFILLER_1_644 VPWR VGND sg13g2_decap_8
XFILLER_5_438 VPWR VGND sg13g2_decap_8
X_703_ Tile_X2Y0_S2MID[4] Tile_X2Y0_N2BEG[3] VPWR VGND sg13g2_buf_1
X_634_ Tile_X1Y0_S_XIF_middle.Inst_S_XIF_middle_switch_matrix.NN4BEG7 Tile_X1Y0_NN4BEG[7]
+ VPWR VGND sg13g2_buf_1
XFILLER_7_1249 VPWR VGND sg13g2_fill_2
XFILLER_0_154 VPWR VGND sg13g2_decap_8
X_496_ VPWR VGND Tile_X1Y0_Co sg13g2_tielo
X_565_ Tile_X0Y0_S_XIF_left.Inst_S_XIF_left_switch_matrix.NN4BEG11 Tile_X0Y0_NN4BEG[11]
+ VPWR VGND sg13g2_buf_1
XFILLER_5_21 VPWR VGND sg13g2_decap_8
XFILLER_5_950 VPWR VGND sg13g2_decap_8
XFILLER_5_98 VPWR VGND sg13g2_decap_8
XFILLER_2_1102 VPWR VGND sg13g2_decap_8
X_350_ Tile_X0Y0_FrameData[30] Tile_X1Y0_FrameStrobe[2] Tile_X1Y0_S_XIF_middle.Inst_S_XIF_middle_ConfigMem.Inst_frame2_bit30.Q
+ VPWR VGND sg13g2_dlhq_1
XANTENNA_127 VPWR VGND Tile_X0Y0_FrameData[13] sg13g2_antennanp
XFILLER_2_1146 VPWR VGND sg13g2_decap_4
XANTENNA_116 VPWR VGND Tile_X0Y0_FrameData[9] sg13g2_antennanp
XANTENNA_105 VPWR VGND Tile_X0Y0_FrameData[14] sg13g2_antennanp
X_281_ Tile_X1Y0_SS4END[0] ISSUE_INSTR_top16 Tile_X1Y0_S_XIF_middle.Inst_S_XIF_middle_ConfigMem.Inst_frame0_bit16.Q
+ Tile_X1Y0_S_XIF_middle.Inst_S_XIF_middle_switch_matrix.NN4BEG15 VPWR VGND sg13g2_mux2_1
XFILLER_5_202 VPWR VGND sg13g2_decap_8
XFILLER_5_213 VPWR VGND sg13g2_fill_2
XFILLER_1_474 VPWR VGND sg13g2_decap_8
XFILLER_2_920 VPWR VGND sg13g2_decap_8
XFILLER_2_997 VPWR VGND sg13g2_decap_8
X_617_ Tile_X1Y0_S_XIF_middle.Inst_S_XIF_middle_switch_matrix.N4BEG6 Tile_X1Y0_N4BEG[6]
+ VPWR VGND sg13g2_buf_1
XFILLER_7_1046 VPWR VGND sg13g2_decap_8
X_479_ Tile_X0Y0_FrameData[0] Tile_X0Y0_FrameStrobe[1] Tile_X0Y0_S_XIF_left.Inst_S_XIF_left_ConfigMem.Inst_frame1_bit0.Q
+ VPWR VGND sg13g2_dlhq_1
X_548_ Tile_X0Y0_S_XIF_left.Inst_S_XIF_left_switch_matrix.N4BEG10 Tile_X0Y0_N4BEG[10]
+ VPWR VGND sg13g2_buf_1
XFILLER_3_739 VPWR VGND sg13g2_decap_8
XFILLER_4_7 VPWR VGND sg13g2_decap_8
X_264_ Tile_X1Y0_S4END[1] ISSUE_INSTR_top1 Tile_X1Y0_S_XIF_middle.Inst_S_XIF_middle_ConfigMem.Inst_frame1_bit31.Q
+ Tile_X1Y0_S_XIF_middle.Inst_S_XIF_middle_switch_matrix.N4BEG14 VPWR VGND sg13g2_mux2_1
X_402_ Tile_X0Y0_FrameData[13] Tile_X2Y0_FrameStrobe[1] Tile_X2Y0_S_XIF_right.Inst_S_XIF_right_ConfigMem.Inst_frame1_bit13.Q
+ VPWR VGND sg13g2_dlhq_1
X_333_ Tile_X0Y0_FrameData[15] Tile_X1Y0_FrameStrobe[1] Tile_X1Y0_S_XIF_middle.Inst_S_XIF_middle_ConfigMem.Inst_frame1_bit15.Q
+ VPWR VGND sg13g2_dlhq_1
X_195_ _041_ Tile_X0Y0_S4END[4] Tile_X0Y0_S_XIF_left.Inst_S_XIF_left_ConfigMem.Inst_frame0_bit8.Q
+ VPWR VGND sg13g2_nand2b_1
XFILLER_2_77 VPWR VGND sg13g2_decap_8
XFILLER_2_794 VPWR VGND sg13g2_decap_8
XANTENNA_16 VPWR VGND ISSUE_OPA_top22 sg13g2_antennanp
XANTENNA_38 VPWR VGND Tile_X0Y0_FrameData[1] sg13g2_antennanp
XANTENNA_49 VPWR VGND Tile_X0Y0_FrameData[21] sg13g2_antennanp
XANTENNA_27 VPWR VGND ISSUE_OPA_top5 sg13g2_antennanp
XFILLER_0_709 VPWR VGND sg13g2_decap_8
XFILLER_3_1230 VPWR VGND sg13g2_fill_1
XFILLER_3_1263 VPWR VGND sg13g2_decap_8
XFILLER_11_315 VPWR VGND sg13g2_decap_4
XFILLER_11_42 VPWR VGND sg13g2_decap_8
XFILLER_8_1185 VPWR VGND sg13g2_fill_1
XFILLER_8_1141 VPWR VGND sg13g2_fill_2
XFILLER_3_569 VPWR VGND sg13g2_decap_8
XFILLER_4_1027 VPWR VGND sg13g2_decap_8
XFILLER_11_893 VPWR VGND sg13g2_decap_8
X_316_ Tile_X0Y0_FrameData[0] Tile_X1Y0_FrameStrobe[0] Tile_X1Y0_S_XIF_middle.Inst_S_XIF_middle_ConfigMem.Inst_frame0_bit0.Q
+ VPWR VGND sg13g2_dlhq_1
X_247_ Tile_X1Y0_S2END[2] ISSUE_ID_top1 Tile_X1Y0_S_XIF_middle.Inst_S_XIF_middle_ConfigMem.Inst_frame1_bit14.Q
+ Tile_X1Y0_S_XIF_middle.Inst_S_XIF_middle_switch_matrix.N2BEGb5 VPWR VGND sg13g2_mux2_1
X_178_ Tile_X0Y0_SS4END[3] ISSUE_OPA_top19 Tile_X0Y0_S_XIF_left.Inst_S_XIF_left_ConfigMem.Inst_frame1_bit28.Q
+ Tile_X0Y0_S_XIF_left.Inst_S_XIF_left_switch_matrix.NN4BEG12 VPWR VGND sg13g2_mux2_1
XFILLER_7_864 VPWR VGND sg13g2_decap_8
XFILLER_0_506 VPWR VGND sg13g2_decap_8
XFILLER_3_1071 VPWR VGND sg13g2_decap_8
XFILLER_11_145 VPWR VGND sg13g2_decap_8
XFILLER_8_617 VPWR VGND sg13g2_decap_8
X_101_ Tile_X2Y0_SS4END[0] ISSUE_OPB_top16 Tile_X2Y0_S_XIF_right.Inst_S_XIF_right_ConfigMem.Inst_frame1_bit31.Q
+ Tile_X2Y0_S_XIF_right.Inst_S_XIF_right_switch_matrix.NN4BEG15 VPWR VGND sg13g2_mux2_1
XFILLER_7_105 VPWR VGND sg13g2_decap_8
XFILLER_3_366 VPWR VGND sg13g2_decap_8
XFILLER_4_845 VPWR VGND sg13g2_decap_8
XFILLER_11_1319 VPWR VGND sg13g2_decap_8
XFILLER_8_98 VPWR VGND sg13g2_decap_8
XFILLER_8_21 VPWR VGND sg13g2_decap_8
XFILLER_6_171 VPWR VGND sg13g2_decap_8
XFILLER_0_1222 VPWR VGND sg13g2_decap_8
XFILLER_0_1299 VPWR VGND sg13g2_decap_8
XFILLER_0_303 VPWR VGND sg13g2_decap_8
XFILLER_4_119 VPWR VGND sg13g2_decap_8
X_650_ Tile_X0Y0_FrameData[6] Tile_X2Y0_FrameData_O[6] VPWR VGND sg13g2_buf_1
X_581_ Tile_X1Y0_FrameStrobe[10] Tile_X1Y0_FrameStrobe_O[10] VPWR VGND sg13g2_buf_1
XFILLER_9_948 VPWR VGND sg13g2_decap_8
XFILLER_3_196 VPWR VGND sg13g2_decap_8
XFILLER_4_642 VPWR VGND sg13g2_decap_4
XFILLER_0_1085 VPWR VGND sg13g2_decap_8
XFILLER_10_969 VPWR VGND sg13g2_decap_8
XFILLER_1_623 VPWR VGND sg13g2_decap_8
XFILLER_0_133 VPWR VGND sg13g2_decap_8
X_702_ Tile_X2Y0_S2MID[5] Tile_X2Y0_N2BEG[2] VPWR VGND sg13g2_buf_1
X_633_ Tile_X1Y0_S_XIF_middle.Inst_S_XIF_middle_switch_matrix.NN4BEG6 Tile_X1Y0_NN4BEG[6]
+ VPWR VGND sg13g2_buf_1
X_495_ VPWR VGND Tile_X2Y0_Co sg13g2_tielo
X_564_ Tile_X0Y0_S_XIF_left.Inst_S_XIF_left_switch_matrix.NN4BEG10 Tile_X0Y0_NN4BEG[10]
+ VPWR VGND sg13g2_buf_1
XFILLER_8_200 VPWR VGND sg13g2_fill_2
XFILLER_10_1171 VPWR VGND sg13g2_fill_2
XFILLER_5_77 VPWR VGND sg13g2_decap_8
XANTENNA_106 VPWR VGND Tile_X0Y0_FrameData[3] sg13g2_antennanp
XFILLER_6_1294 VPWR VGND sg13g2_decap_8
X_280_ Tile_X1Y0_SS4END[1] ISSUE_INSTR_top17 Tile_X1Y0_S_XIF_middle.Inst_S_XIF_middle_ConfigMem.Inst_frame0_bit15.Q
+ Tile_X1Y0_S_XIF_middle.Inst_S_XIF_middle_switch_matrix.NN4BEG14 VPWR VGND sg13g2_mux2_1
XANTENNA_117 VPWR VGND Tile_X0Y0_FrameData[9] sg13g2_antennanp
XANTENNA_128 VPWR VGND Tile_X0Y0_FrameData[13] sg13g2_antennanp
XFILLER_7_1025 VPWR VGND sg13g2_decap_8
XFILLER_2_976 VPWR VGND sg13g2_decap_8
X_616_ Tile_X1Y0_S_XIF_middle.Inst_S_XIF_middle_switch_matrix.N4BEG5 Tile_X1Y0_N4BEG[5]
+ VPWR VGND sg13g2_buf_1
X_547_ Tile_X0Y0_S_XIF_left.Inst_S_XIF_left_switch_matrix.N4BEG9 Tile_X0Y0_N4BEG[9]
+ VPWR VGND sg13g2_buf_1
X_478_ Tile_X0Y0_FrameData[1] Tile_X0Y0_FrameStrobe[1] Tile_X0Y0_S_XIF_left.Inst_S_XIF_left_ConfigMem.Inst_frame1_bit1.Q
+ VPWR VGND sg13g2_dlhq_1
XFILLER_1_1191 VPWR VGND sg13g2_decap_8
XFILLER_8_1323 VPWR VGND sg13g2_decap_8
X_401_ Tile_X0Y0_FrameData[14] Tile_X2Y0_FrameStrobe[1] Tile_X2Y0_S_XIF_right.Inst_S_XIF_right_ConfigMem.Inst_frame1_bit14.Q
+ VPWR VGND sg13g2_dlhq_1
X_263_ Tile_X1Y0_S4END[2] ISSUE_INSTR_top2 Tile_X1Y0_S_XIF_middle.Inst_S_XIF_middle_ConfigMem.Inst_frame1_bit30.Q
+ Tile_X1Y0_S_XIF_middle.Inst_S_XIF_middle_switch_matrix.N4BEG13 VPWR VGND sg13g2_mux2_1
X_332_ Tile_X0Y0_FrameData[16] Tile_X1Y0_FrameStrobe[1] Tile_X1Y0_S_XIF_middle.Inst_S_XIF_middle_ConfigMem.Inst_frame1_bit16.Q
+ VPWR VGND sg13g2_dlhq_1
X_194_ Tile_X0Y0_S_XIF_left.Inst_S_XIF_left_ConfigMem.Inst_frame0_bit8.Q VPWR _040_
+ VGND Tile_X0Y0_SS4END[4] Tile_X0Y0_S_XIF_left.Inst_S_XIF_left_ConfigMem.Inst_frame0_bit9.Q
+ sg13g2_o21ai_1
XFILLER_6_534 VPWR VGND sg13g2_decap_8
XFILLER_2_56 VPWR VGND sg13g2_decap_8
XFILLER_2_773 VPWR VGND sg13g2_decap_8
XANTENNA_17 VPWR VGND ISSUE_OPA_top23 sg13g2_antennanp
XANTENNA_28 VPWR VGND ISSUE_OPA_top6 sg13g2_antennanp
XANTENNA_39 VPWR VGND Tile_X0Y0_FrameData[21] sg13g2_antennanp
XFILLER_11_338 VPWR VGND sg13g2_fill_2
XFILLER_11_98 VPWR VGND sg13g2_decap_4
XFILLER_11_21 VPWR VGND sg13g2_decap_8
XFILLER_3_548 VPWR VGND sg13g2_decap_8
XFILLER_8_1153 VPWR VGND sg13g2_fill_2
XFILLER_4_1006 VPWR VGND sg13g2_decap_8
XFILLER_11_872 VPWR VGND sg13g2_decap_8
X_177_ Tile_X0Y0_SS4END[4] ISSUE_OPA_top20 Tile_X0Y0_S_XIF_left.Inst_S_XIF_left_ConfigMem.Inst_frame1_bit27.Q
+ Tile_X0Y0_S_XIF_left.Inst_S_XIF_left_switch_matrix.NN4BEG11 VPWR VGND sg13g2_mux2_1
XFILLER_7_843 VPWR VGND sg13g2_decap_8
X_315_ Tile_X0Y0_FrameData[1] Tile_X1Y0_FrameStrobe[0] Tile_X1Y0_S_XIF_middle.Inst_S_XIF_middle_ConfigMem.Inst_frame0_bit1.Q
+ VPWR VGND sg13g2_dlhq_1
X_246_ Tile_X1Y0_S2END[3] ISSUE_ID_top0 Tile_X1Y0_S_XIF_middle.Inst_S_XIF_middle_ConfigMem.Inst_frame1_bit13.Q
+ Tile_X1Y0_S_XIF_middle.Inst_S_XIF_middle_switch_matrix.N2BEGb4 VPWR VGND sg13g2_mux2_1
XFILLER_9_191 VPWR VGND sg13g2_fill_2
XFILLER_5_1326 VPWR VGND sg13g2_decap_4
XFILLER_11_124 VPWR VGND sg13g2_decap_8
XFILLER_11_102 VPWR VGND sg13g2_fill_2
X_100_ Tile_X2Y0_SS4END[1] ISSUE_OPB_top17 Tile_X2Y0_S_XIF_right.Inst_S_XIF_right_ConfigMem.Inst_frame1_bit30.Q
+ Tile_X2Y0_S_XIF_right.Inst_S_XIF_right_switch_matrix.NN4BEG14 VPWR VGND sg13g2_mux2_1
XFILLER_3_345 VPWR VGND sg13g2_decap_8
XFILLER_4_824 VPWR VGND sg13g2_decap_8
XFILLER_11_1309 VPWR VGND sg13g2_fill_2
X_229_ _062_ VPWR RESULT_top31 VGND Tile_X0Y0_S_XIF_left.Inst_S_XIF_left_ConfigMem.Inst_frame0_bit31.Q
+ _063_ sg13g2_o21ai_1
XFILLER_8_77 VPWR VGND sg13g2_decap_8
XFILLER_0_1201 VPWR VGND sg13g2_decap_8
XFILLER_0_1278 VPWR VGND sg13g2_decap_8
X_580_ Tile_X1Y0_FrameStrobe[9] Tile_X1Y0_FrameStrobe_O[9] VPWR VGND sg13g2_buf_1
XFILLER_0_359 VPWR VGND sg13g2_decap_8
XFILLER_9_927 VPWR VGND sg13g2_decap_8
XFILLER_10_1331 VPWR VGND sg13g2_fill_1
XFILLER_0_882 VPWR VGND sg13g2_decap_8
XFILLER_3_175 VPWR VGND sg13g2_decap_8
XFILLER_4_698 VPWR VGND sg13g2_fill_1
XFILLER_7_481 VPWR VGND sg13g2_decap_8
XFILLER_2_1307 VPWR VGND sg13g2_decap_4
XFILLER_0_1064 VPWR VGND sg13g2_decap_8
XFILLER_10_948 VPWR VGND sg13g2_decap_8
XFILLER_1_679 VPWR VGND sg13g2_fill_1
XFILLER_1_602 VPWR VGND sg13g2_decap_8
XFILLER_0_112 VPWR VGND sg13g2_decap_8
X_632_ Tile_X1Y0_S_XIF_middle.Inst_S_XIF_middle_switch_matrix.NN4BEG5 Tile_X1Y0_NN4BEG[5]
+ VPWR VGND sg13g2_buf_1
X_701_ Tile_X2Y0_S2MID[6] Tile_X2Y0_N2BEG[1] VPWR VGND sg13g2_buf_1
X_563_ Tile_X0Y0_S_XIF_left.Inst_S_XIF_left_switch_matrix.NN4BEG9 Tile_X0Y0_NN4BEG[9]
+ VPWR VGND sg13g2_buf_1
XFILLER_0_189 VPWR VGND sg13g2_decap_8
X_494_ Tile_X0Y0_FrameData[17] Tile_X1Y0_FrameStrobe[0] Tile_X1Y0_S_XIF_middle.Inst_S_XIF_middle_ConfigMem.Inst_frame0_bit17.Q
+ VPWR VGND sg13g2_dlhq_1
XFILLER_8_256 VPWR VGND sg13g2_fill_1
XFILLER_4_484 VPWR VGND sg13g2_decap_8
XFILLER_5_56 VPWR VGND sg13g2_decap_8
XFILLER_5_985 VPWR VGND sg13g2_decap_8
XANTENNA_118 VPWR VGND Tile_X0Y0_FrameData[9] sg13g2_antennanp
XANTENNA_107 VPWR VGND Tile_X0Y0_FrameData[3] sg13g2_antennanp
XFILLER_6_1273 VPWR VGND sg13g2_decap_8
XFILLER_7_1004 VPWR VGND sg13g2_decap_8
XFILLER_2_955 VPWR VGND sg13g2_decap_8
X_546_ Tile_X0Y0_S_XIF_left.Inst_S_XIF_left_switch_matrix.N4BEG8 Tile_X0Y0_N4BEG[8]
+ VPWR VGND sg13g2_buf_1
X_615_ Tile_X1Y0_S_XIF_middle.Inst_S_XIF_middle_switch_matrix.N4BEG4 Tile_X1Y0_N4BEG[4]
+ VPWR VGND sg13g2_buf_1
XFILLER_9_576 VPWR VGND sg13g2_fill_2
X_477_ Tile_X0Y0_FrameData[2] Tile_X0Y0_FrameStrobe[1] Tile_X0Y0_S_XIF_left.Inst_S_XIF_left_ConfigMem.Inst_frame1_bit2.Q
+ VPWR VGND sg13g2_dlhq_1
XFILLER_5_782 VPWR VGND sg13g2_decap_8
X_400_ Tile_X0Y0_FrameData[15] Tile_X2Y0_FrameStrobe[1] Tile_X2Y0_S_XIF_right.Inst_S_XIF_right_ConfigMem.Inst_frame1_bit15.Q
+ VPWR VGND sg13g2_dlhq_1
X_331_ Tile_X0Y0_FrameData[17] Tile_X1Y0_FrameStrobe[1] Tile_X1Y0_S_XIF_middle.Inst_S_XIF_middle_ConfigMem.Inst_frame1_bit17.Q
+ VPWR VGND sg13g2_dlhq_1
X_262_ Tile_X1Y0_S4END[3] ISSUE_INSTR_top3 Tile_X1Y0_S_XIF_middle.Inst_S_XIF_middle_ConfigMem.Inst_frame1_bit29.Q
+ Tile_X1Y0_S_XIF_middle.Inst_S_XIF_middle_switch_matrix.N4BEG12 VPWR VGND sg13g2_mux2_1
X_193_ _038_ VPWR RESULT_top19 VGND Tile_X0Y0_S_XIF_left.Inst_S_XIF_left_ConfigMem.Inst_frame0_bit7.Q
+ _039_ sg13g2_o21ai_1
XFILLER_6_513 VPWR VGND sg13g2_decap_8
XFILLER_2_752 VPWR VGND sg13g2_decap_8
XFILLER_1_273 VPWR VGND sg13g2_fill_2
XFILLER_2_35 VPWR VGND sg13g2_decap_8
X_529_ Tile_X0Y0_S2MID[0] Tile_X0Y0_N2BEG[7] VPWR VGND sg13g2_buf_1
XANTENNA_18 VPWR VGND ISSUE_OPA_top24 sg13g2_antennanp
XANTENNA_29 VPWR VGND ISSUE_OPA_top7 sg13g2_antennanp
XFILLER_3_1221 VPWR VGND sg13g2_decap_8
XFILLER_3_1298 VPWR VGND sg13g2_decap_8
XFILLER_11_77 VPWR VGND sg13g2_decap_8
XFILLER_3_527 VPWR VGND sg13g2_decap_8
X_314_ Tile_X0Y0_FrameData[2] Tile_X1Y0_FrameStrobe[0] Tile_X1Y0_S_XIF_middle.Inst_S_XIF_middle_ConfigMem.Inst_frame0_bit2.Q
+ VPWR VGND sg13g2_dlhq_1
XFILLER_11_851 VPWR VGND sg13g2_decap_8
X_245_ Tile_X1Y0_S2END[4] ISSUE_VALID_top Tile_X1Y0_S_XIF_middle.Inst_S_XIF_middle_ConfigMem.Inst_frame1_bit12.Q
+ Tile_X1Y0_S_XIF_middle.Inst_S_XIF_middle_switch_matrix.N2BEGb3 VPWR VGND sg13g2_mux2_1
X_176_ Tile_X0Y0_SS4END[5] ISSUE_OPA_top21 Tile_X0Y0_S_XIF_left.Inst_S_XIF_left_ConfigMem.Inst_frame1_bit26.Q
+ Tile_X0Y0_S_XIF_left.Inst_S_XIF_left_switch_matrix.NN4BEG10 VPWR VGND sg13g2_mux2_1
XFILLER_7_899 VPWR VGND sg13g2_decap_8
XFILLER_7_822 VPWR VGND sg13g2_decap_8
XFILLER_2_582 VPWR VGND sg13g2_decap_8
XFILLER_3_1040 VPWR VGND sg13g2_decap_8
XFILLER_4_803 VPWR VGND sg13g2_decap_8
XFILLER_8_56 VPWR VGND sg13g2_decap_8
X_228_ _063_ Tile_X0Y0_S4END[15] Tile_X0Y0_S_XIF_left.Inst_S_XIF_left_ConfigMem.Inst_frame0_bit30.Q
+ VPWR VGND sg13g2_nand2b_1
X_159_ Tile_X0Y0_S4END[6] ISSUE_OPA_top6 Tile_X0Y0_S_XIF_left.Inst_S_XIF_left_ConfigMem.Inst_frame1_bit9.Q
+ Tile_X0Y0_S_XIF_left.Inst_S_XIF_left_switch_matrix.N4BEG9 VPWR VGND sg13g2_mux2_1
XFILLER_6_140 VPWR VGND sg13g2_decap_8
XFILLER_0_1257 VPWR VGND sg13g2_decap_8
XFILLER_1_839 VPWR VGND sg13g2_fill_1
XFILLER_1_828 VPWR VGND sg13g2_decap_8
XFILLER_0_338 VPWR VGND sg13g2_decap_8
XFILLER_9_906 VPWR VGND sg13g2_decap_8
XFILLER_3_154 VPWR VGND sg13g2_decap_8
XFILLER_4_611 VPWR VGND sg13g2_fill_2
XFILLER_0_861 VPWR VGND sg13g2_decap_8
XFILLER_7_460 VPWR VGND sg13g2_decap_8
XFILLER_8_994 VPWR VGND sg13g2_decap_8
XFILLER_10_927 VPWR VGND sg13g2_decap_8
XFILLER_0_1043 VPWR VGND sg13g2_decap_8
X_700_ Tile_X2Y0_S2MID[7] Tile_X2Y0_N2BEG[0] VPWR VGND sg13g2_buf_1
XFILLER_1_658 VPWR VGND sg13g2_decap_8
XFILLER_0_168 VPWR VGND sg13g2_decap_8
X_562_ Tile_X0Y0_S_XIF_left.Inst_S_XIF_left_switch_matrix.NN4BEG8 Tile_X0Y0_NN4BEG[8]
+ VPWR VGND sg13g2_buf_1
X_631_ Tile_X1Y0_S_XIF_middle.Inst_S_XIF_middle_switch_matrix.NN4BEG4 Tile_X1Y0_NN4BEG[4]
+ VPWR VGND sg13g2_buf_1
X_493_ Tile_X0Y0_FrameData[18] Tile_X1Y0_FrameStrobe[0] Tile_X1Y0_S_XIF_middle.Inst_S_XIF_middle_ConfigMem.Inst_frame0_bit18.Q
+ VPWR VGND sg13g2_dlhq_1
XFILLER_9_758 VPWR VGND sg13g2_fill_2
XFILLER_8_202 VPWR VGND sg13g2_fill_1
XFILLER_4_463 VPWR VGND sg13g2_decap_8
XFILLER_5_35 VPWR VGND sg13g2_decap_8
XFILLER_5_964 VPWR VGND sg13g2_decap_8
XFILLER_6_1230 VPWR VGND sg13g2_fill_1
XANTENNA_108 VPWR VGND Tile_X0Y0_FrameData[3] sg13g2_antennanp
XANTENNA_119 VPWR VGND Tile_X0Y0_FrameData[9] sg13g2_antennanp
XFILLER_1_444 VPWR VGND sg13g2_decap_8
XFILLER_2_934 VPWR VGND sg13g2_decap_8
XFILLER_1_499 VPWR VGND sg13g2_decap_4
XFILLER_1_455 VPWR VGND sg13g2_fill_1
X_476_ Tile_X0Y0_FrameData[3] Tile_X0Y0_FrameStrobe[1] Tile_X0Y0_S_XIF_left.Inst_S_XIF_left_ConfigMem.Inst_frame1_bit3.Q
+ VPWR VGND sg13g2_dlhq_1
X_545_ Tile_X0Y0_S_XIF_left.Inst_S_XIF_left_switch_matrix.N4BEG7 Tile_X0Y0_N4BEG[7]
+ VPWR VGND sg13g2_buf_1
X_614_ Tile_X1Y0_S_XIF_middle.Inst_S_XIF_middle_switch_matrix.N4BEG3 Tile_X1Y0_N4BEG[3]
+ VPWR VGND sg13g2_buf_1
XFILLER_5_761 VPWR VGND sg13g2_decap_8
XFILLER_6_1071 VPWR VGND sg13g2_decap_4
X_330_ Tile_X0Y0_FrameData[18] Tile_X1Y0_FrameStrobe[1] Tile_X1Y0_S_XIF_middle.Inst_S_XIF_middle_ConfigMem.Inst_frame1_bit18.Q
+ VPWR VGND sg13g2_dlhq_1
X_261_ Tile_X1Y0_S4END[4] ISSUE_INSTR_top4 Tile_X1Y0_S_XIF_middle.Inst_S_XIF_middle_ConfigMem.Inst_frame1_bit28.Q
+ Tile_X1Y0_S_XIF_middle.Inst_S_XIF_middle_switch_matrix.N4BEG11 VPWR VGND sg13g2_mux2_1
X_192_ _039_ Tile_X0Y0_S4END[3] Tile_X0Y0_S_XIF_left.Inst_S_XIF_left_ConfigMem.Inst_frame0_bit6.Q
+ VPWR VGND sg13g2_nand2b_1
XFILLER_9_0 VPWR VGND sg13g2_decap_8
XFILLER_1_241 VPWR VGND sg13g2_decap_8
XFILLER_1_285 VPWR VGND sg13g2_decap_8
XFILLER_2_14 VPWR VGND sg13g2_decap_8
XFILLER_2_731 VPWR VGND sg13g2_decap_8
XFILLER_1_296 VPWR VGND sg13g2_decap_8
XFILLER_9_352 VPWR VGND sg13g2_fill_1
XANTENNA_19 VPWR VGND ISSUE_OPA_top25 sg13g2_antennanp
X_528_ Tile_X0Y0_S2MID[1] Tile_X0Y0_N2BEG[6] VPWR VGND sg13g2_buf_1
X_459_ Tile_X0Y0_FrameData[20] Tile_X0Y0_FrameStrobe[1] Tile_X0Y0_S_XIF_left.Inst_S_XIF_left_ConfigMem.Inst_frame1_bit20.Q
+ VPWR VGND sg13g2_dlhq_1
XFILLER_3_1277 VPWR VGND sg13g2_decap_8
XFILLER_11_56 VPWR VGND sg13g2_decap_8
XFILLER_8_1122 VPWR VGND sg13g2_fill_2
XFILLER_2_7 VPWR VGND sg13g2_decap_8
XFILLER_3_506 VPWR VGND sg13g2_decap_8
X_313_ Tile_X0Y0_FrameData[3] Tile_X1Y0_FrameStrobe[0] Tile_X1Y0_S_XIF_middle.Inst_S_XIF_middle_ConfigMem.Inst_frame0_bit3.Q
+ VPWR VGND sg13g2_dlhq_1
X_244_ Tile_X1Y0_S2END[5] ISSUE_VALID_top Tile_X1Y0_S_XIF_middle.Inst_S_XIF_middle_ConfigMem.Inst_frame1_bit11.Q
+ Tile_X1Y0_S_XIF_middle.Inst_S_XIF_middle_switch_matrix.N2BEGb2 VPWR VGND sg13g2_mux2_1
X_175_ Tile_X0Y0_SS4END[6] ISSUE_OPA_top22 Tile_X0Y0_S_XIF_left.Inst_S_XIF_left_ConfigMem.Inst_frame1_bit25.Q
+ Tile_X0Y0_S_XIF_left.Inst_S_XIF_left_switch_matrix.NN4BEG9 VPWR VGND sg13g2_mux2_1
XFILLER_7_878 VPWR VGND sg13g2_decap_8
XFILLER_2_561 VPWR VGND sg13g2_decap_8
XFILLER_9_171 VPWR VGND sg13g2_fill_1
XFILLER_5_1306 VPWR VGND sg13g2_fill_2
XFILLER_11_115 VPWR VGND sg13g2_decap_4
XFILLER_3_1085 VPWR VGND sg13g2_decap_8
XFILLER_11_159 VPWR VGND sg13g2_decap_8
XFILLER_4_859 VPWR VGND sg13g2_decap_8
XFILLER_7_119 VPWR VGND sg13g2_decap_8
X_227_ Tile_X0Y0_S_XIF_left.Inst_S_XIF_left_ConfigMem.Inst_frame0_bit30.Q VPWR _062_
+ VGND Tile_X0Y0_SS4END[15] Tile_X0Y0_S_XIF_left.Inst_S_XIF_left_ConfigMem.Inst_frame0_bit31.Q
+ sg13g2_o21ai_1
XFILLER_8_35 VPWR VGND sg13g2_decap_8
XFILLER_7_642 VPWR VGND sg13g2_fill_2
X_089_ Tile_X2Y0_SS4END[12] ISSUE_OPB_top28 Tile_X2Y0_S_XIF_right.Inst_S_XIF_right_ConfigMem.Inst_frame1_bit19.Q
+ Tile_X2Y0_S_XIF_right.Inst_S_XIF_right_switch_matrix.NN4BEG3 VPWR VGND sg13g2_mux2_1
XFILLER_6_152 VPWR VGND sg13g2_decap_8
XFILLER_6_185 VPWR VGND sg13g2_decap_8
X_158_ Tile_X0Y0_S4END[7] ISSUE_OPA_top7 Tile_X0Y0_S_XIF_left.Inst_S_XIF_left_ConfigMem.Inst_frame1_bit8.Q
+ Tile_X0Y0_S_XIF_left.Inst_S_XIF_left_switch_matrix.N4BEG8 VPWR VGND sg13g2_mux2_1
XFILLER_7_686 VPWR VGND sg13g2_decap_8
XFILLER_0_1236 VPWR VGND sg13g2_decap_8
XFILLER_1_807 VPWR VGND sg13g2_fill_1
XFILLER_0_317 VPWR VGND sg13g2_decap_8
XFILLER_3_133 VPWR VGND sg13g2_decap_8
XFILLER_0_840 VPWR VGND sg13g2_decap_8
XFILLER_8_973 VPWR VGND sg13g2_decap_8
XFILLER_0_1022 VPWR VGND sg13g2_decap_8
XFILLER_10_906 VPWR VGND sg13g2_decap_8
XFILLER_0_1099 VPWR VGND sg13g2_decap_8
XFILLER_0_91 VPWR VGND sg13g2_decap_8
XFILLER_1_637 VPWR VGND sg13g2_decap_8
XFILLER_0_147 VPWR VGND sg13g2_decap_8
X_630_ Tile_X1Y0_S_XIF_middle.Inst_S_XIF_middle_switch_matrix.NN4BEG3 Tile_X1Y0_NN4BEG[3]
+ VPWR VGND sg13g2_buf_1
X_561_ Tile_X0Y0_S_XIF_left.Inst_S_XIF_left_switch_matrix.NN4BEG7 Tile_X0Y0_NN4BEG[7]
+ VPWR VGND sg13g2_buf_1
X_492_ Tile_X0Y0_FrameData[19] Tile_X1Y0_FrameStrobe[0] Tile_X1Y0_S_XIF_middle.Inst_S_XIF_middle_ConfigMem.Inst_frame0_bit19.Q
+ VPWR VGND sg13g2_dlhq_1
XFILLER_4_442 VPWR VGND sg13g2_decap_8
XFILLER_5_14 VPWR VGND sg13g2_decap_8
XFILLER_5_943 VPWR VGND sg13g2_decap_8
XFILLER_0_681 VPWR VGND sg13g2_decap_8
XFILLER_1_1331 VPWR VGND sg13g2_fill_1
XANTENNA_109 VPWR VGND Tile_X0Y0_FrameData[3] sg13g2_antennanp
XFILLER_1_467 VPWR VGND sg13g2_decap_8
XFILLER_1_423 VPWR VGND sg13g2_fill_1
XFILLER_1_412 VPWR VGND sg13g2_decap_8
XFILLER_2_913 VPWR VGND sg13g2_decap_8
X_613_ Tile_X1Y0_S_XIF_middle.Inst_S_XIF_middle_switch_matrix.N4BEG2 Tile_X1Y0_N4BEG[2]
+ VPWR VGND sg13g2_buf_1
XFILLER_7_1039 VPWR VGND sg13g2_fill_2
X_544_ Tile_X0Y0_S_XIF_left.Inst_S_XIF_left_switch_matrix.N4BEG6 Tile_X0Y0_N4BEG[6]
+ VPWR VGND sg13g2_buf_1
X_475_ Tile_X0Y0_FrameData[4] Tile_X0Y0_FrameStrobe[1] Tile_X0Y0_S_XIF_left.Inst_S_XIF_left_ConfigMem.Inst_frame1_bit4.Q
+ VPWR VGND sg13g2_dlhq_1
XFILLER_6_1050 VPWR VGND sg13g2_decap_8
X_260_ Tile_X1Y0_S4END[5] ISSUE_INSTR_top5 Tile_X1Y0_S_XIF_middle.Inst_S_XIF_middle_ConfigMem.Inst_frame1_bit27.Q
+ Tile_X1Y0_S_XIF_middle.Inst_S_XIF_middle_switch_matrix.N4BEG10 VPWR VGND sg13g2_mux2_1
X_191_ Tile_X0Y0_S_XIF_left.Inst_S_XIF_left_ConfigMem.Inst_frame0_bit6.Q VPWR _038_
+ VGND Tile_X0Y0_SS4END[3] Tile_X0Y0_S_XIF_left.Inst_S_XIF_left_ConfigMem.Inst_frame0_bit7.Q
+ sg13g2_o21ai_1
XFILLER_11_1291 VPWR VGND sg13g2_decap_8
XFILLER_1_220 VPWR VGND sg13g2_decap_8
XFILLER_2_710 VPWR VGND sg13g2_decap_8
XFILLER_2_787 VPWR VGND sg13g2_decap_8
X_527_ Tile_X0Y0_S2MID[2] Tile_X0Y0_N2BEG[5] VPWR VGND sg13g2_buf_1
X_389_ Tile_X0Y0_FrameData[26] Tile_X2Y0_FrameStrobe[1] Tile_X2Y0_S_XIF_right.Inst_S_XIF_right_ConfigMem.Inst_frame1_bit26.Q
+ VPWR VGND sg13g2_dlhq_1
X_458_ Tile_X0Y0_FrameData[21] Tile_X0Y0_FrameStrobe[1] Tile_X0Y0_S_XIF_left.Inst_S_XIF_left_ConfigMem.Inst_frame1_bit21.Q
+ VPWR VGND sg13g2_dlhq_1
XFILLER_11_319 VPWR VGND sg13g2_fill_2
XFILLER_3_1256 VPWR VGND sg13g2_decap_8
XFILLER_11_35 VPWR VGND sg13g2_decap_8
XFILLER_11_886 VPWR VGND sg13g2_decap_8
X_243_ Tile_X1Y0_S2END[6] ISSUE_VALID_top Tile_X1Y0_S_XIF_middle.Inst_S_XIF_middle_ConfigMem.Inst_frame1_bit10.Q
+ Tile_X1Y0_S_XIF_middle.Inst_S_XIF_middle_switch_matrix.N2BEGb1 VPWR VGND sg13g2_mux2_1
X_312_ Tile_X0Y0_FrameData[4] Tile_X1Y0_FrameStrobe[0] Tile_X1Y0_S_XIF_middle.Inst_S_XIF_middle_ConfigMem.Inst_frame0_bit4.Q
+ VPWR VGND sg13g2_dlhq_1
X_174_ Tile_X0Y0_SS4END[7] ISSUE_OPA_top23 Tile_X0Y0_S_XIF_left.Inst_S_XIF_left_ConfigMem.Inst_frame1_bit24.Q
+ Tile_X0Y0_S_XIF_left.Inst_S_XIF_left_switch_matrix.NN4BEG8 VPWR VGND sg13g2_mux2_1
XFILLER_7_857 VPWR VGND sg13g2_decap_8
XFILLER_2_540 VPWR VGND sg13g2_decap_8
XFILLER_6_367 VPWR VGND sg13g2_fill_1
XFILLER_9_183 VPWR VGND sg13g2_decap_4
XFILLER_9_150 VPWR VGND sg13g2_fill_1
XFILLER_3_91 VPWR VGND sg13g2_decap_8
XFILLER_3_1064 VPWR VGND sg13g2_decap_8
XFILLER_11_138 VPWR VGND sg13g2_decap_8
XFILLER_3_359 VPWR VGND sg13g2_decap_8
XFILLER_4_838 VPWR VGND sg13g2_decap_8
X_226_ _060_ VPWR RESULT_top30 VGND Tile_X0Y0_S_XIF_left.Inst_S_XIF_left_ConfigMem.Inst_frame0_bit29.Q
+ _061_ sg13g2_o21ai_1
X_157_ Tile_X0Y0_S4END[8] ISSUE_OPA_top8 Tile_X0Y0_S_XIF_left.Inst_S_XIF_left_ConfigMem.Inst_frame1_bit7.Q
+ Tile_X0Y0_S_XIF_left.Inst_S_XIF_left_switch_matrix.N4BEG7 VPWR VGND sg13g2_mux2_1
XFILLER_8_14 VPWR VGND sg13g2_decap_8
X_088_ Tile_X2Y0_SS4END[13] ISSUE_OPB_top29 Tile_X2Y0_S_XIF_right.Inst_S_XIF_right_ConfigMem.Inst_frame1_bit18.Q
+ Tile_X2Y0_S_XIF_right.Inst_S_XIF_right_switch_matrix.NN4BEG2 VPWR VGND sg13g2_mux2_1
XFILLER_3_893 VPWR VGND sg13g2_decap_8
XFILLER_6_164 VPWR VGND sg13g2_decap_8
XFILLER_0_1215 VPWR VGND sg13g2_decap_8
XFILLER_1_819 VPWR VGND sg13g2_decap_4
XFILLER_5_1137 VPWR VGND sg13g2_fill_1
XFILLER_3_112 VPWR VGND sg13g2_decap_8
XFILLER_3_189 VPWR VGND sg13g2_decap_8
XFILLER_4_635 VPWR VGND sg13g2_decap_8
XFILLER_0_896 VPWR VGND sg13g2_decap_8
XFILLER_8_952 VPWR VGND sg13g2_decap_8
X_209_ Tile_X0Y0_S_XIF_left.Inst_S_XIF_left_ConfigMem.Inst_frame0_bit18.Q VPWR _050_
+ VGND Tile_X0Y0_SS4END[9] Tile_X0Y0_S_XIF_left.Inst_S_XIF_left_ConfigMem.Inst_frame0_bit19.Q
+ sg13g2_o21ai_1
XFILLER_7_495 VPWR VGND sg13g2_decap_8
XFILLER_0_1078 VPWR VGND sg13g2_decap_8
XFILLER_0_1001 VPWR VGND sg13g2_decap_8
XFILLER_0_70 VPWR VGND sg13g2_decap_8
XFILLER_1_616 VPWR VGND sg13g2_decap_8
XFILLER_0_126 VPWR VGND sg13g2_decap_8
X_560_ Tile_X0Y0_S_XIF_left.Inst_S_XIF_left_switch_matrix.NN4BEG6 Tile_X0Y0_NN4BEG[6]
+ VPWR VGND sg13g2_buf_1
X_491_ Tile_X0Y0_FrameData[20] Tile_X1Y0_FrameStrobe[0] Tile_X1Y0_S_XIF_middle.Inst_S_XIF_middle_ConfigMem.Inst_frame0_bit20.Q
+ VPWR VGND sg13g2_dlhq_1
XFILLER_4_421 VPWR VGND sg13g2_decap_8
XFILLER_5_922 VPWR VGND sg13g2_decap_8
XFILLER_0_660 VPWR VGND sg13g2_decap_8
XFILLER_4_498 VPWR VGND sg13g2_decap_8
XFILLER_5_999 VPWR VGND sg13g2_decap_8
XFILLER_10_7 VPWR VGND sg13g2_decap_8
X_689_ Tile_X2Y0_FrameStrobe[13] Tile_X2Y0_FrameStrobe_O[13] VPWR VGND sg13g2_buf_1
XFILLER_8_771 VPWR VGND sg13g2_fill_1
XFILLER_6_1287 VPWR VGND sg13g2_decap_8
XFILLER_7_1018 VPWR VGND sg13g2_decap_8
XFILLER_1_435 VPWR VGND sg13g2_decap_4
XFILLER_2_969 VPWR VGND sg13g2_decap_8
X_612_ Tile_X1Y0_S_XIF_middle.Inst_S_XIF_middle_switch_matrix.N4BEG1 Tile_X1Y0_N4BEG[1]
+ VPWR VGND sg13g2_buf_1
X_543_ Tile_X0Y0_S_XIF_left.Inst_S_XIF_left_switch_matrix.N4BEG5 Tile_X0Y0_N4BEG[5]
+ VPWR VGND sg13g2_buf_1
X_474_ Tile_X0Y0_FrameData[5] Tile_X0Y0_FrameStrobe[1] Tile_X0Y0_S_XIF_left.Inst_S_XIF_left_ConfigMem.Inst_frame1_bit5.Q
+ VPWR VGND sg13g2_dlhq_1
XFILLER_5_796 VPWR VGND sg13g2_decap_8
XFILLER_6_91 VPWR VGND sg13g2_decap_8
X_190_ _036_ VPWR RESULT_top18 VGND Tile_X0Y0_S_XIF_left.Inst_S_XIF_left_ConfigMem.Inst_frame0_bit5.Q
+ _037_ sg13g2_o21ai_1
XFILLER_10_578 VPWR VGND sg13g2_fill_1
XFILLER_6_527 VPWR VGND sg13g2_decap_8
XFILLER_2_49 VPWR VGND sg13g2_decap_8
XFILLER_2_766 VPWR VGND sg13g2_decap_8
X_526_ Tile_X0Y0_S2MID[3] Tile_X0Y0_N2BEG[4] VPWR VGND sg13g2_buf_1
X_388_ Tile_X0Y0_FrameData[27] Tile_X2Y0_FrameStrobe[1] Tile_X2Y0_S_XIF_right.Inst_S_XIF_right_ConfigMem.Inst_frame1_bit27.Q
+ VPWR VGND sg13g2_dlhq_1
X_457_ Tile_X0Y0_FrameData[22] Tile_X0Y0_FrameStrobe[1] Tile_X0Y0_S_XIF_left.Inst_S_XIF_left_ConfigMem.Inst_frame1_bit22.Q
+ VPWR VGND sg13g2_dlhq_1
XFILLER_5_582 VPWR VGND sg13g2_decap_8
XFILLER_11_14 VPWR VGND sg13g2_decap_8
XFILLER_11_865 VPWR VGND sg13g2_decap_8
X_173_ Tile_X0Y0_SS4END[8] ISSUE_OPA_top24 Tile_X0Y0_S_XIF_left.Inst_S_XIF_left_ConfigMem.Inst_frame1_bit23.Q
+ Tile_X0Y0_S_XIF_left.Inst_S_XIF_left_switch_matrix.NN4BEG7 VPWR VGND sg13g2_mux2_1
XFILLER_7_836 VPWR VGND sg13g2_decap_8
XFILLER_7_803 VPWR VGND sg13g2_fill_2
X_311_ Tile_X0Y0_FrameData[5] Tile_X1Y0_FrameStrobe[0] Tile_X1Y0_S_XIF_middle.Inst_S_XIF_middle_ConfigMem.Inst_frame0_bit5.Q
+ VPWR VGND sg13g2_dlhq_1
X_242_ Tile_X1Y0_S2END[7] ISSUE_VALID_top Tile_X1Y0_S_XIF_middle.Inst_S_XIF_middle_ConfigMem.Inst_frame1_bit9.Q
+ Tile_X1Y0_S_XIF_middle.Inst_S_XIF_middle_switch_matrix.N2BEGb0 VPWR VGND sg13g2_mux2_1
XFILLER_10_397 VPWR VGND sg13g2_fill_2
XFILLER_2_596 VPWR VGND sg13g2_decap_8
X_509_ Tile_X0Y0_FrameStrobe[11] Tile_X0Y0_FrameStrobe_O[11] VPWR VGND sg13g2_buf_1
XFILLER_9_162 VPWR VGND sg13g2_decap_8
XFILLER_3_70 VPWR VGND sg13g2_decap_8
XFILLER_5_1319 VPWR VGND sg13g2_decap_8
XFILLER_3_1054 VPWR VGND sg13g2_decap_4
XFILLER_3_338 VPWR VGND sg13g2_decap_8
XFILLER_4_817 VPWR VGND sg13g2_decap_8
X_087_ Tile_X2Y0_SS4END[14] ISSUE_OPB_top30 Tile_X2Y0_S_XIF_right.Inst_S_XIF_right_ConfigMem.Inst_frame1_bit17.Q
+ Tile_X2Y0_S_XIF_right.Inst_S_XIF_right_switch_matrix.NN4BEG1 VPWR VGND sg13g2_mux2_1
X_225_ _061_ Tile_X0Y0_S4END[14] Tile_X0Y0_S_XIF_left.Inst_S_XIF_left_ConfigMem.Inst_frame0_bit28.Q
+ VPWR VGND sg13g2_nand2b_1
X_156_ Tile_X0Y0_S4END[9] ISSUE_OPA_top9 Tile_X0Y0_S_XIF_left.Inst_S_XIF_left_ConfigMem.Inst_frame1_bit6.Q
+ Tile_X0Y0_S_XIF_left.Inst_S_XIF_left_switch_matrix.N4BEG6 VPWR VGND sg13g2_mux2_1
XFILLER_7_644 VPWR VGND sg13g2_fill_1
XFILLER_2_393 VPWR VGND sg13g2_decap_8
XFILLER_3_872 VPWR VGND sg13g2_decap_8
XFILLER_4_1330 VPWR VGND sg13g2_fill_2
XFILLER_9_1296 VPWR VGND sg13g2_decap_8
XFILLER_10_1302 VPWR VGND sg13g2_fill_2
XFILLER_0_875 VPWR VGND sg13g2_decap_8
XFILLER_3_168 VPWR VGND sg13g2_decap_8
XFILLER_8_931 VPWR VGND sg13g2_decap_8
XFILLER_11_481 VPWR VGND sg13g2_decap_8
X_139_ _025_ Tile_X2Y0_S4END[12] Tile_X2Y0_S_XIF_right.Inst_S_XIF_right_ConfigMem.Inst_frame0_bit24.Q
+ VPWR VGND sg13g2_nand2b_1
X_208_ _048_ VPWR RESULT_top24 VGND Tile_X0Y0_S_XIF_left.Inst_S_XIF_left_ConfigMem.Inst_frame0_bit17.Q
+ _049_ sg13g2_o21ai_1
XFILLER_7_474 VPWR VGND sg13g2_decap_8
XFILLER_0_1057 VPWR VGND sg13g2_decap_8
XFILLER_9_91 VPWR VGND sg13g2_decap_8
XFILLER_0_105 VPWR VGND sg13g2_decap_8
XFILLER_9_1071 VPWR VGND sg13g2_fill_1
X_490_ Tile_X0Y0_FrameData[21] Tile_X1Y0_FrameStrobe[0] Tile_X1Y0_S_XIF_middle.Inst_S_XIF_middle_ConfigMem.Inst_frame0_bit21.Q
+ VPWR VGND sg13g2_dlhq_1
XFILLER_4_477 VPWR VGND sg13g2_decap_8
XFILLER_5_49 VPWR VGND sg13g2_decap_8
XFILLER_5_901 VPWR VGND sg13g2_decap_8
XFILLER_5_978 VPWR VGND sg13g2_decap_8
X_688_ Tile_X2Y0_FrameStrobe[12] Tile_X2Y0_FrameStrobe_O[12] VPWR VGND sg13g2_buf_1
XFILLER_1_1311 VPWR VGND sg13g2_fill_1
XFILLER_10_727 VPWR VGND sg13g2_decap_4
XFILLER_2_948 VPWR VGND sg13g2_decap_8
X_611_ Tile_X1Y0_S_XIF_middle.Inst_S_XIF_middle_switch_matrix.N4BEG0 Tile_X1Y0_N4BEG[0]
+ VPWR VGND sg13g2_buf_1
X_473_ Tile_X0Y0_FrameData[6] Tile_X0Y0_FrameStrobe[1] Tile_X0Y0_S_XIF_left.Inst_S_XIF_left_ConfigMem.Inst_frame1_bit6.Q
+ VPWR VGND sg13g2_dlhq_1
X_542_ Tile_X0Y0_S_XIF_left.Inst_S_XIF_left_switch_matrix.N4BEG4 Tile_X0Y0_N4BEG[4]
+ VPWR VGND sg13g2_buf_1
XFILLER_9_569 VPWR VGND sg13g2_fill_2
XFILLER_9_547 VPWR VGND sg13g2_fill_1
XFILLER_5_775 VPWR VGND sg13g2_decap_8
XFILLER_1_1130 VPWR VGND sg13g2_decap_4
XFILLER_6_70 VPWR VGND sg13g2_decap_8
XFILLER_8_1306 VPWR VGND sg13g2_fill_2
XFILLER_6_506 VPWR VGND sg13g2_decap_8
XFILLER_1_211 VPWR VGND sg13g2_decap_4
XFILLER_2_745 VPWR VGND sg13g2_decap_8
XFILLER_2_28 VPWR VGND sg13g2_decap_8
X_525_ Tile_X0Y0_S2MID[4] Tile_X0Y0_N2BEG[3] VPWR VGND sg13g2_buf_1
X_456_ Tile_X0Y0_FrameData[23] Tile_X0Y0_FrameStrobe[1] Tile_X0Y0_S_XIF_left.Inst_S_XIF_left_ConfigMem.Inst_frame1_bit23.Q
+ VPWR VGND sg13g2_dlhq_1
X_387_ Tile_X0Y0_FrameData[28] Tile_X2Y0_FrameStrobe[1] Tile_X2Y0_S_XIF_right.Inst_S_XIF_right_ConfigMem.Inst_frame1_bit28.Q
+ VPWR VGND sg13g2_dlhq_1
X_310_ Tile_X0Y0_FrameData[6] Tile_X1Y0_FrameStrobe[0] Tile_X1Y0_S_XIF_middle.Inst_S_XIF_middle_ConfigMem.Inst_frame0_bit6.Q
+ VPWR VGND sg13g2_dlhq_1
XFILLER_11_844 VPWR VGND sg13g2_decap_8
X_241_ Tile_X1Y0_S2MID[0] ISSUE_VALID_top Tile_X1Y0_S_XIF_middle.Inst_S_XIF_middle_ConfigMem.Inst_frame1_bit8.Q
+ Tile_X1Y0_S_XIF_middle.Inst_S_XIF_middle_switch_matrix.N2BEG7 VPWR VGND sg13g2_mux2_1
X_172_ Tile_X0Y0_SS4END[9] ISSUE_OPA_top25 Tile_X0Y0_S_XIF_left.Inst_S_XIF_left_ConfigMem.Inst_frame1_bit22.Q
+ Tile_X0Y0_S_XIF_left.Inst_S_XIF_left_switch_matrix.NN4BEG6 VPWR VGND sg13g2_mux2_1
XFILLER_7_815 VPWR VGND sg13g2_decap_8
XFILLER_2_575 VPWR VGND sg13g2_decap_8
XFILLER_7_0 VPWR VGND sg13g2_decap_8
X_508_ Tile_X0Y0_FrameStrobe[10] Tile_X0Y0_FrameStrobe_O[10] VPWR VGND sg13g2_buf_1
X_439_ Tile_X0Y0_FrameData[8] Tile_X0Y0_FrameStrobe[0] Tile_X0Y0_S_XIF_left.Inst_S_XIF_left_ConfigMem.Inst_frame0_bit8.Q
+ VPWR VGND sg13g2_dlhq_1
XFILLER_3_1033 VPWR VGND sg13g2_decap_8
XFILLER_3_1099 VPWR VGND sg13g2_decap_4
XFILLER_0_7 VPWR VGND sg13g2_decap_8
XFILLER_3_317 VPWR VGND sg13g2_fill_1
XFILLER_8_49 VPWR VGND sg13g2_decap_8
X_224_ Tile_X0Y0_S_XIF_left.Inst_S_XIF_left_ConfigMem.Inst_frame0_bit28.Q VPWR _060_
+ VGND Tile_X0Y0_SS4END[14] Tile_X0Y0_S_XIF_left.Inst_S_XIF_left_ConfigMem.Inst_frame0_bit29.Q
+ sg13g2_o21ai_1
X_086_ Tile_X2Y0_SS4END[15] ISSUE_OPB_top31 Tile_X2Y0_S_XIF_right.Inst_S_XIF_right_ConfigMem.Inst_frame1_bit16.Q
+ Tile_X2Y0_S_XIF_right.Inst_S_XIF_right_switch_matrix.NN4BEG0 VPWR VGND sg13g2_mux2_1
X_155_ Tile_X0Y0_S4END[10] ISSUE_OPA_top10 Tile_X0Y0_S_XIF_left.Inst_S_XIF_left_ConfigMem.Inst_frame1_bit5.Q
+ Tile_X0Y0_S_XIF_left.Inst_S_XIF_left_switch_matrix.N4BEG5 VPWR VGND sg13g2_mux2_1
XFILLER_6_133 VPWR VGND sg13g2_decap_8
XFILLER_2_372 VPWR VGND sg13g2_decap_8
XFILLER_3_851 VPWR VGND sg13g2_decap_8
XFILLER_4_604 VPWR VGND sg13g2_decap_8
XFILLER_0_854 VPWR VGND sg13g2_decap_8
XFILLER_3_147 VPWR VGND sg13g2_decap_8
XFILLER_11_460 VPWR VGND sg13g2_decap_8
XFILLER_8_910 VPWR VGND sg13g2_decap_8
X_207_ _049_ Tile_X0Y0_S4END[8] Tile_X0Y0_S_XIF_left.Inst_S_XIF_left_ConfigMem.Inst_frame0_bit16.Q
+ VPWR VGND sg13g2_nand2b_1
XFILLER_7_420 VPWR VGND sg13g2_fill_1
X_138_ Tile_X2Y0_S_XIF_right.Inst_S_XIF_right_ConfigMem.Inst_frame0_bit24.Q VPWR _024_
+ VGND Tile_X2Y0_SS4END[12] Tile_X2Y0_S_XIF_right.Inst_S_XIF_right_ConfigMem.Inst_frame0_bit25.Q
+ sg13g2_o21ai_1
XFILLER_8_987 VPWR VGND sg13g2_decap_8
XFILLER_7_453 VPWR VGND sg13g2_decap_8
XFILLER_0_1036 VPWR VGND sg13g2_decap_8
XFILLER_9_70 VPWR VGND sg13g2_decap_8
XFILLER_4_456 VPWR VGND sg13g2_decap_8
XFILLER_5_28 VPWR VGND sg13g2_decap_8
XFILLER_5_957 VPWR VGND sg13g2_decap_8
XFILLER_0_695 VPWR VGND sg13g2_decap_8
X_687_ Tile_X2Y0_FrameStrobe[11] Tile_X2Y0_FrameStrobe_O[11] VPWR VGND sg13g2_buf_1
XFILLER_7_250 VPWR VGND sg13g2_decap_4
XFILLER_2_1109 VPWR VGND sg13g2_decap_8
XFILLER_6_1223 VPWR VGND sg13g2_decap_8
XFILLER_6_1267 VPWR VGND sg13g2_fill_1
XFILLER_1_404 VPWR VGND sg13g2_decap_4
XFILLER_2_927 VPWR VGND sg13g2_decap_8
XFILLER_5_209 VPWR VGND sg13g2_decap_4
X_610_ Tile_X1Y0_S_XIF_middle.Inst_S_XIF_middle_switch_matrix.N2BEGb7 Tile_X1Y0_N2BEGb[7]
+ VPWR VGND sg13g2_buf_1
X_472_ Tile_X0Y0_FrameData[7] Tile_X0Y0_FrameStrobe[1] Tile_X0Y0_S_XIF_left.Inst_S_XIF_left_ConfigMem.Inst_frame1_bit7.Q
+ VPWR VGND sg13g2_dlhq_1
X_541_ Tile_X0Y0_S_XIF_left.Inst_S_XIF_left_switch_matrix.N4BEG3 Tile_X0Y0_N4BEG[3]
+ VPWR VGND sg13g2_buf_1
XFILLER_5_754 VPWR VGND sg13g2_fill_2
X_739_ Tile_X2Y0_S_XIF_right.Inst_S_XIF_right_switch_matrix.NN4BEG7 Tile_X2Y0_NN4BEG[7]
+ VPWR VGND sg13g2_buf_1
XFILLER_0_492 VPWR VGND sg13g2_decap_8
XFILLER_1_1153 VPWR VGND sg13g2_fill_1
XFILLER_8_581 VPWR VGND sg13g2_decap_8
XFILLER_6_1064 VPWR VGND sg13g2_decap_8
XFILLER_6_1075 VPWR VGND sg13g2_fill_2
XFILLER_1_234 VPWR VGND sg13g2_decap_8
XFILLER_2_724 VPWR VGND sg13g2_decap_8
X_455_ Tile_X0Y0_FrameData[24] Tile_X0Y0_FrameStrobe[1] Tile_X0Y0_S_XIF_left.Inst_S_XIF_left_ConfigMem.Inst_frame1_bit24.Q
+ VPWR VGND sg13g2_dlhq_1
X_524_ Tile_X0Y0_S2MID[5] Tile_X0Y0_N2BEG[2] VPWR VGND sg13g2_buf_1
X_386_ Tile_X0Y0_FrameData[29] Tile_X2Y0_FrameStrobe[1] Tile_X2Y0_S_XIF_right.Inst_S_XIF_right_ConfigMem.Inst_frame1_bit29.Q
+ VPWR VGND sg13g2_dlhq_1
XFILLER_11_49 VPWR VGND sg13g2_decap_8
XFILLER_8_1104 VPWR VGND sg13g2_fill_1
X_240_ Tile_X1Y0_S2MID[1] ISSUE_VALID_top Tile_X1Y0_S_XIF_middle.Inst_S_XIF_middle_ConfigMem.Inst_frame1_bit7.Q
+ Tile_X1Y0_S_XIF_middle.Inst_S_XIF_middle_switch_matrix.N2BEG6 VPWR VGND sg13g2_mux2_1
XFILLER_10_399 VPWR VGND sg13g2_fill_1
XFILLER_10_366 VPWR VGND sg13g2_decap_4
X_171_ Tile_X0Y0_SS4END[10] ISSUE_OPA_top26 Tile_X0Y0_S_XIF_left.Inst_S_XIF_left_ConfigMem.Inst_frame1_bit21.Q
+ Tile_X0Y0_S_XIF_left.Inst_S_XIF_left_switch_matrix.NN4BEG5 VPWR VGND sg13g2_mux2_1
XFILLER_2_554 VPWR VGND sg13g2_decap_8
X_507_ Tile_X0Y0_FrameStrobe[9] Tile_X0Y0_FrameStrobe_O[9] VPWR VGND sg13g2_buf_1
X_438_ Tile_X0Y0_FrameData[9] Tile_X0Y0_FrameStrobe[0] Tile_X0Y0_S_XIF_left.Inst_S_XIF_left_ConfigMem.Inst_frame0_bit9.Q
+ VPWR VGND sg13g2_dlhq_1
X_369_ Tile_X0Y0_FrameData[14] Tile_X2Y0_FrameStrobe[0] Tile_X2Y0_S_XIF_right.Inst_S_XIF_right_ConfigMem.Inst_frame0_bit14.Q
+ VPWR VGND sg13g2_dlhq_1
XFILLER_9_197 VPWR VGND sg13g2_fill_2
XFILLER_6_882 VPWR VGND sg13g2_decap_8
XFILLER_3_1012 VPWR VGND sg13g2_decap_8
XFILLER_11_119 VPWR VGND sg13g2_fill_1
XFILLER_11_108 VPWR VGND sg13g2_decap_8
XFILLER_3_1078 VPWR VGND sg13g2_decap_8
X_223_ _058_ VPWR RESULT_top29 VGND Tile_X0Y0_S_XIF_left.Inst_S_XIF_left_ConfigMem.Inst_frame0_bit27.Q
+ _059_ sg13g2_o21ai_1
XFILLER_8_28 VPWR VGND sg13g2_decap_8
XFILLER_7_602 VPWR VGND sg13g2_fill_2
X_085_ Tile_X2Y0_S4END[0] ISSUE_OPB_top0 Tile_X2Y0_S_XIF_right.Inst_S_XIF_right_ConfigMem.Inst_frame1_bit15.Q
+ Tile_X2Y0_S_XIF_right.Inst_S_XIF_right_switch_matrix.N4BEG15 VPWR VGND sg13g2_mux2_1
XFILLER_3_830 VPWR VGND sg13g2_decap_8
X_154_ Tile_X0Y0_S4END[11] ISSUE_OPA_top11 Tile_X0Y0_S_XIF_left.Inst_S_XIF_left_ConfigMem.Inst_frame1_bit4.Q
+ Tile_X0Y0_S_XIF_left.Inst_S_XIF_left_switch_matrix.N4BEG4 VPWR VGND sg13g2_mux2_1
XFILLER_6_112 VPWR VGND sg13g2_decap_8
XFILLER_6_178 VPWR VGND sg13g2_decap_8
XFILLER_2_351 VPWR VGND sg13g2_decap_8
XFILLER_0_1229 VPWR VGND sg13g2_decap_8
XFILLER_5_1118 VPWR VGND sg13g2_fill_2
XFILLER_10_1315 VPWR VGND sg13g2_fill_1
XFILLER_3_126 VPWR VGND sg13g2_decap_8
XFILLER_0_833 VPWR VGND sg13g2_decap_8
XFILLER_8_966 VPWR VGND sg13g2_decap_8
X_137_ _022_ VPWR RESULT_top11 VGND Tile_X2Y0_S_XIF_right.Inst_S_XIF_right_ConfigMem.Inst_frame0_bit23.Q
+ _023_ sg13g2_o21ai_1
X_206_ Tile_X0Y0_S_XIF_left.Inst_S_XIF_left_ConfigMem.Inst_frame0_bit16.Q VPWR _048_
+ VGND Tile_X0Y0_SS4END[8] Tile_X0Y0_S_XIF_left.Inst_S_XIF_left_ConfigMem.Inst_frame0_bit17.Q
+ sg13g2_o21ai_1
XFILLER_0_1015 VPWR VGND sg13g2_decap_8
XFILLER_4_1151 VPWR VGND sg13g2_fill_2
XFILLER_4_1184 VPWR VGND sg13g2_decap_4
XFILLER_0_84 VPWR VGND sg13g2_decap_8
XFILLER_10_1167 VPWR VGND sg13g2_decap_4
XFILLER_4_435 VPWR VGND sg13g2_decap_8
XFILLER_5_936 VPWR VGND sg13g2_decap_8
XFILLER_0_674 VPWR VGND sg13g2_decap_8
XFILLER_1_1302 VPWR VGND sg13g2_fill_1
X_686_ Tile_X2Y0_FrameStrobe[10] Tile_X2Y0_FrameStrobe_O[10] VPWR VGND sg13g2_buf_1
XFILLER_2_906 VPWR VGND sg13g2_decap_8
X_540_ Tile_X0Y0_S_XIF_left.Inst_S_XIF_left_switch_matrix.N4BEG2 Tile_X0Y0_N4BEG[2]
+ VPWR VGND sg13g2_buf_1
X_471_ Tile_X0Y0_FrameData[8] Tile_X0Y0_FrameStrobe[1] Tile_X0Y0_S_XIF_left.Inst_S_XIF_left_ConfigMem.Inst_frame1_bit8.Q
+ VPWR VGND sg13g2_dlhq_1
XFILLER_4_210 VPWR VGND sg13g2_decap_8
XFILLER_1_983 VPWR VGND sg13g2_fill_1
XFILLER_1_972 VPWR VGND sg13g2_decap_8
XFILLER_0_471 VPWR VGND sg13g2_decap_8
X_669_ Tile_X0Y0_FrameData[25] Tile_X2Y0_FrameData_O[25] VPWR VGND sg13g2_buf_1
X_738_ Tile_X2Y0_S_XIF_right.Inst_S_XIF_right_switch_matrix.NN4BEG6 Tile_X2Y0_NN4BEG[6]
+ VPWR VGND sg13g2_buf_1
XFILLER_1_1198 VPWR VGND sg13g2_fill_2
XFILLER_6_1043 VPWR VGND sg13g2_decap_8
XFILLER_2_703 VPWR VGND sg13g2_decap_8
X_523_ Tile_X0Y0_S2MID[6] Tile_X0Y0_N2BEG[1] VPWR VGND sg13g2_buf_1
X_385_ Tile_X0Y0_FrameData[30] Tile_X2Y0_FrameStrobe[1] Tile_X2Y0_S_XIF_right.Inst_S_XIF_right_ConfigMem.Inst_frame1_bit30.Q
+ VPWR VGND sg13g2_dlhq_1
X_454_ Tile_X0Y0_FrameData[25] Tile_X0Y0_FrameStrobe[1] Tile_X0Y0_S_XIF_left.Inst_S_XIF_left_ConfigMem.Inst_frame1_bit25.Q
+ VPWR VGND sg13g2_dlhq_1
XFILLER_7_1330 VPWR VGND sg13g2_fill_2
XFILLER_11_28 VPWR VGND sg13g2_decap_8
XFILLER_11_813 VPWR VGND sg13g2_fill_1
X_170_ Tile_X0Y0_SS4END[11] ISSUE_OPA_top27 Tile_X0Y0_S_XIF_left.Inst_S_XIF_left_ConfigMem.Inst_frame1_bit20.Q
+ Tile_X0Y0_S_XIF_left.Inst_S_XIF_left_switch_matrix.NN4BEG4 VPWR VGND sg13g2_mux2_1
XFILLER_11_879 VPWR VGND sg13g2_decap_8
XFILLER_2_533 VPWR VGND sg13g2_decap_8
X_506_ Tile_X0Y0_FrameStrobe[8] Tile_X0Y0_FrameStrobe_O[8] VPWR VGND sg13g2_buf_1
XFILLER_2_1293 VPWR VGND sg13g2_decap_8
XFILLER_9_176 VPWR VGND sg13g2_decap_8
XFILLER_9_143 VPWR VGND sg13g2_decap_8
X_299_ Tile_X1Y0_S2MID[3] Tile_X1Y0_S2END[3] Tile_X1Y0_S_XIF_middle.Inst_S_XIF_middle_ConfigMem.Inst_frame0_bit31.Q
+ RESULT_RD_top4 VPWR VGND sg13g2_mux2_1
X_368_ Tile_X0Y0_FrameData[15] Tile_X2Y0_FrameStrobe[0] Tile_X2Y0_S_XIF_right.Inst_S_XIF_right_ConfigMem.Inst_frame0_bit15.Q
+ VPWR VGND sg13g2_dlhq_1
X_437_ Tile_X0Y0_FrameData[10] Tile_X0Y0_FrameStrobe[0] Tile_X0Y0_S_XIF_left.Inst_S_XIF_left_ConfigMem.Inst_frame0_bit10.Q
+ VPWR VGND sg13g2_dlhq_1
XFILLER_5_360 VPWR VGND sg13g2_decap_8
XFILLER_6_861 VPWR VGND sg13g2_decap_8
XFILLER_3_84 VPWR VGND sg13g2_decap_8
X_153_ Tile_X0Y0_S4END[12] ISSUE_OPA_top12 Tile_X0Y0_S_XIF_left.Inst_S_XIF_left_ConfigMem.Inst_frame1_bit3.Q
+ Tile_X0Y0_S_XIF_left.Inst_S_XIF_left_switch_matrix.N4BEG3 VPWR VGND sg13g2_mux2_1
X_222_ _059_ Tile_X0Y0_S4END[13] Tile_X0Y0_S_XIF_left.Inst_S_XIF_left_ConfigMem.Inst_frame0_bit26.Q
+ VPWR VGND sg13g2_nand2b_1
X_084_ Tile_X2Y0_S4END[1] ISSUE_OPB_top1 Tile_X2Y0_S_XIF_right.Inst_S_XIF_right_ConfigMem.Inst_frame1_bit14.Q
+ Tile_X2Y0_S_XIF_right.Inst_S_XIF_right_switch_matrix.N4BEG14 VPWR VGND sg13g2_mux2_1
XFILLER_2_330 VPWR VGND sg13g2_decap_8
XFILLER_3_886 VPWR VGND sg13g2_decap_8
XFILLER_0_1208 VPWR VGND sg13g2_decap_8
XFILLER_10_1327 VPWR VGND sg13g2_decap_4
XFILLER_0_812 VPWR VGND sg13g2_decap_8
XFILLER_3_105 VPWR VGND sg13g2_decap_8
XFILLER_0_889 VPWR VGND sg13g2_decap_8
XFILLER_11_495 VPWR VGND sg13g2_decap_4
XFILLER_8_945 VPWR VGND sg13g2_decap_8
X_136_ _023_ Tile_X2Y0_S4END[11] Tile_X2Y0_S_XIF_right.Inst_S_XIF_right_ConfigMem.Inst_frame0_bit22.Q
+ VPWR VGND sg13g2_nand2b_1
X_205_ _046_ VPWR RESULT_top23 VGND Tile_X0Y0_S_XIF_left.Inst_S_XIF_left_ConfigMem.Inst_frame0_bit15.Q
+ _047_ sg13g2_o21ai_1
XFILLER_7_488 VPWR VGND sg13g2_decap_8
XFILLER_2_182 VPWR VGND sg13g2_decap_8
XFILLER_0_63 VPWR VGND sg13g2_decap_8
XFILLER_4_1130 VPWR VGND sg13g2_fill_1
XFILLER_1_609 VPWR VGND sg13g2_decap_8
XFILLER_0_119 VPWR VGND sg13g2_decap_8
XFILLER_4_414 VPWR VGND sg13g2_decap_8
XFILLER_5_915 VPWR VGND sg13g2_decap_8
XFILLER_0_653 VPWR VGND sg13g2_decap_8
X_685_ Tile_X2Y0_FrameStrobe[9] Tile_X2Y0_FrameStrobe_O[9] VPWR VGND sg13g2_buf_1
X_119_ _010_ VPWR RESULT_top5 VGND Tile_X2Y0_S_XIF_right.Inst_S_XIF_right_ConfigMem.Inst_frame0_bit11.Q
+ _011_ sg13g2_o21ai_1
XFILLER_4_992 VPWR VGND sg13g2_decap_8
XFILLER_6_1236 VPWR VGND sg13g2_fill_1
XFILLER_1_439 VPWR VGND sg13g2_fill_1
XFILLER_1_428 VPWR VGND sg13g2_decap_8
X_470_ Tile_X0Y0_FrameData[9] Tile_X0Y0_FrameStrobe[1] Tile_X0Y0_S_XIF_left.Inst_S_XIF_left_ConfigMem.Inst_frame1_bit9.Q
+ VPWR VGND sg13g2_dlhq_1
XFILLER_5_712 VPWR VGND sg13g2_fill_2
XFILLER_5_756 VPWR VGND sg13g2_fill_1
XFILLER_5_789 VPWR VGND sg13g2_decap_8
XFILLER_1_995 VPWR VGND sg13g2_decap_4
XFILLER_1_951 VPWR VGND sg13g2_fill_1
XFILLER_1_940 VPWR VGND sg13g2_decap_8
XFILLER_0_450 VPWR VGND sg13g2_decap_8
X_668_ Tile_X0Y0_FrameData[24] Tile_X2Y0_FrameData_O[24] VPWR VGND sg13g2_buf_1
X_599_ Tile_X1Y0_S_XIF_middle.Inst_S_XIF_middle_switch_matrix.N2BEG4 Tile_X1Y0_N2BEG[4]
+ VPWR VGND sg13g2_buf_1
X_737_ Tile_X2Y0_S_XIF_right.Inst_S_XIF_right_switch_matrix.NN4BEG5 Tile_X2Y0_NN4BEG[5]
+ VPWR VGND sg13g2_buf_1
XFILLER_6_84 VPWR VGND sg13g2_decap_8
XFILLER_6_1022 VPWR VGND sg13g2_decap_8
XFILLER_1_269 VPWR VGND sg13g2_decap_4
XFILLER_2_759 VPWR VGND sg13g2_decap_8
X_453_ Tile_X0Y0_FrameData[26] Tile_X0Y0_FrameStrobe[1] Tile_X0Y0_S_XIF_left.Inst_S_XIF_left_ConfigMem.Inst_frame1_bit26.Q
+ VPWR VGND sg13g2_dlhq_1
X_522_ Tile_X0Y0_S2MID[7] Tile_X0Y0_N2BEG[0] VPWR VGND sg13g2_buf_1
X_384_ Tile_X0Y0_FrameData[31] Tile_X2Y0_FrameStrobe[1] Tile_X2Y0_S_XIF_right.Inst_S_XIF_right_ConfigMem.Inst_frame1_bit31.Q
+ VPWR VGND sg13g2_dlhq_1
XFILLER_5_575 VPWR VGND sg13g2_decap_8
XFILLER_3_1228 VPWR VGND sg13g2_fill_2
XFILLER_9_892 VPWR VGND sg13g2_decap_8
XFILLER_11_858 VPWR VGND sg13g2_decap_8
XFILLER_7_829 VPWR VGND sg13g2_decap_8
XFILLER_2_512 VPWR VGND sg13g2_decap_8
XFILLER_2_589 VPWR VGND sg13g2_decap_8
X_505_ Tile_X0Y0_FrameStrobe[7] Tile_X0Y0_FrameStrobe_O[7] VPWR VGND sg13g2_buf_1
XFILLER_2_1272 VPWR VGND sg13g2_decap_8
X_436_ Tile_X0Y0_FrameData[11] Tile_X0Y0_FrameStrobe[0] Tile_X0Y0_S_XIF_left.Inst_S_XIF_left_ConfigMem.Inst_frame0_bit11.Q
+ VPWR VGND sg13g2_dlhq_1
XFILLER_9_155 VPWR VGND sg13g2_decap_8
X_367_ Tile_X0Y0_FrameData[16] Tile_X2Y0_FrameStrobe[0] Tile_X2Y0_S_XIF_right.Inst_S_XIF_right_ConfigMem.Inst_frame0_bit16.Q
+ VPWR VGND sg13g2_dlhq_1
X_298_ Tile_X1Y0_S2MID[4] Tile_X1Y0_S2END[4] Tile_X1Y0_S_XIF_middle.Inst_S_XIF_middle_ConfigMem.Inst_frame0_bit30.Q
+ RESULT_RD_top3 VPWR VGND sg13g2_mux2_1
XFILLER_6_840 VPWR VGND sg13g2_decap_8
XFILLER_3_63 VPWR VGND sg13g2_decap_8
XFILLER_3_1047 VPWR VGND sg13g2_decap_8
XFILLER_3_1058 VPWR VGND sg13g2_fill_2
X_152_ Tile_X0Y0_S4END[13] ISSUE_OPA_top13 Tile_X0Y0_S_XIF_left.Inst_S_XIF_left_ConfigMem.Inst_frame1_bit2.Q
+ Tile_X0Y0_S_XIF_left.Inst_S_XIF_left_switch_matrix.N4BEG2 VPWR VGND sg13g2_mux2_1
X_221_ Tile_X0Y0_S_XIF_left.Inst_S_XIF_left_ConfigMem.Inst_frame0_bit26.Q VPWR _058_
+ VGND Tile_X0Y0_SS4END[13] Tile_X0Y0_S_XIF_left.Inst_S_XIF_left_ConfigMem.Inst_frame0_bit27.Q
+ sg13g2_o21ai_1
X_083_ Tile_X2Y0_S4END[2] ISSUE_OPB_top2 Tile_X2Y0_S_XIF_right.Inst_S_XIF_right_ConfigMem.Inst_frame1_bit13.Q
+ Tile_X2Y0_S_XIF_right.Inst_S_XIF_right_switch_matrix.N4BEG13 VPWR VGND sg13g2_mux2_1
XFILLER_6_147 VPWR VGND sg13g2_fill_1
XFILLER_2_386 VPWR VGND sg13g2_decap_8
XFILLER_3_865 VPWR VGND sg13g2_decap_8
XFILLER_5_0 VPWR VGND sg13g2_decap_8
XFILLER_4_1323 VPWR VGND sg13g2_decap_8
X_419_ Tile_X0Y0_FrameData[28] Tile_X0Y0_FrameStrobe[0] Tile_X0Y0_S_XIF_left.Inst_S_XIF_left_ConfigMem.Inst_frame0_bit28.Q
+ VPWR VGND sg13g2_dlhq_1
XFILLER_9_1256 VPWR VGND sg13g2_fill_2
XFILLER_0_868 VPWR VGND sg13g2_decap_8
X_204_ _047_ Tile_X0Y0_S4END[7] Tile_X0Y0_S_XIF_left.Inst_S_XIF_left_ConfigMem.Inst_frame0_bit14.Q
+ VPWR VGND sg13g2_nand2b_1
XFILLER_11_474 VPWR VGND sg13g2_decap_8
XFILLER_8_924 VPWR VGND sg13g2_decap_8
X_135_ Tile_X2Y0_S_XIF_right.Inst_S_XIF_right_ConfigMem.Inst_frame0_bit22.Q VPWR _022_
+ VGND Tile_X2Y0_SS4END[11] Tile_X2Y0_S_XIF_right.Inst_S_XIF_right_ConfigMem.Inst_frame0_bit23.Q
+ sg13g2_o21ai_1
XFILLER_7_467 VPWR VGND sg13g2_decap_8
XFILLER_2_161 VPWR VGND sg13g2_decap_8
XFILLER_0_42 VPWR VGND sg13g2_decap_8
XFILLER_4_1153 VPWR VGND sg13g2_fill_1
XFILLER_9_84 VPWR VGND sg13g2_decap_8
XFILLER_7_990 VPWR VGND sg13g2_decap_8
XFILLER_9_1042 VPWR VGND sg13g2_fill_2
XFILLER_0_632 VPWR VGND sg13g2_decap_8
X_684_ Tile_X2Y0_FrameStrobe[8] Tile_X2Y0_FrameStrobe_O[8] VPWR VGND sg13g2_buf_1
XFILLER_11_293 VPWR VGND sg13g2_fill_1
X_118_ _011_ Tile_X2Y0_S4END[5] Tile_X2Y0_S_XIF_right.Inst_S_XIF_right_ConfigMem.Inst_frame0_bit10.Q
+ VPWR VGND sg13g2_nand2b_1
XFILLER_4_971 VPWR VGND sg13g2_decap_8
XFILLER_3_492 VPWR VGND sg13g2_decap_8
XFILLER_5_768 VPWR VGND sg13g2_decap_8
X_736_ Tile_X2Y0_S_XIF_right.Inst_S_XIF_right_switch_matrix.NN4BEG4 Tile_X2Y0_NN4BEG[4]
+ VPWR VGND sg13g2_buf_1
XFILLER_1_963 VPWR VGND sg13g2_decap_4
X_667_ Tile_X0Y0_FrameData[23] Tile_X2Y0_FrameData_O[23] VPWR VGND sg13g2_buf_1
XFILLER_1_1123 VPWR VGND sg13g2_decap_8
XFILLER_1_1134 VPWR VGND sg13g2_fill_2
XFILLER_5_1292 VPWR VGND sg13g2_decap_8
X_598_ Tile_X1Y0_S_XIF_middle.Inst_S_XIF_middle_switch_matrix.N2BEG3 Tile_X1Y0_N2BEG[3]
+ VPWR VGND sg13g2_buf_1
XANTENNA_1 VPWR VGND ISSUE_OPA_top0 sg13g2_antennanp
XFILLER_6_63 VPWR VGND sg13g2_decap_8
XFILLER_6_1001 VPWR VGND sg13g2_decap_8
XFILLER_10_539 VPWR VGND sg13g2_fill_1
XFILLER_9_7 VPWR VGND sg13g2_decap_8
XFILLER_1_204 VPWR VGND sg13g2_decap_8
XFILLER_1_215 VPWR VGND sg13g2_fill_1
XFILLER_2_738 VPWR VGND sg13g2_decap_8
XFILLER_1_248 VPWR VGND sg13g2_decap_4
X_521_ Tile_X0Y0_S1END[0] Tile_X0Y0_N1BEG[3] VPWR VGND sg13g2_buf_1
X_452_ Tile_X0Y0_FrameData[27] Tile_X0Y0_FrameStrobe[1] Tile_X0Y0_S_XIF_left.Inst_S_XIF_left_ConfigMem.Inst_frame1_bit27.Q
+ VPWR VGND sg13g2_dlhq_1
X_383_ Tile_X0Y0_FrameData[0] Tile_X2Y0_FrameStrobe[0] Tile_X2Y0_S_XIF_right.Inst_S_XIF_right_ConfigMem.Inst_frame0_bit0.Q
+ VPWR VGND sg13g2_dlhq_1
XFILLER_9_315 VPWR VGND sg13g2_decap_8
XFILLER_1_771 VPWR VGND sg13g2_fill_1
XFILLER_5_543 VPWR VGND sg13g2_fill_1
X_719_ Tile_X2Y0_S_XIF_right.Inst_S_XIF_right_switch_matrix.N4BEG3 Tile_X2Y0_N4BEG[3]
+ VPWR VGND sg13g2_buf_1
XFILLER_9_871 VPWR VGND sg13g2_decap_8
XFILLER_11_804 VPWR VGND sg13g2_fill_1
XFILLER_6_307 VPWR VGND sg13g2_fill_1
XFILLER_2_568 VPWR VGND sg13g2_decap_8
X_504_ Tile_X0Y0_FrameStrobe[6] Tile_X0Y0_FrameStrobe_O[6] VPWR VGND sg13g2_buf_1
X_366_ Tile_X0Y0_FrameData[17] Tile_X2Y0_FrameStrobe[0] Tile_X2Y0_S_XIF_right.Inst_S_XIF_right_ConfigMem.Inst_frame0_bit17.Q
+ VPWR VGND sg13g2_dlhq_1
XFILLER_2_1251 VPWR VGND sg13g2_decap_8
X_435_ Tile_X0Y0_FrameData[12] Tile_X0Y0_FrameStrobe[0] Tile_X0Y0_S_XIF_left.Inst_S_XIF_left_ConfigMem.Inst_frame0_bit12.Q
+ VPWR VGND sg13g2_dlhq_1
XFILLER_10_892 VPWR VGND sg13g2_decap_8
X_297_ Tile_X1Y0_S2MID[5] Tile_X1Y0_S2END[5] Tile_X1Y0_S_XIF_middle.Inst_S_XIF_middle_ConfigMem.Inst_frame0_bit29.Q
+ RESULT_RD_top2 VPWR VGND sg13g2_mux2_1
XFILLER_6_896 VPWR VGND sg13g2_decap_8
XFILLER_3_42 VPWR VGND sg13g2_decap_8
XFILLER_3_1026 VPWR VGND sg13g2_decap_8
X_220_ _056_ VPWR RESULT_top28 VGND Tile_X0Y0_S_XIF_left.Inst_S_XIF_left_ConfigMem.Inst_frame0_bit25.Q
+ _057_ sg13g2_o21ai_1
X_082_ Tile_X2Y0_S4END[3] ISSUE_OPB_top3 Tile_X2Y0_S_XIF_right.Inst_S_XIF_right_ConfigMem.Inst_frame1_bit12.Q
+ Tile_X2Y0_S_XIF_right.Inst_S_XIF_right_switch_matrix.N4BEG12 VPWR VGND sg13g2_mux2_1
XFILLER_6_126 VPWR VGND sg13g2_decap_8
XFILLER_6_159 VPWR VGND sg13g2_fill_1
X_151_ Tile_X0Y0_S4END[14] ISSUE_OPA_top14 Tile_X0Y0_S_XIF_left.Inst_S_XIF_left_ConfigMem.Inst_frame1_bit1.Q
+ Tile_X0Y0_S_XIF_left.Inst_S_XIF_left_switch_matrix.N4BEG1 VPWR VGND sg13g2_mux2_1
XFILLER_7_649 VPWR VGND sg13g2_decap_8
XFILLER_2_365 VPWR VGND sg13g2_decap_8
XFILLER_3_844 VPWR VGND sg13g2_decap_8
XFILLER_4_1302 VPWR VGND sg13g2_decap_8
XFILLER_2_1081 VPWR VGND sg13g2_decap_8
X_349_ Tile_X0Y0_FrameData[31] Tile_X1Y0_FrameStrobe[2] Tile_X1Y0_S_XIF_middle.Inst_S_XIF_middle_ConfigMem.Inst_frame2_bit31.Q
+ VPWR VGND sg13g2_dlhq_1
X_418_ Tile_X0Y0_FrameData[29] Tile_X0Y0_FrameStrobe[0] Tile_X0Y0_S_XIF_left.Inst_S_XIF_left_ConfigMem.Inst_frame0_bit29.Q
+ VPWR VGND sg13g2_dlhq_1
XFILLER_5_181 VPWR VGND sg13g2_decap_8
XFILLER_9_1224 VPWR VGND sg13g2_fill_2
XFILLER_0_847 VPWR VGND sg13g2_decap_8
XFILLER_11_453 VPWR VGND sg13g2_decap_8
XFILLER_8_903 VPWR VGND sg13g2_decap_8
X_203_ Tile_X0Y0_S_XIF_left.Inst_S_XIF_left_ConfigMem.Inst_frame0_bit14.Q VPWR _046_
+ VGND Tile_X0Y0_SS4END[7] Tile_X0Y0_S_XIF_left.Inst_S_XIF_left_ConfigMem.Inst_frame0_bit15.Q
+ sg13g2_o21ai_1
XFILLER_7_413 VPWR VGND sg13g2_decap_8
XFILLER_2_140 VPWR VGND sg13g2_decap_8
X_134_ _020_ VPWR RESULT_top10 VGND Tile_X2Y0_S_XIF_right.Inst_S_XIF_right_ConfigMem.Inst_frame0_bit21.Q
+ _021_ sg13g2_o21ai_1
XFILLER_7_446 VPWR VGND sg13g2_decap_8
XFILLER_0_1029 VPWR VGND sg13g2_decap_8
XFILLER_0_21 VPWR VGND sg13g2_decap_8
XFILLER_0_98 VPWR VGND sg13g2_decap_8
XFILLER_9_63 VPWR VGND sg13g2_decap_8
XFILLER_4_449 VPWR VGND sg13g2_decap_8
XFILLER_0_688 VPWR VGND sg13g2_decap_8
XFILLER_0_611 VPWR VGND sg13g2_decap_8
X_683_ Tile_X2Y0_FrameStrobe[7] Tile_X2Y0_FrameStrobe_O[7] VPWR VGND sg13g2_buf_1
XFILLER_1_1327 VPWR VGND sg13g2_decap_4
X_117_ Tile_X2Y0_S_XIF_right.Inst_S_XIF_right_ConfigMem.Inst_frame0_bit10.Q VPWR _010_
+ VGND Tile_X2Y0_SS4END[5] Tile_X2Y0_S_XIF_right.Inst_S_XIF_right_ConfigMem.Inst_frame0_bit11.Q
+ sg13g2_o21ai_1
XFILLER_7_221 VPWR VGND sg13g2_decap_8
XFILLER_7_232 VPWR VGND sg13g2_fill_1
XFILLER_7_254 VPWR VGND sg13g2_fill_1
XFILLER_3_471 VPWR VGND sg13g2_decap_8
XFILLER_4_950 VPWR VGND sg13g2_decap_8
XFILLER_1_419 VPWR VGND sg13g2_decap_4
XFILLER_9_519 VPWR VGND sg13g2_fill_1
XFILLER_1_931 VPWR VGND sg13g2_decap_4
X_735_ Tile_X2Y0_S_XIF_right.Inst_S_XIF_right_switch_matrix.NN4BEG3 Tile_X2Y0_NN4BEG[3]
+ VPWR VGND sg13g2_buf_1
XFILLER_1_1102 VPWR VGND sg13g2_decap_8
XFILLER_0_485 VPWR VGND sg13g2_decap_8
XFILLER_5_1271 VPWR VGND sg13g2_decap_8
X_666_ Tile_X0Y0_FrameData[22] Tile_X2Y0_FrameData_O[22] VPWR VGND sg13g2_buf_1
XFILLER_1_1146 VPWR VGND sg13g2_decap_8
X_597_ Tile_X1Y0_S_XIF_middle.Inst_S_XIF_middle_switch_matrix.N2BEG2 Tile_X1Y0_N2BEG[2]
+ VPWR VGND sg13g2_buf_1
XFILLER_8_574 VPWR VGND sg13g2_decap_8
XFILLER_6_42 VPWR VGND sg13g2_decap_8
XANTENNA_2 VPWR VGND ISSUE_OPA_top0 sg13g2_antennanp
XFILLER_6_1057 VPWR VGND sg13g2_decap_8
XFILLER_11_1298 VPWR VGND sg13g2_decap_8
XFILLER_1_227 VPWR VGND sg13g2_decap_8
XFILLER_2_717 VPWR VGND sg13g2_decap_8
X_520_ Tile_X0Y0_S1END[1] Tile_X0Y0_N1BEG[2] VPWR VGND sg13g2_buf_1
X_451_ Tile_X0Y0_FrameData[28] Tile_X0Y0_FrameStrobe[1] Tile_X0Y0_S_XIF_left.Inst_S_XIF_left_ConfigMem.Inst_frame1_bit28.Q
+ VPWR VGND sg13g2_dlhq_1
X_382_ Tile_X0Y0_FrameData[1] Tile_X2Y0_FrameStrobe[0] Tile_X2Y0_S_XIF_right.Inst_S_XIF_right_ConfigMem.Inst_frame0_bit1.Q
+ VPWR VGND sg13g2_dlhq_1
XFILLER_5_522 VPWR VGND sg13g2_decap_8
XFILLER_7_1300 VPWR VGND sg13g2_decap_8
XFILLER_0_282 VPWR VGND sg13g2_decap_8
X_718_ Tile_X2Y0_S_XIF_right.Inst_S_XIF_right_switch_matrix.N4BEG2 Tile_X2Y0_N4BEG[2]
+ VPWR VGND sg13g2_buf_1
X_649_ Tile_X0Y0_FrameData[5] Tile_X2Y0_FrameData_O[5] VPWR VGND sg13g2_buf_1
XFILLER_9_850 VPWR VGND sg13g2_decap_8
XFILLER_10_359 VPWR VGND sg13g2_decap_8
XFILLER_11_1062 VPWR VGND sg13g2_fill_1
XFILLER_11_1051 VPWR VGND sg13g2_decap_8
XFILLER_2_547 VPWR VGND sg13g2_decap_8
X_503_ Tile_X0Y0_FrameStrobe[5] Tile_X0Y0_FrameStrobe_O[5] VPWR VGND sg13g2_buf_1
XFILLER_2_1230 VPWR VGND sg13g2_decap_4
X_296_ Tile_X1Y0_S2MID[6] Tile_X1Y0_S2END[6] Tile_X1Y0_S_XIF_middle.Inst_S_XIF_middle_ConfigMem.Inst_frame0_bit28.Q
+ RESULT_RD_top1 VPWR VGND sg13g2_mux2_1
XFILLER_9_124 VPWR VGND sg13g2_fill_2
X_365_ Tile_X0Y0_FrameData[18] Tile_X2Y0_FrameStrobe[0] Tile_X2Y0_S_XIF_right.Inst_S_XIF_right_ConfigMem.Inst_frame0_bit18.Q
+ VPWR VGND sg13g2_dlhq_1
X_434_ Tile_X0Y0_FrameData[13] Tile_X0Y0_FrameStrobe[0] Tile_X0Y0_S_XIF_left.Inst_S_XIF_left_ConfigMem.Inst_frame0_bit13.Q
+ VPWR VGND sg13g2_dlhq_1
XFILLER_5_374 VPWR VGND sg13g2_decap_4
XFILLER_6_875 VPWR VGND sg13g2_decap_8
XFILLER_3_21 VPWR VGND sg13g2_decap_8
XFILLER_3_98 VPWR VGND sg13g2_decap_8
XFILLER_3_1005 VPWR VGND sg13g2_decap_8
X_150_ Tile_X2Y0_S4END[15] ISSUE_OPB_top15 Tile_X2Y0_S_XIF_right.Inst_S_XIF_right_ConfigMem.Inst_frame1_bit0.Q
+ Tile_X2Y0_S_XIF_right.Inst_S_XIF_right_switch_matrix.N4BEG0 VPWR VGND sg13g2_mux2_1
XFILLER_3_823 VPWR VGND sg13g2_decap_8
X_081_ Tile_X2Y0_S4END[4] ISSUE_OPB_top4 Tile_X2Y0_S_XIF_right.Inst_S_XIF_right_ConfigMem.Inst_frame1_bit11.Q
+ Tile_X2Y0_S_XIF_right.Inst_S_XIF_right_switch_matrix.N4BEG11 VPWR VGND sg13g2_mux2_1
XFILLER_6_105 VPWR VGND sg13g2_decap_8
XFILLER_7_628 VPWR VGND sg13g2_decap_4
XFILLER_2_344 VPWR VGND sg13g2_decap_8
XFILLER_2_1060 VPWR VGND sg13g2_decap_8
X_417_ Tile_X0Y0_FrameData[30] Tile_X0Y0_FrameStrobe[0] Tile_X0Y0_S_XIF_left.Inst_S_XIF_left_ConfigMem.Inst_frame0_bit30.Q
+ VPWR VGND sg13g2_dlhq_1
X_279_ Tile_X1Y0_SS4END[2] ISSUE_INSTR_top18 Tile_X1Y0_S_XIF_middle.Inst_S_XIF_middle_ConfigMem.Inst_frame0_bit14.Q
+ Tile_X1Y0_S_XIF_middle.Inst_S_XIF_middle_switch_matrix.NN4BEG13 VPWR VGND sg13g2_mux2_1
XFILLER_10_690 VPWR VGND sg13g2_decap_8
X_348_ Tile_X0Y0_FrameData[0] Tile_X1Y0_FrameStrobe[1] Tile_X1Y0_S_XIF_middle.Inst_S_XIF_middle_ConfigMem.Inst_frame1_bit0.Q
+ VPWR VGND sg13g2_dlhq_1
XFILLER_5_160 VPWR VGND sg13g2_decap_8
XFILLER_6_694 VPWR VGND sg13g2_fill_1
XFILLER_9_1258 VPWR VGND sg13g2_fill_1
XFILLER_3_119 VPWR VGND sg13g2_decap_8
XFILLER_0_826 VPWR VGND sg13g2_decap_8
XFILLER_8_959 VPWR VGND sg13g2_decap_8
X_202_ _044_ VPWR RESULT_top22 VGND Tile_X0Y0_S_XIF_left.Inst_S_XIF_left_ConfigMem.Inst_frame0_bit13.Q
+ _045_ sg13g2_o21ai_1
X_133_ _021_ Tile_X2Y0_S4END[10] Tile_X2Y0_S_XIF_right.Inst_S_XIF_right_ConfigMem.Inst_frame0_bit20.Q
+ VPWR VGND sg13g2_nand2b_1
XFILLER_0_1008 VPWR VGND sg13g2_decap_8
XFILLER_2_196 VPWR VGND sg13g2_decap_8
XFILLER_9_42 VPWR VGND sg13g2_decap_8
XFILLER_0_77 VPWR VGND sg13g2_decap_8
XFILLER_9_1044 VPWR VGND sg13g2_fill_1
XFILLER_9_1022 VPWR VGND sg13g2_fill_2
XFILLER_4_428 VPWR VGND sg13g2_decap_8
XFILLER_5_929 VPWR VGND sg13g2_decap_8
X_682_ Tile_X2Y0_FrameStrobe[6] Tile_X2Y0_FrameStrobe_O[6] VPWR VGND sg13g2_buf_1
XFILLER_0_667 VPWR VGND sg13g2_decap_8
XFILLER_8_767 VPWR VGND sg13g2_decap_4
XFILLER_8_756 VPWR VGND sg13g2_fill_1
X_116_ _008_ VPWR RESULT_top4 VGND Tile_X2Y0_S_XIF_right.Inst_S_XIF_right_ConfigMem.Inst_frame0_bit9.Q
+ _009_ sg13g2_o21ai_1
XFILLER_3_450 VPWR VGND sg13g2_decap_8
XFILLER_4_203 VPWR VGND sg13g2_decap_8
XFILLER_0_464 VPWR VGND sg13g2_decap_8
X_734_ Tile_X2Y0_S_XIF_right.Inst_S_XIF_right_switch_matrix.NN4BEG2 Tile_X2Y0_NN4BEG[2]
+ VPWR VGND sg13g2_buf_1
X_665_ Tile_X0Y0_FrameData[21] Tile_X2Y0_FrameData_O[21] VPWR VGND sg13g2_buf_1
X_596_ Tile_X1Y0_S_XIF_middle.Inst_S_XIF_middle_switch_matrix.N2BEG1 Tile_X1Y0_N2BEG[1]
+ VPWR VGND sg13g2_buf_1
XANTENNA_3 VPWR VGND ISSUE_OPA_top1 sg13g2_antennanp
XFILLER_6_21 VPWR VGND sg13g2_decap_8
XFILLER_6_98 VPWR VGND sg13g2_decap_8
XFILLER_6_1036 VPWR VGND sg13g2_decap_8
X_381_ Tile_X0Y0_FrameData[2] Tile_X2Y0_FrameStrobe[0] Tile_X2Y0_S_XIF_right.Inst_S_XIF_right_ConfigMem.Inst_frame0_bit2.Q
+ VPWR VGND sg13g2_dlhq_1
X_450_ Tile_X0Y0_FrameData[29] Tile_X0Y0_FrameStrobe[1] Tile_X0Y0_S_XIF_left.Inst_S_XIF_left_ConfigMem.Inst_frame1_bit29.Q
+ VPWR VGND sg13g2_dlhq_1
XFILLER_0_1180 VPWR VGND sg13g2_decap_8
XFILLER_5_501 VPWR VGND sg13g2_decap_8
XFILLER_5_589 VPWR VGND sg13g2_fill_1
X_717_ Tile_X2Y0_S_XIF_right.Inst_S_XIF_right_switch_matrix.N4BEG1 Tile_X2Y0_N4BEG[1]
+ VPWR VGND sg13g2_buf_1
X_648_ Tile_X0Y0_FrameData[4] Tile_X2Y0_FrameData_O[4] VPWR VGND sg13g2_buf_1
X_579_ Tile_X1Y0_FrameStrobe[8] Tile_X1Y0_FrameStrobe_O[8] VPWR VGND sg13g2_buf_1
XFILLER_8_394 VPWR VGND sg13g2_decap_8
XFILLER_11_1030 VPWR VGND sg13g2_decap_8
XFILLER_2_526 VPWR VGND sg13g2_decap_8
X_502_ Tile_X0Y0_FrameStrobe[4] Tile_X0Y0_FrameStrobe_O[4] VPWR VGND sg13g2_buf_1
XFILLER_2_1286 VPWR VGND sg13g2_decap_8
X_433_ Tile_X0Y0_FrameData[14] Tile_X0Y0_FrameStrobe[0] Tile_X0Y0_S_XIF_left.Inst_S_XIF_left_ConfigMem.Inst_frame0_bit14.Q
+ VPWR VGND sg13g2_dlhq_1
XFILLER_10_872 VPWR VGND sg13g2_decap_8
XFILLER_9_169 VPWR VGND sg13g2_fill_2
X_364_ Tile_X0Y0_FrameData[19] Tile_X2Y0_FrameStrobe[0] Tile_X2Y0_S_XIF_right.Inst_S_XIF_right_ConfigMem.Inst_frame0_bit19.Q
+ VPWR VGND sg13g2_dlhq_1
X_295_ Tile_X1Y0_S2MID[7] Tile_X1Y0_S2END[7] Tile_X1Y0_S_XIF_middle.Inst_S_XIF_middle_ConfigMem.Inst_frame0_bit27.Q
+ RESULT_RD_top0 VPWR VGND sg13g2_mux2_1
XFILLER_6_854 VPWR VGND sg13g2_decap_8
XFILLER_7_1175 VPWR VGND sg13g2_fill_2
XFILLER_3_77 VPWR VGND sg13g2_decap_8
X_080_ Tile_X2Y0_S4END[5] ISSUE_OPB_top5 Tile_X2Y0_S_XIF_right.Inst_S_XIF_right_ConfigMem.Inst_frame1_bit10.Q
+ Tile_X2Y0_S_XIF_right.Inst_S_XIF_right_switch_matrix.N4BEG10 VPWR VGND sg13g2_mux2_1
XFILLER_2_323 VPWR VGND sg13g2_decap_8
XFILLER_3_802 VPWR VGND sg13g2_decap_8
XFILLER_3_879 VPWR VGND sg13g2_decap_8
XFILLER_4_1315 VPWR VGND sg13g2_fill_1
X_416_ Tile_X0Y0_FrameData[31] Tile_X0Y0_FrameStrobe[0] Tile_X0Y0_S_XIF_left.Inst_S_XIF_left_ConfigMem.Inst_frame0_bit31.Q
+ VPWR VGND sg13g2_dlhq_1
X_278_ Tile_X1Y0_SS4END[3] ISSUE_INSTR_top19 Tile_X1Y0_S_XIF_middle.Inst_S_XIF_middle_ConfigMem.Inst_frame0_bit13.Q
+ Tile_X1Y0_S_XIF_middle.Inst_S_XIF_middle_switch_matrix.NN4BEG12 VPWR VGND sg13g2_mux2_1
X_347_ Tile_X0Y0_FrameData[1] Tile_X1Y0_FrameStrobe[1] Tile_X1Y0_S_XIF_middle.Inst_S_XIF_middle_ConfigMem.Inst_frame1_bit1.Q
+ VPWR VGND sg13g2_dlhq_1
XFILLER_0_805 VPWR VGND sg13g2_decap_8
XFILLER_11_499 VPWR VGND sg13g2_fill_2
XFILLER_11_488 VPWR VGND sg13g2_decap_8
XFILLER_8_938 VPWR VGND sg13g2_decap_8
X_132_ Tile_X2Y0_S_XIF_right.Inst_S_XIF_right_ConfigMem.Inst_frame0_bit20.Q VPWR _020_
+ VGND Tile_X2Y0_SS4END[10] Tile_X2Y0_S_XIF_right.Inst_S_XIF_right_ConfigMem.Inst_frame0_bit21.Q
+ sg13g2_o21ai_1
X_201_ _045_ Tile_X0Y0_S4END[6] Tile_X0Y0_S_XIF_left.Inst_S_XIF_left_ConfigMem.Inst_frame0_bit12.Q
+ VPWR VGND sg13g2_nand2b_1
XFILLER_2_175 VPWR VGND sg13g2_decap_8
XFILLER_3_0 VPWR VGND sg13g2_decap_8
XFILLER_3_632 VPWR VGND sg13g2_fill_2
XFILLER_8_1292 VPWR VGND sg13g2_decap_8
XFILLER_0_56 VPWR VGND sg13g2_decap_8
XFILLER_9_21 VPWR VGND sg13g2_decap_8
XFILLER_9_98 VPWR VGND sg13g2_fill_2
XFILLER_6_492 VPWR VGND sg13g2_decap_8
XFILLER_9_1001 VPWR VGND sg13g2_fill_1
XFILLER_4_407 VPWR VGND sg13g2_decap_8
XFILLER_5_908 VPWR VGND sg13g2_decap_8
XFILLER_10_1128 VPWR VGND sg13g2_fill_2
XFILLER_10_1117 VPWR VGND sg13g2_fill_1
XFILLER_0_646 VPWR VGND sg13g2_decap_8
X_681_ Tile_X2Y0_FrameStrobe[5] Tile_X2Y0_FrameStrobe_O[5] VPWR VGND sg13g2_buf_1
X_115_ _009_ Tile_X2Y0_S4END[4] Tile_X2Y0_S_XIF_right.Inst_S_XIF_right_ConfigMem.Inst_frame0_bit8.Q
+ VPWR VGND sg13g2_nand2b_1
XFILLER_4_985 VPWR VGND sg13g2_decap_8
XFILLER_4_237 VPWR VGND sg13g2_decap_8
XFILLER_1_999 VPWR VGND sg13g2_fill_1
XFILLER_1_988 VPWR VGND sg13g2_decap_8
XFILLER_0_443 VPWR VGND sg13g2_decap_8
X_733_ Tile_X2Y0_S_XIF_right.Inst_S_XIF_right_switch_matrix.NN4BEG1 Tile_X2Y0_NN4BEG[1]
+ VPWR VGND sg13g2_buf_1
X_664_ Tile_X0Y0_FrameData[20] Tile_X2Y0_FrameData_O[20] VPWR VGND sg13g2_buf_1
X_595_ Tile_X1Y0_S_XIF_middle.Inst_S_XIF_middle_switch_matrix.N2BEG0 Tile_X1Y0_N2BEG[0]
+ VPWR VGND sg13g2_buf_1
XFILLER_4_782 VPWR VGND sg13g2_decap_8
XANTENNA_4 VPWR VGND ISSUE_OPA_top10 sg13g2_antennanp
XFILLER_6_77 VPWR VGND sg13g2_decap_8
XFILLER_6_1015 VPWR VGND sg13g2_decap_8
XFILLER_11_1267 VPWR VGND sg13g2_decap_4
X_380_ Tile_X0Y0_FrameData[3] Tile_X2Y0_FrameStrobe[0] Tile_X2Y0_S_XIF_right.Inst_S_XIF_right_ConfigMem.Inst_frame0_bit3.Q
+ VPWR VGND sg13g2_dlhq_1
XFILLER_5_568 VPWR VGND sg13g2_decap_8
X_716_ Tile_X2Y0_S_XIF_right.Inst_S_XIF_right_switch_matrix.N4BEG0 Tile_X2Y0_N4BEG[0]
+ VPWR VGND sg13g2_buf_1
XFILLER_1_796 VPWR VGND sg13g2_decap_8
X_578_ Tile_X1Y0_FrameStrobe[7] Tile_X1Y0_FrameStrobe_O[7] VPWR VGND sg13g2_buf_1
X_647_ Tile_X0Y0_FrameData[3] Tile_X2Y0_FrameData_O[3] VPWR VGND sg13g2_buf_1
XFILLER_9_885 VPWR VGND sg13g2_decap_8
XFILLER_4_590 VPWR VGND sg13g2_decap_8
.ends
