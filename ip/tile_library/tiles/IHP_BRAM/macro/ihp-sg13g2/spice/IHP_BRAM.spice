* NGSPICE file created from IHP_BRAM.ext - technology: ihp-sg13g2

* Black-box entry subcircuit for sg13g2_fill_1 abstract view
.subckt sg13g2_fill_1 VDD VSS
.ends

* Black-box entry subcircuit for sg13g2_decap_4 abstract view
.subckt sg13g2_decap_4 VDD VSS
.ends

* Black-box entry subcircuit for sg13g2_dlhq_1 abstract view
.subckt sg13g2_dlhq_1 D GATE Q VDD VSS
.ends

* Black-box entry subcircuit for sg13g2_o21ai_1 abstract view
.subckt sg13g2_o21ai_1 B1 VDD Y VSS A1 A2
.ends

* Black-box entry subcircuit for sg13g2_inv_1 abstract view
.subckt sg13g2_inv_1 VDD Y A VSS
.ends

* Black-box entry subcircuit for sg13g2_decap_8 abstract view
.subckt sg13g2_decap_8 VDD VSS
.ends

* Black-box entry subcircuit for sg13g2_mux4_1 abstract view
.subckt sg13g2_mux4_1 S0 A0 A1 A2 A3 S1 X VDD VSS
.ends

* Black-box entry subcircuit for sg13g2_buf_1 abstract view
.subckt sg13g2_buf_1 A X VDD VSS
.ends

* Black-box entry subcircuit for sg13g2_fill_2 abstract view
.subckt sg13g2_fill_2 VDD VSS
.ends

* Black-box entry subcircuit for sg13g2_mux2_1 abstract view
.subckt sg13g2_mux2_1 A0 A1 S X VDD VSS
.ends

* Black-box entry subcircuit for sg13g2_a21oi_1 abstract view
.subckt sg13g2_a21oi_1 VSS VDD A1 A2 Y B1
.ends

* Black-box entry subcircuit for sg13g2_nor2_1 abstract view
.subckt sg13g2_nor2_1 A B Y VDD VSS
.ends

* Black-box entry subcircuit for sg13g2_antennanp abstract view
.subckt sg13g2_antennanp VDD VSS A
.ends

* Black-box entry subcircuit for sg13g2_nor3_1 abstract view
.subckt sg13g2_nor3_1 A B C Y VDD VSS
.ends

* Black-box entry subcircuit for sg13g2_nand2_1 abstract view
.subckt sg13g2_nand2_1 Y A B VDD VSS
.ends

* Black-box entry subcircuit for sg13g2_nand2b_1 abstract view
.subckt sg13g2_nand2b_1 Y B A_N VDD VSS
.ends

* Black-box entry subcircuit for sg13g2_a221oi_1 abstract view
.subckt sg13g2_a221oi_1 VDD VSS B2 C1 B1 A1 Y A2
.ends

* Black-box entry subcircuit for sg13g2_nor2b_1 abstract view
.subckt sg13g2_nor2b_1 A B_N Y VDD VSS
.ends

* Black-box entry subcircuit for sg13g2_a21o_1 abstract view
.subckt sg13g2_a21o_1 A2 A1 B1 X VDD VSS
.ends

* Black-box entry subcircuit for sg13g2_tielo abstract view
.subckt sg13g2_tielo VDD VSS L_LO
.ends

* Black-box entry subcircuit for sg13g2_nand3b_1 abstract view
.subckt sg13g2_nand3b_1 B C Y VDD VSS A_N
.ends

* Black-box entry subcircuit for sg13g2_tiehi abstract view
.subckt sg13g2_tiehi VDD VSS L_HI
.ends

* Black-box entry subcircuit for sg13g2_buf_8 abstract view
.subckt sg13g2_buf_8 A X VDD VSS
.ends

* Black-box entry subcircuit for sg13g2_nand4_1 abstract view
.subckt sg13g2_nand4_1 B C A Y VDD VSS D
.ends

* Black-box entry subcircuit for sg13g2_or2_1 abstract view
.subckt sg13g2_or2_1 VSS VDD X B A
.ends

* Black-box entry subcircuit for sg13g2_or3_1 abstract view
.subckt sg13g2_or3_1 A B C X VDD VSS
.ends

* Black-box entry subcircuit for sg13g2_and2_1 abstract view
.subckt sg13g2_and2_1 A B X VDD VSS
.ends

.subckt IHP_BRAM A_ADDR_BRAM0 A_ADDR_BRAM1 A_ADDR_BRAM2 A_ADDR_BRAM3 A_ADDR_BRAM4
+ A_ADDR_BRAM5 A_ADDR_BRAM6 A_ADDR_BRAM7 A_ADDR_BRAM8 A_ADDR_BRAM9 A_BM_BRAM0 A_BM_BRAM1
+ A_BM_BRAM10 A_BM_BRAM11 A_BM_BRAM12 A_BM_BRAM13 A_BM_BRAM14 A_BM_BRAM15 A_BM_BRAM2
+ A_BM_BRAM3 A_BM_BRAM4 A_BM_BRAM5 A_BM_BRAM6 A_BM_BRAM7 A_BM_BRAM8 A_BM_BRAM9 A_CLK_BRAM
+ A_DIN_BRAM0 A_DIN_BRAM1 A_DIN_BRAM10 A_DIN_BRAM11 A_DIN_BRAM12 A_DIN_BRAM13 A_DIN_BRAM14
+ A_DIN_BRAM15 A_DIN_BRAM2 A_DIN_BRAM3 A_DIN_BRAM4 A_DIN_BRAM5 A_DIN_BRAM6 A_DIN_BRAM7
+ A_DIN_BRAM8 A_DIN_BRAM9 A_DOUT_BRAM0 A_DOUT_BRAM1 A_DOUT_BRAM10 A_DOUT_BRAM11 A_DOUT_BRAM12
+ A_DOUT_BRAM13 A_DOUT_BRAM14 A_DOUT_BRAM15 A_DOUT_BRAM2 A_DOUT_BRAM3 A_DOUT_BRAM4
+ A_DOUT_BRAM5 A_DOUT_BRAM6 A_DOUT_BRAM7 A_DOUT_BRAM8 A_DOUT_BRAM9 A_MEN_BRAM A_REN_BRAM
+ A_TIE_HIGH_BRAM A_TIE_LOW_BRAM A_WEN_BRAM B_ADDR_BRAM0 B_ADDR_BRAM1 B_ADDR_BRAM2
+ B_ADDR_BRAM3 B_ADDR_BRAM4 B_ADDR_BRAM5 B_ADDR_BRAM6 B_ADDR_BRAM7 B_ADDR_BRAM8 B_ADDR_BRAM9
+ B_BM_BRAM0 B_BM_BRAM1 B_BM_BRAM10 B_BM_BRAM11 B_BM_BRAM12 B_BM_BRAM13 B_BM_BRAM14
+ B_BM_BRAM15 B_BM_BRAM2 B_BM_BRAM3 B_BM_BRAM4 B_BM_BRAM5 B_BM_BRAM6 B_BM_BRAM7 B_BM_BRAM8
+ B_BM_BRAM9 B_CLK_BRAM B_DIN_BRAM0 B_DIN_BRAM1 B_DIN_BRAM10 B_DIN_BRAM11 B_DIN_BRAM12
+ B_DIN_BRAM13 B_DIN_BRAM14 B_DIN_BRAM15 B_DIN_BRAM2 B_DIN_BRAM3 B_DIN_BRAM4 B_DIN_BRAM5
+ B_DIN_BRAM6 B_DIN_BRAM7 B_DIN_BRAM8 B_DIN_BRAM9 B_DOUT_BRAM0 B_DOUT_BRAM1 B_DOUT_BRAM10
+ B_DOUT_BRAM11 B_DOUT_BRAM12 B_DOUT_BRAM13 B_DOUT_BRAM14 B_DOUT_BRAM15 B_DOUT_BRAM2
+ B_DOUT_BRAM3 B_DOUT_BRAM4 B_DOUT_BRAM5 B_DOUT_BRAM6 B_DOUT_BRAM7 B_DOUT_BRAM8 B_DOUT_BRAM9
+ B_MEN_BRAM B_REN_BRAM B_TIE_HIGH_BRAM B_TIE_LOW_BRAM B_WEN_BRAM CONFIGURED_top Tile_X0Y0_E1END[0]
+ Tile_X0Y0_E1END[1] Tile_X0Y0_E1END[2] Tile_X0Y0_E1END[3] Tile_X0Y0_E2END[0] Tile_X0Y0_E2END[1]
+ Tile_X0Y0_E2END[2] Tile_X0Y0_E2END[3] Tile_X0Y0_E2END[4] Tile_X0Y0_E2END[5] Tile_X0Y0_E2END[6]
+ Tile_X0Y0_E2END[7] Tile_X0Y0_E2MID[0] Tile_X0Y0_E2MID[1] Tile_X0Y0_E2MID[2] Tile_X0Y0_E2MID[3]
+ Tile_X0Y0_E2MID[4] Tile_X0Y0_E2MID[5] Tile_X0Y0_E2MID[6] Tile_X0Y0_E2MID[7] Tile_X0Y0_E6END[0]
+ Tile_X0Y0_E6END[10] Tile_X0Y0_E6END[11] Tile_X0Y0_E6END[1] Tile_X0Y0_E6END[2] Tile_X0Y0_E6END[3]
+ Tile_X0Y0_E6END[4] Tile_X0Y0_E6END[5] Tile_X0Y0_E6END[6] Tile_X0Y0_E6END[7] Tile_X0Y0_E6END[8]
+ Tile_X0Y0_E6END[9] Tile_X0Y0_EE4END[0] Tile_X0Y0_EE4END[10] Tile_X0Y0_EE4END[11]
+ Tile_X0Y0_EE4END[12] Tile_X0Y0_EE4END[13] Tile_X0Y0_EE4END[14] Tile_X0Y0_EE4END[15]
+ Tile_X0Y0_EE4END[1] Tile_X0Y0_EE4END[2] Tile_X0Y0_EE4END[3] Tile_X0Y0_EE4END[4]
+ Tile_X0Y0_EE4END[5] Tile_X0Y0_EE4END[6] Tile_X0Y0_EE4END[7] Tile_X0Y0_EE4END[8]
+ Tile_X0Y0_EE4END[9] Tile_X0Y0_FrameData[0] Tile_X0Y0_FrameData[10] Tile_X0Y0_FrameData[11]
+ Tile_X0Y0_FrameData[12] Tile_X0Y0_FrameData[13] Tile_X0Y0_FrameData[14] Tile_X0Y0_FrameData[15]
+ Tile_X0Y0_FrameData[16] Tile_X0Y0_FrameData[17] Tile_X0Y0_FrameData[18] Tile_X0Y0_FrameData[19]
+ Tile_X0Y0_FrameData[1] Tile_X0Y0_FrameData[20] Tile_X0Y0_FrameData[21] Tile_X0Y0_FrameData[22]
+ Tile_X0Y0_FrameData[23] Tile_X0Y0_FrameData[24] Tile_X0Y0_FrameData[25] Tile_X0Y0_FrameData[26]
+ Tile_X0Y0_FrameData[27] Tile_X0Y0_FrameData[28] Tile_X0Y0_FrameData[29] Tile_X0Y0_FrameData[2]
+ Tile_X0Y0_FrameData[30] Tile_X0Y0_FrameData[31] Tile_X0Y0_FrameData[3] Tile_X0Y0_FrameData[4]
+ Tile_X0Y0_FrameData[5] Tile_X0Y0_FrameData[6] Tile_X0Y0_FrameData[7] Tile_X0Y0_FrameData[8]
+ Tile_X0Y0_FrameData[9] Tile_X0Y0_FrameData_O[0] Tile_X0Y0_FrameData_O[10] Tile_X0Y0_FrameData_O[11]
+ Tile_X0Y0_FrameData_O[12] Tile_X0Y0_FrameData_O[13] Tile_X0Y0_FrameData_O[14] Tile_X0Y0_FrameData_O[15]
+ Tile_X0Y0_FrameData_O[16] Tile_X0Y0_FrameData_O[17] Tile_X0Y0_FrameData_O[18] Tile_X0Y0_FrameData_O[19]
+ Tile_X0Y0_FrameData_O[1] Tile_X0Y0_FrameData_O[20] Tile_X0Y0_FrameData_O[21] Tile_X0Y0_FrameData_O[22]
+ Tile_X0Y0_FrameData_O[23] Tile_X0Y0_FrameData_O[24] Tile_X0Y0_FrameData_O[25] Tile_X0Y0_FrameData_O[26]
+ Tile_X0Y0_FrameData_O[27] Tile_X0Y0_FrameData_O[28] Tile_X0Y0_FrameData_O[29] Tile_X0Y0_FrameData_O[2]
+ Tile_X0Y0_FrameData_O[30] Tile_X0Y0_FrameData_O[31] Tile_X0Y0_FrameData_O[3] Tile_X0Y0_FrameData_O[4]
+ Tile_X0Y0_FrameData_O[5] Tile_X0Y0_FrameData_O[6] Tile_X0Y0_FrameData_O[7] Tile_X0Y0_FrameData_O[8]
+ Tile_X0Y0_FrameData_O[9] Tile_X0Y0_FrameStrobe_O[0] Tile_X0Y0_FrameStrobe_O[10]
+ Tile_X0Y0_FrameStrobe_O[11] Tile_X0Y0_FrameStrobe_O[12] Tile_X0Y0_FrameStrobe_O[13]
+ Tile_X0Y0_FrameStrobe_O[14] Tile_X0Y0_FrameStrobe_O[15] Tile_X0Y0_FrameStrobe_O[16]
+ Tile_X0Y0_FrameStrobe_O[17] Tile_X0Y0_FrameStrobe_O[18] Tile_X0Y0_FrameStrobe_O[19]
+ Tile_X0Y0_FrameStrobe_O[1] Tile_X0Y0_FrameStrobe_O[2] Tile_X0Y0_FrameStrobe_O[3]
+ Tile_X0Y0_FrameStrobe_O[4] Tile_X0Y0_FrameStrobe_O[5] Tile_X0Y0_FrameStrobe_O[6]
+ Tile_X0Y0_FrameStrobe_O[7] Tile_X0Y0_FrameStrobe_O[8] Tile_X0Y0_FrameStrobe_O[9]
+ Tile_X0Y0_N1BEG[0] Tile_X0Y0_N1BEG[1] Tile_X0Y0_N1BEG[2] Tile_X0Y0_N1BEG[3] Tile_X0Y0_N2BEG[0]
+ Tile_X0Y0_N2BEG[1] Tile_X0Y0_N2BEG[2] Tile_X0Y0_N2BEG[3] Tile_X0Y0_N2BEG[4] Tile_X0Y0_N2BEG[5]
+ Tile_X0Y0_N2BEG[6] Tile_X0Y0_N2BEG[7] Tile_X0Y0_N2BEGb[0] Tile_X0Y0_N2BEGb[1] Tile_X0Y0_N2BEGb[2]
+ Tile_X0Y0_N2BEGb[3] Tile_X0Y0_N2BEGb[4] Tile_X0Y0_N2BEGb[5] Tile_X0Y0_N2BEGb[6]
+ Tile_X0Y0_N2BEGb[7] Tile_X0Y0_N4BEG[0] Tile_X0Y0_N4BEG[10] Tile_X0Y0_N4BEG[11] Tile_X0Y0_N4BEG[12]
+ Tile_X0Y0_N4BEG[13] Tile_X0Y0_N4BEG[14] Tile_X0Y0_N4BEG[15] Tile_X0Y0_N4BEG[1] Tile_X0Y0_N4BEG[2]
+ Tile_X0Y0_N4BEG[3] Tile_X0Y0_N4BEG[4] Tile_X0Y0_N4BEG[5] Tile_X0Y0_N4BEG[6] Tile_X0Y0_N4BEG[7]
+ Tile_X0Y0_N4BEG[8] Tile_X0Y0_N4BEG[9] Tile_X0Y0_S1END[0] Tile_X0Y0_S1END[1] Tile_X0Y0_S1END[2]
+ Tile_X0Y0_S1END[3] Tile_X0Y0_S2END[0] Tile_X0Y0_S2END[1] Tile_X0Y0_S2END[2] Tile_X0Y0_S2END[3]
+ Tile_X0Y0_S2END[4] Tile_X0Y0_S2END[5] Tile_X0Y0_S2END[6] Tile_X0Y0_S2END[7] Tile_X0Y0_S2MID[0]
+ Tile_X0Y0_S2MID[1] Tile_X0Y0_S2MID[2] Tile_X0Y0_S2MID[3] Tile_X0Y0_S2MID[4] Tile_X0Y0_S2MID[5]
+ Tile_X0Y0_S2MID[6] Tile_X0Y0_S2MID[7] Tile_X0Y0_S4END[0] Tile_X0Y0_S4END[10] Tile_X0Y0_S4END[11]
+ Tile_X0Y0_S4END[12] Tile_X0Y0_S4END[13] Tile_X0Y0_S4END[14] Tile_X0Y0_S4END[15]
+ Tile_X0Y0_S4END[1] Tile_X0Y0_S4END[2] Tile_X0Y0_S4END[3] Tile_X0Y0_S4END[4] Tile_X0Y0_S4END[5]
+ Tile_X0Y0_S4END[6] Tile_X0Y0_S4END[7] Tile_X0Y0_S4END[8] Tile_X0Y0_S4END[9] Tile_X0Y0_UserCLKo
+ Tile_X0Y0_W1BEG[0] Tile_X0Y0_W1BEG[1] Tile_X0Y0_W1BEG[2] Tile_X0Y0_W1BEG[3] Tile_X0Y0_W2BEG[0]
+ Tile_X0Y0_W2BEG[1] Tile_X0Y0_W2BEG[2] Tile_X0Y0_W2BEG[3] Tile_X0Y0_W2BEG[4] Tile_X0Y0_W2BEG[5]
+ Tile_X0Y0_W2BEG[6] Tile_X0Y0_W2BEG[7] Tile_X0Y0_W2BEGb[0] Tile_X0Y0_W2BEGb[1] Tile_X0Y0_W2BEGb[2]
+ Tile_X0Y0_W2BEGb[3] Tile_X0Y0_W2BEGb[4] Tile_X0Y0_W2BEGb[5] Tile_X0Y0_W2BEGb[6]
+ Tile_X0Y0_W2BEGb[7] Tile_X0Y0_W6BEG[0] Tile_X0Y0_W6BEG[10] Tile_X0Y0_W6BEG[11] Tile_X0Y0_W6BEG[1]
+ Tile_X0Y0_W6BEG[2] Tile_X0Y0_W6BEG[3] Tile_X0Y0_W6BEG[4] Tile_X0Y0_W6BEG[5] Tile_X0Y0_W6BEG[6]
+ Tile_X0Y0_W6BEG[7] Tile_X0Y0_W6BEG[8] Tile_X0Y0_W6BEG[9] Tile_X0Y0_WW4BEG[0] Tile_X0Y0_WW4BEG[10]
+ Tile_X0Y0_WW4BEG[11] Tile_X0Y0_WW4BEG[12] Tile_X0Y0_WW4BEG[13] Tile_X0Y0_WW4BEG[14]
+ Tile_X0Y0_WW4BEG[15] Tile_X0Y0_WW4BEG[1] Tile_X0Y0_WW4BEG[2] Tile_X0Y0_WW4BEG[3]
+ Tile_X0Y0_WW4BEG[4] Tile_X0Y0_WW4BEG[5] Tile_X0Y0_WW4BEG[6] Tile_X0Y0_WW4BEG[7]
+ Tile_X0Y0_WW4BEG[8] Tile_X0Y0_WW4BEG[9] Tile_X0Y1_E1END[0] Tile_X0Y1_E1END[1] Tile_X0Y1_E1END[2]
+ Tile_X0Y1_E1END[3] Tile_X0Y1_E2END[0] Tile_X0Y1_E2END[1] Tile_X0Y1_E2END[2] Tile_X0Y1_E2END[3]
+ Tile_X0Y1_E2END[4] Tile_X0Y1_E2END[5] Tile_X0Y1_E2END[6] Tile_X0Y1_E2END[7] Tile_X0Y1_E2MID[0]
+ Tile_X0Y1_E2MID[1] Tile_X0Y1_E2MID[2] Tile_X0Y1_E2MID[3] Tile_X0Y1_E2MID[4] Tile_X0Y1_E2MID[5]
+ Tile_X0Y1_E2MID[6] Tile_X0Y1_E2MID[7] Tile_X0Y1_E6END[0] Tile_X0Y1_E6END[10] Tile_X0Y1_E6END[11]
+ Tile_X0Y1_E6END[1] Tile_X0Y1_E6END[2] Tile_X0Y1_E6END[3] Tile_X0Y1_E6END[4] Tile_X0Y1_E6END[5]
+ Tile_X0Y1_E6END[6] Tile_X0Y1_E6END[7] Tile_X0Y1_E6END[8] Tile_X0Y1_E6END[9] Tile_X0Y1_EE4END[0]
+ Tile_X0Y1_EE4END[10] Tile_X0Y1_EE4END[11] Tile_X0Y1_EE4END[12] Tile_X0Y1_EE4END[13]
+ Tile_X0Y1_EE4END[14] Tile_X0Y1_EE4END[15] Tile_X0Y1_EE4END[1] Tile_X0Y1_EE4END[2]
+ Tile_X0Y1_EE4END[3] Tile_X0Y1_EE4END[4] Tile_X0Y1_EE4END[5] Tile_X0Y1_EE4END[6]
+ Tile_X0Y1_EE4END[7] Tile_X0Y1_EE4END[8] Tile_X0Y1_EE4END[9] Tile_X0Y1_FrameData[0]
+ Tile_X0Y1_FrameData[10] Tile_X0Y1_FrameData[11] Tile_X0Y1_FrameData[12] Tile_X0Y1_FrameData[13]
+ Tile_X0Y1_FrameData[14] Tile_X0Y1_FrameData[15] Tile_X0Y1_FrameData[16] Tile_X0Y1_FrameData[17]
+ Tile_X0Y1_FrameData[18] Tile_X0Y1_FrameData[19] Tile_X0Y1_FrameData[1] Tile_X0Y1_FrameData[20]
+ Tile_X0Y1_FrameData[21] Tile_X0Y1_FrameData[22] Tile_X0Y1_FrameData[23] Tile_X0Y1_FrameData[24]
+ Tile_X0Y1_FrameData[25] Tile_X0Y1_FrameData[26] Tile_X0Y1_FrameData[27] Tile_X0Y1_FrameData[28]
+ Tile_X0Y1_FrameData[29] Tile_X0Y1_FrameData[2] Tile_X0Y1_FrameData[30] Tile_X0Y1_FrameData[31]
+ Tile_X0Y1_FrameData[3] Tile_X0Y1_FrameData[4] Tile_X0Y1_FrameData[5] Tile_X0Y1_FrameData[6]
+ Tile_X0Y1_FrameData[7] Tile_X0Y1_FrameData[8] Tile_X0Y1_FrameData[9] Tile_X0Y1_FrameData_O[0]
+ Tile_X0Y1_FrameData_O[10] Tile_X0Y1_FrameData_O[11] Tile_X0Y1_FrameData_O[12] Tile_X0Y1_FrameData_O[13]
+ Tile_X0Y1_FrameData_O[14] Tile_X0Y1_FrameData_O[15] Tile_X0Y1_FrameData_O[16] Tile_X0Y1_FrameData_O[17]
+ Tile_X0Y1_FrameData_O[18] Tile_X0Y1_FrameData_O[19] Tile_X0Y1_FrameData_O[1] Tile_X0Y1_FrameData_O[20]
+ Tile_X0Y1_FrameData_O[21] Tile_X0Y1_FrameData_O[22] Tile_X0Y1_FrameData_O[23] Tile_X0Y1_FrameData_O[24]
+ Tile_X0Y1_FrameData_O[25] Tile_X0Y1_FrameData_O[26] Tile_X0Y1_FrameData_O[27] Tile_X0Y1_FrameData_O[28]
+ Tile_X0Y1_FrameData_O[29] Tile_X0Y1_FrameData_O[2] Tile_X0Y1_FrameData_O[30] Tile_X0Y1_FrameData_O[31]
+ Tile_X0Y1_FrameData_O[3] Tile_X0Y1_FrameData_O[4] Tile_X0Y1_FrameData_O[5] Tile_X0Y1_FrameData_O[6]
+ Tile_X0Y1_FrameData_O[7] Tile_X0Y1_FrameData_O[8] Tile_X0Y1_FrameData_O[9] Tile_X0Y1_FrameStrobe[0]
+ Tile_X0Y1_FrameStrobe[10] Tile_X0Y1_FrameStrobe[11] Tile_X0Y1_FrameStrobe[12] Tile_X0Y1_FrameStrobe[13]
+ Tile_X0Y1_FrameStrobe[14] Tile_X0Y1_FrameStrobe[15] Tile_X0Y1_FrameStrobe[16] Tile_X0Y1_FrameStrobe[17]
+ Tile_X0Y1_FrameStrobe[18] Tile_X0Y1_FrameStrobe[19] Tile_X0Y1_FrameStrobe[1] Tile_X0Y1_FrameStrobe[2]
+ Tile_X0Y1_FrameStrobe[3] Tile_X0Y1_FrameStrobe[4] Tile_X0Y1_FrameStrobe[5] Tile_X0Y1_FrameStrobe[6]
+ Tile_X0Y1_FrameStrobe[7] Tile_X0Y1_FrameStrobe[8] Tile_X0Y1_FrameStrobe[9] Tile_X0Y1_N1END[0]
+ Tile_X0Y1_N1END[1] Tile_X0Y1_N1END[2] Tile_X0Y1_N1END[3] Tile_X0Y1_N2END[0] Tile_X0Y1_N2END[1]
+ Tile_X0Y1_N2END[2] Tile_X0Y1_N2END[3] Tile_X0Y1_N2END[4] Tile_X0Y1_N2END[5] Tile_X0Y1_N2END[6]
+ Tile_X0Y1_N2END[7] Tile_X0Y1_N2MID[0] Tile_X0Y1_N2MID[1] Tile_X0Y1_N2MID[2] Tile_X0Y1_N2MID[3]
+ Tile_X0Y1_N2MID[4] Tile_X0Y1_N2MID[5] Tile_X0Y1_N2MID[6] Tile_X0Y1_N2MID[7] Tile_X0Y1_N4END[0]
+ Tile_X0Y1_N4END[10] Tile_X0Y1_N4END[11] Tile_X0Y1_N4END[12] Tile_X0Y1_N4END[13]
+ Tile_X0Y1_N4END[14] Tile_X0Y1_N4END[15] Tile_X0Y1_N4END[1] Tile_X0Y1_N4END[2] Tile_X0Y1_N4END[3]
+ Tile_X0Y1_N4END[4] Tile_X0Y1_N4END[5] Tile_X0Y1_N4END[6] Tile_X0Y1_N4END[7] Tile_X0Y1_N4END[8]
+ Tile_X0Y1_N4END[9] Tile_X0Y1_S1BEG[0] Tile_X0Y1_S1BEG[1] Tile_X0Y1_S1BEG[2] Tile_X0Y1_S1BEG[3]
+ Tile_X0Y1_S2BEG[0] Tile_X0Y1_S2BEG[1] Tile_X0Y1_S2BEG[2] Tile_X0Y1_S2BEG[3] Tile_X0Y1_S2BEG[4]
+ Tile_X0Y1_S2BEG[5] Tile_X0Y1_S2BEG[6] Tile_X0Y1_S2BEG[7] Tile_X0Y1_S2BEGb[0] Tile_X0Y1_S2BEGb[1]
+ Tile_X0Y1_S2BEGb[2] Tile_X0Y1_S2BEGb[3] Tile_X0Y1_S2BEGb[4] Tile_X0Y1_S2BEGb[5]
+ Tile_X0Y1_S2BEGb[6] Tile_X0Y1_S2BEGb[7] Tile_X0Y1_S4BEG[0] Tile_X0Y1_S4BEG[10] Tile_X0Y1_S4BEG[11]
+ Tile_X0Y1_S4BEG[12] Tile_X0Y1_S4BEG[13] Tile_X0Y1_S4BEG[14] Tile_X0Y1_S4BEG[15]
+ Tile_X0Y1_S4BEG[1] Tile_X0Y1_S4BEG[2] Tile_X0Y1_S4BEG[3] Tile_X0Y1_S4BEG[4] Tile_X0Y1_S4BEG[5]
+ Tile_X0Y1_S4BEG[6] Tile_X0Y1_S4BEG[7] Tile_X0Y1_S4BEG[8] Tile_X0Y1_S4BEG[9] Tile_X0Y1_UserCLK
+ Tile_X0Y1_W1BEG[0] Tile_X0Y1_W1BEG[1] Tile_X0Y1_W1BEG[2] Tile_X0Y1_W1BEG[3] Tile_X0Y1_W2BEG[0]
+ Tile_X0Y1_W2BEG[1] Tile_X0Y1_W2BEG[2] Tile_X0Y1_W2BEG[3] Tile_X0Y1_W2BEG[4] Tile_X0Y1_W2BEG[5]
+ Tile_X0Y1_W2BEG[6] Tile_X0Y1_W2BEG[7] Tile_X0Y1_W2BEGb[0] Tile_X0Y1_W2BEGb[1] Tile_X0Y1_W2BEGb[2]
+ Tile_X0Y1_W2BEGb[3] Tile_X0Y1_W2BEGb[4] Tile_X0Y1_W2BEGb[5] Tile_X0Y1_W2BEGb[6]
+ Tile_X0Y1_W2BEGb[7] Tile_X0Y1_W6BEG[0] Tile_X0Y1_W6BEG[10] Tile_X0Y1_W6BEG[11] Tile_X0Y1_W6BEG[1]
+ Tile_X0Y1_W6BEG[2] Tile_X0Y1_W6BEG[3] Tile_X0Y1_W6BEG[4] Tile_X0Y1_W6BEG[5] Tile_X0Y1_W6BEG[6]
+ Tile_X0Y1_W6BEG[7] Tile_X0Y1_W6BEG[8] Tile_X0Y1_W6BEG[9] Tile_X0Y1_WW4BEG[0] Tile_X0Y1_WW4BEG[10]
+ Tile_X0Y1_WW4BEG[11] Tile_X0Y1_WW4BEG[12] Tile_X0Y1_WW4BEG[13] Tile_X0Y1_WW4BEG[14]
+ Tile_X0Y1_WW4BEG[15] Tile_X0Y1_WW4BEG[1] Tile_X0Y1_WW4BEG[2] Tile_X0Y1_WW4BEG[3]
+ Tile_X0Y1_WW4BEG[4] Tile_X0Y1_WW4BEG[5] Tile_X0Y1_WW4BEG[6] Tile_X0Y1_WW4BEG[7]
+ Tile_X0Y1_WW4BEG[8] Tile_X0Y1_WW4BEG[9] VGND VPWR
XFILLER_54_203 VPWR VGND sg13g2_fill_1
XFILLER_93_58 VPWR VGND sg13g2_decap_4
XFILLER_42_62 VPWR VGND sg13g2_decap_4
X_1270_ Tile_X0Y0_FrameData[21] Tile_X0Y1_FrameStrobe[7] Tile_X0Y0_IHP_BRAM_top.Inst_IHP_BRAM_top_ConfigMem.Inst_frame7_bit21.Q
+ VPWR VGND sg13g2_dlhq_1
X_1606_ Tile_X0Y1_FrameData[5] Tile_X0Y1_FrameStrobe[7] Tile_X0Y1_IHP_BRAM_bot.Inst_IHP_BRAM_bot_ConfigMem.Inst_frame7_bit5.Q
+ VPWR VGND sg13g2_dlhq_1
X_0985_ Tile_X0Y1_IHP_BRAM_bot.Inst_IHP_BRAM_bot_ConfigMem.Inst_frame7_bit3.Q VPWR
+ _0330_ VGND Tile_X0Y1_IHP_BRAM_bot.Inst_IHP_BRAM_bot_ConfigMem.Inst_frame7_bit2.Q
+ Tile_X0Y1_IHP_BRAM_bot.Inst_IHP_BRAM_bot_switch_matrix.J_NS4_BEG14 sg13g2_o21ai_1
X_0419_ VPWR _0042_ Tile_X0Y0_IHP_BRAM_top.Inst_IHP_BRAM_top_switch_matrix.J_NS2_BEG1
+ VGND sg13g2_inv_1
XFILLER_86_125 VPWR VGND sg13g2_decap_8
X_1537_ Tile_X0Y1_FrameData[10] Tile_X0Y1_FrameStrobe[5] Tile_X0Y1_IHP_BRAM_bot.Inst_IHP_BRAM_bot_ConfigMem.Inst_frame5_bit10.Q
+ VPWR VGND sg13g2_dlhq_1
X_1468_ Tile_X0Y1_FrameData[15] Tile_X0Y1_FrameStrobe[3] Tile_X0Y1_IHP_BRAM_bot.Inst_IHP_BRAM_bot_ConfigMem.Inst_frame3_bit15.Q
+ VPWR VGND sg13g2_dlhq_1
XFILLER_47_29 VPWR VGND sg13g2_decap_8
X_1399_ Tile_X0Y1_FrameData[20] Tile_X0Y1_FrameStrobe[1] Tile_X0Y1_IHP_BRAM_bot.Inst_IHP_BRAM_bot_ConfigMem.Inst_frame1_bit20.Q
+ VPWR VGND sg13g2_dlhq_1
XFILLER_12_43 VPWR VGND sg13g2_fill_1
XFILLER_77_169 VPWR VGND sg13g2_fill_1
X_0770_ Tile_X0Y1_IHP_BRAM_bot.Inst_IHP_BRAM_bot_ConfigMem.Inst_frame8_bit6.Q Tile_X0Y1_E1END[1]
+ Tile_X0Y1_E6END[9] Tile_X0Y1_IHP_BRAM_bot.Inst_IHP_BRAM_bot_switch_matrix.J_NS4_BEG13
+ _0085_ Tile_X0Y1_IHP_BRAM_bot.Inst_IHP_BRAM_bot_ConfigMem.Inst_frame8_bit7.Q Tile_X0Y1_IHP_BRAM_bot.Inst_IHP_BRAM_bot_switch_matrix.S1BEG1
+ VPWR VGND sg13g2_mux4_1
X_1322_ Tile_X0Y0_FrameData[1] Tile_X0Y1_FrameStrobe[8] Tile_X0Y0_IHP_BRAM_top.Inst_IHP_BRAM_top_ConfigMem.Inst_frame8_bit1.Q
+ VPWR VGND sg13g2_dlhq_1
X_1253_ Tile_X0Y0_FrameData[6] Tile_X0Y1_FrameStrobe[6] Tile_X0Y0_IHP_BRAM_top.Inst_IHP_BRAM_top_ConfigMem.Inst_frame6_bit6.Q
+ VPWR VGND sg13g2_dlhq_1
X_1184_ Tile_X0Y0_FrameData[11] Tile_X0Y1_FrameStrobe[4] Tile_X0Y0_IHP_BRAM_top.Inst_IHP_BRAM_top_ConfigMem.Inst_frame4_bit11.Q
+ VPWR VGND sg13g2_dlhq_1
XFILLER_91_161 VPWR VGND sg13g2_decap_8
X_0968_ Tile_X0Y1_IHP_BRAM_bot.Inst_IHP_BRAM_bot_ConfigMem.Inst_frame7_bit0.Q VPWR
+ _0314_ VGND Tile_X0Y1_E6END[5] Tile_X0Y1_IHP_BRAM_bot.Inst_IHP_BRAM_bot_ConfigMem.Inst_frame8_bit31.Q
+ sg13g2_o21ai_1
Xoutput220 net220 Tile_X0Y0_WW4BEG[15] VPWR VGND sg13g2_buf_1
Xoutput253 net253 Tile_X0Y1_FrameData_O[30] VPWR VGND sg13g2_buf_1
Xoutput242 net242 Tile_X0Y1_FrameData_O[20] VPWR VGND sg13g2_buf_1
Xoutput264 net264 Tile_X0Y1_S1BEG[2] VPWR VGND sg13g2_buf_1
Xoutput286 net286 Tile_X0Y1_S4BEG[13] VPWR VGND sg13g2_buf_1
Xoutput275 net275 Tile_X0Y1_S2BEGb[1] VPWR VGND sg13g2_buf_1
X_0899_ Tile_X0Y1_IHP_BRAM_bot.Inst_IHP_BRAM_bot_ConfigMem.Inst_frame2_bit12.Q Tile_X0Y1_EE4END[2]
+ Tile_X0Y1_EE4END[10] Tile_X0Y1_E6END[10] Tile_X0Y1_IHP_BRAM_bot.Inst_IHP_BRAM_bot_switch_matrix.J_NS4_BEG10
+ Tile_X0Y1_IHP_BRAM_bot.Inst_IHP_BRAM_bot_ConfigMem.Inst_frame2_bit13.Q net82 VPWR
+ VGND sg13g2_mux4_1
Xoutput231 net231 Tile_X0Y1_FrameData_O[10] VPWR VGND sg13g2_buf_1
Xoutput297 net297 Tile_X0Y1_S4BEG[9] VPWR VGND sg13g2_buf_1
XFILLER_82_172 VPWR VGND sg13g2_fill_1
XFILLER_99_57 VPWR VGND sg13g2_fill_2
XFILLER_23_53 VPWR VGND sg13g2_fill_1
XFILLER_23_75 VPWR VGND sg13g2_fill_1
XFILLER_48_61 VPWR VGND sg13g2_decap_8
X_1871_ Tile_X0Y0_S4END[8] net282 VPWR VGND sg13g2_buf_1
X_0822_ Tile_X0Y1_IHP_BRAM_bot.Inst_IHP_BRAM_bot_ConfigMem.Inst_frame5_bit8.Q A_DOUT_BRAM0
+ B_DOUT_BRAM4 _0230_ _0104_ Tile_X0Y1_IHP_BRAM_bot.Inst_IHP_BRAM_bot_ConfigMem.Inst_frame5_bit9.Q
+ Tile_X0Y1_IHP_BRAM_bot.Inst_IHP_BRAM_bot_switch_matrix.WW4BEG12 VPWR VGND sg13g2_mux4_1
X_0684_ Tile_X0Y0_IHP_BRAM_top.Inst_IHP_BRAM_top_switch_matrix.J_NS4_BEG7 Tile_X0Y0_IHP_BRAM_top.Inst_IHP_BRAM_top_switch_matrix.J_NS4_BEG11
+ Tile_X0Y0_IHP_BRAM_top.Inst_IHP_BRAM_top_ConfigMem.Inst_frame8_bit1.Q _0157_ VPWR
+ VGND sg13g2_mux2_1
X_0753_ _0215_ VPWR _0216_ VGND Tile_X0Y0_E2MID[3] Tile_X0Y0_IHP_BRAM_top.Inst_IHP_BRAM_top_ConfigMem.Inst_frame1_bit4.Q
+ sg13g2_o21ai_1
X_1236_ Tile_X0Y0_FrameData[23] Tile_X0Y1_FrameStrobe[6] Tile_X0Y0_IHP_BRAM_top.Inst_IHP_BRAM_top_ConfigMem.Inst_frame6_bit23.Q
+ VPWR VGND sg13g2_dlhq_1
X_1305_ Tile_X0Y0_FrameData[18] Tile_X0Y1_FrameStrobe[8] Tile_X0Y0_IHP_BRAM_top.Inst_IHP_BRAM_top_ConfigMem.Inst_frame8_bit18.Q
+ VPWR VGND sg13g2_dlhq_1
X_1167_ Tile_X0Y0_FrameData[28] Tile_X0Y1_FrameStrobe[4] Tile_X0Y0_IHP_BRAM_top.Inst_IHP_BRAM_top_ConfigMem.Inst_frame4_bit28.Q
+ VPWR VGND sg13g2_dlhq_1
X_1098_ Tile_X0Y0_FrameData[1] Tile_X0Y1_FrameStrobe[1] Tile_X0Y0_IHP_BRAM_top.Inst_IHP_BRAM_top_ConfigMem.Inst_frame1_bit1.Q
+ VPWR VGND sg13g2_dlhq_1
XFILLER_47_106 VPWR VGND sg13g2_fill_2
XFILLER_34_96 VPWR VGND sg13g2_decap_8
XFILLER_109_174 VPWR VGND sg13g2_fill_2
XFILLER_75_70 VPWR VGND sg13g2_fill_2
X_1021_ VGND VPWR _0037_ _0363_ _0364_ _0038_ sg13g2_a21oi_1
XFILLER_46_194 VPWR VGND sg13g2_fill_2
X_1785_ Tile_X0Y0_IHP_BRAM_top.Inst_IHP_BRAM_top_switch_matrix.W2BEGb2 net196 VPWR
+ VGND sg13g2_buf_1
X_0805_ Tile_X0Y1_IHP_BRAM_bot.Inst_IHP_BRAM_bot_ConfigMem.Inst_frame1_bit30.Q Tile_X0Y1_N1END[3]
+ Tile_X0Y1_N4END[3] _0097_ Tile_X0Y0_S4END[7] Tile_X0Y1_IHP_BRAM_bot.Inst_IHP_BRAM_bot_ConfigMem.Inst_frame1_bit31.Q
+ Tile_X0Y1_IHP_BRAM_bot.Inst_IHP_BRAM_bot_switch_matrix.J_NS4_BEG11 VPWR VGND sg13g2_mux4_1
X_1923_ Tile_X0Y1_IHP_BRAM_bot.Inst_IHP_BRAM_bot_switch_matrix.WW4BEG4 net340 VPWR
+ VGND sg13g2_buf_1
X_1854_ Tile_X0Y1_IHP_BRAM_bot.Inst_IHP_BRAM_bot_switch_matrix.S1BEG3 net265 VPWR
+ VGND sg13g2_buf_1
X_0667_ _0140_ _0142_ Tile_X0Y0_IHP_BRAM_top.Inst_IHP_BRAM_top_switch_matrix.N4BEG0
+ VPWR VGND sg13g2_nor2_1
X_0598_ Tile_X0Y0_IHP_BRAM_top.Inst_IHP_BRAM_top_ConfigMem.Inst_frame4_bit8.Q Tile_X0Y0_EE4END[0]
+ Tile_X0Y0_EE4END[8] Tile_X0Y0_E6END[0] Tile_X0Y0_IHP_BRAM_top.Inst_IHP_BRAM_top_switch_matrix.J_NS4_BEG0
+ Tile_X0Y0_IHP_BRAM_top.Inst_IHP_BRAM_top_ConfigMem.Inst_frame4_bit9.Q net42 VPWR
+ VGND sg13g2_mux4_1
X_0736_ VGND VPWR Tile_X0Y0_IHP_BRAM_top.Inst_IHP_BRAM_top_ConfigMem.Inst_frame2_bit29.Q
+ _0198_ _0200_ _0199_ sg13g2_a21oi_1
X_1219_ Tile_X0Y0_FrameData[8] Tile_X0Y1_FrameStrobe[5] Tile_X0Y0_IHP_BRAM_top.Inst_IHP_BRAM_top_ConfigMem.Inst_frame5_bit8.Q
+ VPWR VGND sg13g2_dlhq_1
XFILLER_37_150 VPWR VGND sg13g2_fill_1
XFILLER_37_172 VPWR VGND sg13g2_fill_1
XFILLER_20_43 VPWR VGND sg13g2_fill_2
XFILLER_106_199 VPWR VGND sg13g2_fill_1
XFILLER_96_58 VPWR VGND sg13g2_decap_4
XFILLER_75_201 VPWR VGND sg13g2_fill_2
XFILLER_29_30 VPWR VGND sg13g2_decap_8
XFILLER_43_131 VPWR VGND sg13g2_fill_2
XFILLER_45_40 VPWR VGND sg13g2_fill_2
X_0521_ Tile_X0Y0_IHP_BRAM_top.Inst_IHP_BRAM_top_ConfigMem.Inst_frame9_bit19.Q Tile_X0Y0_E2MID[2]
+ Tile_X0Y0_E6END[2] Tile_X0Y0_E2END[2] Tile_X0Y0_IHP_BRAM_top.Inst_IHP_BRAM_top_switch_matrix.J_NS2_BEG5
+ Tile_X0Y0_IHP_BRAM_top.Inst_IHP_BRAM_top_ConfigMem.Inst_frame9_bit18.Q Tile_X0Y0_IHP_BRAM_top.Inst_IHP_BRAM_top_switch_matrix.N2BEG5
+ VPWR VGND sg13g2_mux4_1
X_1570_ Tile_X0Y1_FrameData[9] Tile_X0Y1_FrameStrobe[6] Tile_X0Y1_IHP_BRAM_bot.Inst_IHP_BRAM_bot_ConfigMem.Inst_frame6_bit9.Q
+ VPWR VGND sg13g2_dlhq_1
XANTENNA_5 VPWR VGND Tile_X0Y0_S2MID[1] sg13g2_antennanp
X_0452_ Tile_X0Y1_IHP_BRAM_bot.Inst_IHP_BRAM_bot_ConfigMem.Inst_frame3_bit22.Q VPWR
+ _0068_ VGND Tile_X0Y1_IHP_BRAM_bot.Inst_IHP_BRAM_bot_ConfigMem.Inst_frame3_bit23.Q
+ _0067_ sg13g2_o21ai_1
X_0383_ VPWR _0006_ Tile_X0Y0_S2MID[2] VGND sg13g2_inv_1
XFILLER_96_0 VPWR VGND sg13g2_fill_1
X_1004_ Tile_X0Y1_IHP_BRAM_bot.Inst_IHP_BRAM_bot_ConfigMem.Inst_frame3_bit19.Q Tile_X0Y1_IHP_BRAM_bot.Inst_IHP_BRAM_bot_ConfigMem.Inst_frame3_bit20.Q
+ _0346_ _0347_ VPWR VGND sg13g2_nor3_1
X_1768_ Tile_X0Y0_IHP_BRAM_top.Inst_IHP_BRAM_top_switch_matrix.N4BEG2 net170 VPWR
+ VGND sg13g2_buf_1
X_1837_ Tile_X0Y1_FrameData[18] net239 VPWR VGND sg13g2_buf_1
X_1906_ Tile_X0Y1_IHP_BRAM_bot.Inst_IHP_BRAM_bot_switch_matrix.W2BEGb7 net317 VPWR
+ VGND sg13g2_buf_1
X_1699_ Tile_X0Y0_FrameData[17] net101 VPWR VGND sg13g2_buf_1
X_0719_ Tile_X0Y0_IHP_BRAM_top.Inst_IHP_BRAM_top_ConfigMem.Inst_frame7_bit7.Q VPWR
+ _0188_ VGND _0186_ _0187_ sg13g2_o21ai_1
XFILLER_25_131 VPWR VGND sg13g2_fill_2
Xoutput31 net31 A_DIN_BRAM11 VPWR VGND sg13g2_buf_1
Xoutput20 net20 A_BM_BRAM3 VPWR VGND sg13g2_buf_1
Xoutput42 net42 A_DIN_BRAM8 VPWR VGND sg13g2_buf_1
Xoutput75 net75 B_DIN_BRAM1 VPWR VGND sg13g2_buf_1
Xoutput53 net53 B_ADDR_BRAM6 VPWR VGND sg13g2_buf_1
Xoutput7 net7 A_ADDR_BRAM6 VPWR VGND sg13g2_buf_1
Xoutput64 net64 B_BM_BRAM15 VPWR VGND sg13g2_buf_1
XFILLER_102_180 VPWR VGND sg13g2_fill_1
Xoutput97 net97 Tile_X0Y0_FrameData_O[13] VPWR VGND sg13g2_buf_1
Xoutput86 net86 B_DIN_BRAM6 VPWR VGND sg13g2_buf_1
XFILLER_31_156 VPWR VGND sg13g2_fill_2
X_1622_ Tile_X0Y1_FrameData[21] Tile_X0Y1_FrameStrobe[8] Tile_X0Y1_IHP_BRAM_bot.Inst_IHP_BRAM_bot_ConfigMem.Inst_frame8_bit21.Q
+ VPWR VGND sg13g2_dlhq_1
XFILLER_98_123 VPWR VGND sg13g2_fill_2
X_0435_ _0055_ Tile_X0Y0_IHP_BRAM_top.Inst_IHP_BRAM_top_ConfigMem.Inst_frame1_bit1.Q
+ Tile_X0Y0_S2MID[0] VPWR VGND sg13g2_nand2_1
X_1553_ Tile_X0Y1_FrameData[26] Tile_X0Y1_FrameStrobe[6] Tile_X0Y1_IHP_BRAM_bot.Inst_IHP_BRAM_bot_ConfigMem.Inst_frame6_bit26.Q
+ VPWR VGND sg13g2_dlhq_1
X_1484_ Tile_X0Y1_FrameData[31] Tile_X0Y1_FrameStrobe[4] Tile_X0Y1_IHP_BRAM_bot.Inst_IHP_BRAM_bot_ConfigMem.Inst_frame4_bit31.Q
+ VPWR VGND sg13g2_dlhq_1
X_0504_ Tile_X0Y1_IHP_BRAM_bot.Inst_IHP_BRAM_bot_ConfigMem.Inst_frame9_bit13.Q Tile_X0Y1_E2MID[5]
+ Tile_X0Y1_E6END[5] Tile_X0Y1_E2END[5] _0103_ Tile_X0Y1_IHP_BRAM_bot.Inst_IHP_BRAM_bot_ConfigMem.Inst_frame9_bit12.Q
+ Tile_X0Y0_IHP_BRAM_top.Inst_IHP_BRAM_top_switch_matrix.N2BEGb2 VPWR VGND sg13g2_mux4_1
XFILLER_11_0 VPWR VGND sg13g2_fill_1
X_0984_ _0033_ _0046_ _0329_ VPWR VGND sg13g2_nor2_1
X_1536_ Tile_X0Y1_FrameData[11] Tile_X0Y1_FrameStrobe[5] Tile_X0Y1_IHP_BRAM_bot.Inst_IHP_BRAM_bot_ConfigMem.Inst_frame5_bit11.Q
+ VPWR VGND sg13g2_dlhq_1
X_1605_ Tile_X0Y1_FrameData[6] Tile_X0Y1_FrameStrobe[7] Tile_X0Y1_IHP_BRAM_bot.Inst_IHP_BRAM_bot_ConfigMem.Inst_frame7_bit6.Q
+ VPWR VGND sg13g2_dlhq_1
X_0418_ VPWR _0041_ Tile_X0Y0_IHP_BRAM_top.Inst_IHP_BRAM_top_switch_matrix.J_NS2_BEG0
+ VGND sg13g2_inv_1
X_1467_ Tile_X0Y1_FrameData[16] Tile_X0Y1_FrameStrobe[3] Tile_X0Y1_IHP_BRAM_bot.Inst_IHP_BRAM_bot_ConfigMem.Inst_frame3_bit16.Q
+ VPWR VGND sg13g2_dlhq_1
X_1398_ Tile_X0Y1_FrameData[21] Tile_X0Y1_FrameStrobe[1] Tile_X0Y1_IHP_BRAM_bot.Inst_IHP_BRAM_bot_ConfigMem.Inst_frame1_bit21.Q
+ VPWR VGND sg13g2_dlhq_1
XFILLER_103_58 VPWR VGND sg13g2_fill_2
XFILLER_33_207 VPWR VGND sg13g2_fill_1
XFILLER_52_7 VPWR VGND sg13g2_decap_8
X_1321_ Tile_X0Y0_FrameData[2] Tile_X0Y1_FrameStrobe[8] Tile_X0Y0_IHP_BRAM_top.Inst_IHP_BRAM_top_ConfigMem.Inst_frame8_bit2.Q
+ VPWR VGND sg13g2_dlhq_1
X_1252_ Tile_X0Y0_FrameData[7] Tile_X0Y1_FrameStrobe[6] Tile_X0Y0_IHP_BRAM_top.Inst_IHP_BRAM_top_ConfigMem.Inst_frame6_bit7.Q
+ VPWR VGND sg13g2_dlhq_1
X_1183_ Tile_X0Y0_FrameData[12] Tile_X0Y1_FrameStrobe[4] Tile_X0Y0_IHP_BRAM_top.Inst_IHP_BRAM_top_ConfigMem.Inst_frame4_bit12.Q
+ VPWR VGND sg13g2_dlhq_1
X_0967_ VGND VPWR _0306_ _0308_ Tile_X0Y1_IHP_BRAM_bot.Inst_IHP_BRAM_bot_switch_matrix.S4BEG0
+ _0313_ sg13g2_a21oi_1
Xoutput210 net210 Tile_X0Y0_W6BEG[6] VPWR VGND sg13g2_buf_1
Xoutput254 net254 Tile_X0Y1_FrameData_O[31] VPWR VGND sg13g2_buf_1
Xoutput221 net221 Tile_X0Y0_WW4BEG[1] VPWR VGND sg13g2_buf_1
Xoutput243 net243 Tile_X0Y1_FrameData_O[21] VPWR VGND sg13g2_buf_1
Xoutput287 net287 Tile_X0Y1_S4BEG[14] VPWR VGND sg13g2_buf_1
Xoutput265 net265 Tile_X0Y1_S1BEG[3] VPWR VGND sg13g2_buf_1
Xoutput276 net276 Tile_X0Y1_S2BEGb[2] VPWR VGND sg13g2_buf_1
X_1519_ Tile_X0Y1_FrameData[28] Tile_X0Y1_FrameStrobe[5] Tile_X0Y1_IHP_BRAM_bot.Inst_IHP_BRAM_bot_ConfigMem.Inst_frame5_bit28.Q
+ VPWR VGND sg13g2_dlhq_1
Xoutput298 net298 Tile_X0Y1_W1BEG[0] VPWR VGND sg13g2_buf_1
X_0898_ Tile_X0Y1_IHP_BRAM_bot.Inst_IHP_BRAM_bot_ConfigMem.Inst_frame2_bit10.Q Tile_X0Y1_EE4END[1]
+ Tile_X0Y1_EE4END[9] Tile_X0Y1_E6END[9] Tile_X0Y1_IHP_BRAM_bot.Inst_IHP_BRAM_bot_switch_matrix.J_NS4_BEG9
+ Tile_X0Y1_IHP_BRAM_bot.Inst_IHP_BRAM_bot_ConfigMem.Inst_frame2_bit11.Q net75 VPWR
+ VGND sg13g2_mux4_1
Xoutput232 net232 Tile_X0Y1_FrameData_O[11] VPWR VGND sg13g2_buf_1
XFILLER_67_181 VPWR VGND sg13g2_decap_8
XFILLER_73_162 VPWR VGND sg13g2_decap_8
XFILLER_64_61 VPWR VGND sg13g2_fill_1
X_0752_ _0215_ Tile_X0Y0_IHP_BRAM_top.Inst_IHP_BRAM_top_ConfigMem.Inst_frame1_bit4.Q
+ Tile_X0Y0_E2MID[6] VPWR VGND sg13g2_nand2b_1
X_1870_ Tile_X0Y0_IHP_BRAM_top.Inst_IHP_BRAM_top_switch_matrix.S2BEG7 net281 VPWR
+ VGND sg13g2_buf_1
X_0821_ Tile_X0Y1_IHP_BRAM_bot.Inst_IHP_BRAM_bot_ConfigMem.Inst_frame1_bit14.Q Tile_X0Y1_N1END[3]
+ Tile_X0Y1_N4END[3] _0097_ Tile_X0Y0_S4END[7] Tile_X0Y1_IHP_BRAM_bot.Inst_IHP_BRAM_bot_ConfigMem.Inst_frame1_bit15.Q
+ _0230_ VPWR VGND sg13g2_mux4_1
X_0683_ _0154_ _0156_ Tile_X0Y0_IHP_BRAM_top.Inst_IHP_BRAM_top_switch_matrix.N4BEG2
+ VPWR VGND sg13g2_nor2_1
X_1166_ Tile_X0Y0_FrameData[29] Tile_X0Y1_FrameStrobe[4] Tile_X0Y0_IHP_BRAM_top.Inst_IHP_BRAM_top_ConfigMem.Inst_frame4_bit29.Q
+ VPWR VGND sg13g2_dlhq_1
X_1304_ Tile_X0Y0_FrameData[19] Tile_X0Y1_FrameStrobe[8] Tile_X0Y0_IHP_BRAM_top.Inst_IHP_BRAM_top_ConfigMem.Inst_frame8_bit19.Q
+ VPWR VGND sg13g2_dlhq_1
X_1235_ Tile_X0Y0_FrameData[24] Tile_X0Y1_FrameStrobe[6] Tile_X0Y0_IHP_BRAM_top.Inst_IHP_BRAM_top_ConfigMem.Inst_frame6_bit24.Q
+ VPWR VGND sg13g2_dlhq_1
XFILLER_64_140 VPWR VGND sg13g2_fill_1
XFILLER_100_59 VPWR VGND sg13g2_fill_1
X_1097_ Tile_X0Y0_FrameData[2] Tile_X0Y1_FrameStrobe[1] Tile_X0Y0_IHP_BRAM_top.Inst_IHP_BRAM_top_ConfigMem.Inst_frame1_bit2.Q
+ VPWR VGND sg13g2_dlhq_1
XFILLER_109_186 VPWR VGND sg13g2_fill_1
X_1020_ VPWR VGND Tile_X0Y1_IHP_BRAM_bot.Inst_IHP_BRAM_bot_ConfigMem.Inst_frame3_bit19.Q
+ _0362_ _0361_ _0006_ _0363_ Tile_X0Y1_IHP_BRAM_bot.Inst_IHP_BRAM_bot_ConfigMem.Inst_frame3_bit20.Q
+ sg13g2_a221oi_1
XFILLER_61_187 VPWR VGND sg13g2_fill_2
X_1922_ Tile_X0Y1_IHP_BRAM_bot.Inst_IHP_BRAM_bot_switch_matrix.WW4BEG3 net339 VPWR
+ VGND sg13g2_buf_1
X_0735_ Tile_X0Y0_IHP_BRAM_top.Inst_IHP_BRAM_top_ConfigMem.Inst_frame2_bit30.Q VPWR
+ _0199_ VGND Tile_X0Y0_IHP_BRAM_top.Inst_IHP_BRAM_top_ConfigMem.Inst_frame2_bit29.Q
+ _0197_ sg13g2_o21ai_1
X_1784_ Tile_X0Y0_IHP_BRAM_top.Inst_IHP_BRAM_top_switch_matrix.W2BEGb1 net195 VPWR
+ VGND sg13g2_buf_1
X_0804_ Tile_X0Y1_IHP_BRAM_bot.Inst_IHP_BRAM_bot_ConfigMem.Inst_frame6_bit22.Q A_DOUT_BRAM3
+ B_DOUT_BRAM7 Tile_X0Y1_IHP_BRAM_bot.Inst_IHP_BRAM_bot_switch_matrix.J_NS4_BEG12
+ _0105_ Tile_X0Y1_IHP_BRAM_bot.Inst_IHP_BRAM_bot_ConfigMem.Inst_frame6_bit23.Q Tile_X0Y1_IHP_BRAM_bot.Inst_IHP_BRAM_bot_switch_matrix.WW4BEG3
+ VPWR VGND sg13g2_mux4_1
X_1853_ Tile_X0Y1_IHP_BRAM_bot.Inst_IHP_BRAM_bot_switch_matrix.S1BEG2 net264 VPWR
+ VGND sg13g2_buf_1
X_0666_ Tile_X0Y0_IHP_BRAM_top.Inst_IHP_BRAM_top_ConfigMem.Inst_frame9_bit26.Q _0141_
+ _0142_ VPWR VGND sg13g2_nor2_1
X_0597_ Tile_X0Y0_IHP_BRAM_top.Inst_IHP_BRAM_top_ConfigMem.Inst_frame4_bit7.Q A_DOUT_BRAM11
+ Tile_X0Y0_IHP_BRAM_top.Inst_IHP_BRAM_top_switch_matrix.J_NS4_BEG4 Tile_X0Y0_IHP_BRAM_top.Inst_IHP_BRAM_top_switch_matrix.J_NS4_BEG0
+ Tile_X0Y0_IHP_BRAM_top.Inst_IHP_BRAM_top_switch_matrix.J_NS2_BEG7 Tile_X0Y0_IHP_BRAM_top.Inst_IHP_BRAM_top_ConfigMem.Inst_frame4_bit6.Q
+ Tile_X0Y0_IHP_BRAM_top.Inst_IHP_BRAM_top_switch_matrix.W6BEG11 VPWR VGND sg13g2_mux4_1
XFILLER_69_210 VPWR VGND sg13g2_fill_2
XFILLER_41_0 VPWR VGND sg13g2_fill_2
X_1218_ Tile_X0Y0_FrameData[9] Tile_X0Y1_FrameStrobe[5] Tile_X0Y0_IHP_BRAM_top.Inst_IHP_BRAM_top_ConfigMem.Inst_frame5_bit9.Q
+ VPWR VGND sg13g2_dlhq_1
X_1149_ Tile_X0Y0_FrameData[14] Tile_X0Y1_FrameStrobe[3] Tile_X0Y0_IHP_BRAM_top.Inst_IHP_BRAM_top_ConfigMem.Inst_frame3_bit14.Q
+ VPWR VGND sg13g2_dlhq_1
XFILLER_52_198 VPWR VGND sg13g2_fill_2
XFILLER_106_178 VPWR VGND sg13g2_decap_4
XFILLER_106_167 VPWR VGND sg13g2_fill_1
XFILLER_106_145 VPWR VGND sg13g2_decap_4
XFILLER_43_110 VPWR VGND sg13g2_decap_4
XANTENNA_6 VPWR VGND Tile_X0Y0_S2MID[1] sg13g2_antennanp
XFILLER_101_91 VPWR VGND sg13g2_fill_2
XFILLER_61_62 VPWR VGND sg13g2_decap_4
X_0520_ Tile_X0Y0_IHP_BRAM_top.Inst_IHP_BRAM_top_ConfigMem.Inst_frame0_bit19.Q Tile_X0Y0_IHP_BRAM_top.Inst_IHP_BRAM_top_switch_matrix.N2BEGb5
+ Tile_X0Y0_S2MID[5] Tile_X0Y1_N2MID[5] Tile_X0Y0_S2END[5] Tile_X0Y0_IHP_BRAM_top.Inst_IHP_BRAM_top_ConfigMem.Inst_frame0_bit18.Q
+ Tile_X0Y0_IHP_BRAM_top.Inst_IHP_BRAM_top_switch_matrix.J_NS2_BEG5 VPWR VGND sg13g2_mux4_1
XFILLER_6_68 VPWR VGND sg13g2_fill_1
X_0382_ VPWR _0005_ Tile_X0Y1_E2MID[3] VGND sg13g2_inv_1
X_0451_ Tile_X0Y1_E2END[4] Tile_X0Y0_S2MID[3] Tile_X0Y1_IHP_BRAM_bot.Inst_IHP_BRAM_bot_ConfigMem.Inst_frame3_bit24.Q
+ _0067_ VPWR VGND sg13g2_mux2_1
X_1003_ Tile_X0Y1_N2MID[6] Tile_X0Y1_N2END[2] Tile_X0Y1_IHP_BRAM_bot.Inst_IHP_BRAM_bot_ConfigMem.Inst_frame3_bit18.Q
+ _0346_ VPWR VGND sg13g2_mux2_1
XFILLER_89_0 VPWR VGND sg13g2_fill_1
X_1905_ Tile_X0Y1_IHP_BRAM_bot.Inst_IHP_BRAM_bot_switch_matrix.W2BEGb6 net316 VPWR
+ VGND sg13g2_buf_1
X_1767_ Tile_X0Y0_IHP_BRAM_top.Inst_IHP_BRAM_top_switch_matrix.N4BEG1 net169 VPWR
+ VGND sg13g2_buf_1
X_1698_ Tile_X0Y0_FrameData[16] net100 VPWR VGND sg13g2_buf_1
X_0718_ Tile_X0Y0_IHP_BRAM_top.Inst_IHP_BRAM_top_ConfigMem.Inst_frame7_bit6.Q VPWR
+ _0187_ VGND Tile_X0Y0_IHP_BRAM_top.Inst_IHP_BRAM_top_ConfigMem.Inst_frame7_bit5.Q
+ Tile_X0Y0_IHP_BRAM_top.Inst_IHP_BRAM_top_switch_matrix.J_NS4_BEG15 sg13g2_o21ai_1
X_1836_ Tile_X0Y1_FrameData[17] net238 VPWR VGND sg13g2_buf_1
X_0649_ _0129_ Tile_X0Y0_E2END[1] Tile_X0Y0_IHP_BRAM_top.Inst_IHP_BRAM_top_ConfigMem.Inst_frame2_bit21.Q
+ VPWR VGND sg13g2_nand2b_1
XFILLER_103_2 VPWR VGND sg13g2_fill_1
Xoutput98 net98 Tile_X0Y0_FrameData_O[14] VPWR VGND sg13g2_buf_1
Xoutput8 net8 A_ADDR_BRAM7 VPWR VGND sg13g2_buf_1
Xoutput43 net43 A_DIN_BRAM9 VPWR VGND sg13g2_buf_1
Xoutput32 net32 A_DIN_BRAM12 VPWR VGND sg13g2_buf_1
Xoutput10 net10 A_ADDR_BRAM9 VPWR VGND sg13g2_buf_1
Xoutput21 net21 A_BM_BRAM4 VPWR VGND sg13g2_buf_1
Xoutput54 net54 B_ADDR_BRAM7 VPWR VGND sg13g2_buf_1
Xoutput76 net76 B_DIN_BRAM10 VPWR VGND sg13g2_buf_1
Xoutput87 net87 B_DIN_BRAM7 VPWR VGND sg13g2_buf_1
Xoutput65 net65 B_BM_BRAM2 VPWR VGND sg13g2_buf_1
XFILLER_31_179 VPWR VGND sg13g2_fill_2
X_1552_ Tile_X0Y1_FrameData[27] Tile_X0Y1_FrameStrobe[6] Tile_X0Y1_IHP_BRAM_bot.Inst_IHP_BRAM_bot_ConfigMem.Inst_frame6_bit27.Q
+ VPWR VGND sg13g2_dlhq_1
X_1621_ Tile_X0Y1_FrameData[22] Tile_X0Y1_FrameStrobe[8] Tile_X0Y1_IHP_BRAM_bot.Inst_IHP_BRAM_bot_ConfigMem.Inst_frame8_bit22.Q
+ VPWR VGND sg13g2_dlhq_1
X_0434_ Tile_X0Y0_IHP_BRAM_top.Inst_IHP_BRAM_top_ConfigMem.Inst_frame1_bit1.Q Tile_X0Y0_IHP_BRAM_top.Inst_IHP_BRAM_top_ConfigMem.Inst_frame1_bit2.Q
+ _0001_ _0054_ VPWR VGND sg13g2_nor3_1
X_1483_ Tile_X0Y1_FrameData[0] Tile_X0Y1_FrameStrobe[3] Tile_X0Y1_IHP_BRAM_bot.Inst_IHP_BRAM_bot_ConfigMem.Inst_frame3_bit0.Q
+ VPWR VGND sg13g2_dlhq_1
X_0503_ Tile_X0Y1_IHP_BRAM_bot.Inst_IHP_BRAM_bot_ConfigMem.Inst_frame0_bit12.Q Tile_X0Y1_N2MID[2]
+ Tile_X0Y1_N2END[2] Tile_X0Y0_IHP_BRAM_top.Inst_IHP_BRAM_top_switch_matrix.S2BEG2
+ Tile_X0Y0_S2MID[2] Tile_X0Y1_IHP_BRAM_bot.Inst_IHP_BRAM_bot_ConfigMem.Inst_frame0_bit13.Q
+ _0103_ VPWR VGND sg13g2_mux4_1
XFILLER_22_124 VPWR VGND sg13g2_fill_1
X_1819_ Tile_X0Y1_FrameData[0] net230 VPWR VGND sg13g2_buf_1
XFILLER_13_135 VPWR VGND sg13g2_fill_2
XFILLER_83_82 VPWR VGND sg13g2_fill_1
X_0983_ VGND VPWR _0034_ _0327_ _0328_ Tile_X0Y1_IHP_BRAM_bot.Inst_IHP_BRAM_bot_ConfigMem.Inst_frame7_bit4.Q
+ sg13g2_a21oi_1
X_1535_ Tile_X0Y1_FrameData[12] Tile_X0Y1_FrameStrobe[5] Tile_X0Y1_IHP_BRAM_bot.Inst_IHP_BRAM_bot_ConfigMem.Inst_frame5_bit12.Q
+ VPWR VGND sg13g2_dlhq_1
X_1604_ Tile_X0Y1_FrameData[7] Tile_X0Y1_FrameStrobe[7] Tile_X0Y1_IHP_BRAM_bot.Inst_IHP_BRAM_bot_ConfigMem.Inst_frame7_bit7.Q
+ VPWR VGND sg13g2_dlhq_1
X_1397_ Tile_X0Y1_FrameData[22] Tile_X0Y1_FrameStrobe[1] Tile_X0Y1_IHP_BRAM_bot.Inst_IHP_BRAM_bot_ConfigMem.Inst_frame1_bit22.Q
+ VPWR VGND sg13g2_dlhq_1
X_1466_ Tile_X0Y1_FrameData[17] Tile_X0Y1_FrameStrobe[3] Tile_X0Y1_IHP_BRAM_bot.Inst_IHP_BRAM_bot_ConfigMem.Inst_frame3_bit17.Q
+ VPWR VGND sg13g2_dlhq_1
X_0417_ VPWR _0040_ Tile_X0Y1_IHP_BRAM_bot.Inst_IHP_BRAM_bot_ConfigMem.Inst_frame3_bit29.Q
+ VGND sg13g2_inv_1
XFILLER_92_108 VPWR VGND sg13g2_fill_2
X_1320_ Tile_X0Y0_FrameData[3] Tile_X0Y1_FrameStrobe[8] Tile_X0Y0_IHP_BRAM_top.Inst_IHP_BRAM_top_ConfigMem.Inst_frame8_bit3.Q
+ VPWR VGND sg13g2_dlhq_1
X_1182_ Tile_X0Y0_FrameData[13] Tile_X0Y1_FrameStrobe[4] Tile_X0Y0_IHP_BRAM_top.Inst_IHP_BRAM_top_ConfigMem.Inst_frame4_bit13.Q
+ VPWR VGND sg13g2_dlhq_1
XFILLER_94_81 VPWR VGND sg13g2_decap_8
XFILLER_78_93 VPWR VGND sg13g2_fill_1
X_1251_ Tile_X0Y0_FrameData[8] Tile_X0Y1_FrameStrobe[6] Tile_X0Y0_IHP_BRAM_top.Inst_IHP_BRAM_top_ConfigMem.Inst_frame6_bit8.Q
+ VPWR VGND sg13g2_dlhq_1
Xoutput200 net200 Tile_X0Y0_W2BEGb[6] VPWR VGND sg13g2_buf_1
X_0966_ VGND VPWR _0030_ _0311_ _0313_ _0312_ sg13g2_a21oi_1
X_0897_ Tile_X0Y1_IHP_BRAM_bot.Inst_IHP_BRAM_bot_ConfigMem.Inst_frame2_bit8.Q Tile_X0Y1_EE4END[0]
+ Tile_X0Y1_EE4END[8] Tile_X0Y1_E6END[8] Tile_X0Y1_IHP_BRAM_bot.Inst_IHP_BRAM_bot_switch_matrix.J_NS4_BEG8
+ Tile_X0Y1_IHP_BRAM_bot.Inst_IHP_BRAM_bot_ConfigMem.Inst_frame2_bit9.Q net74 VPWR
+ VGND sg13g2_mux4_1
Xoutput211 net211 Tile_X0Y0_W6BEG[7] VPWR VGND sg13g2_buf_1
Xoutput222 net222 Tile_X0Y0_WW4BEG[2] VPWR VGND sg13g2_buf_1
Xoutput244 net244 Tile_X0Y1_FrameData_O[22] VPWR VGND sg13g2_buf_1
Xoutput266 net266 Tile_X0Y1_S2BEG[0] VPWR VGND sg13g2_buf_1
Xoutput288 net288 Tile_X0Y1_S4BEG[15] VPWR VGND sg13g2_buf_1
Xoutput277 net277 Tile_X0Y1_S2BEGb[3] VPWR VGND sg13g2_buf_1
X_1518_ Tile_X0Y1_FrameData[29] Tile_X0Y1_FrameStrobe[5] Tile_X0Y1_IHP_BRAM_bot.Inst_IHP_BRAM_bot_ConfigMem.Inst_frame5_bit29.Q
+ VPWR VGND sg13g2_dlhq_1
Xoutput299 net299 Tile_X0Y1_W1BEG[1] VPWR VGND sg13g2_buf_1
X_1449_ Tile_X0Y1_FrameData[2] Tile_X0Y1_FrameStrobe[2] Tile_X0Y1_IHP_BRAM_bot.Inst_IHP_BRAM_bot_ConfigMem.Inst_frame2_bit2.Q
+ VPWR VGND sg13g2_dlhq_1
Xoutput255 net255 Tile_X0Y1_FrameData_O[3] VPWR VGND sg13g2_buf_1
Xoutput233 net233 Tile_X0Y1_FrameData_O[12] VPWR VGND sg13g2_buf_1
XFILLER_99_59 VPWR VGND sg13g2_fill_1
XFILLER_2_101 VPWR VGND sg13g2_fill_2
XFILLER_80_94 VPWR VGND sg13g2_decap_8
X_0751_ VPWR VGND Tile_X0Y0_IHP_BRAM_top.Inst_IHP_BRAM_top_ConfigMem.Inst_frame1_bit5.Q
+ Tile_X0Y0_IHP_BRAM_top.Inst_IHP_BRAM_top_ConfigMem.Inst_frame1_bit6.Q _0213_ _0211_
+ _0214_ _0212_ sg13g2_a221oi_1
X_0820_ Tile_X0Y1_IHP_BRAM_bot.Inst_IHP_BRAM_bot_ConfigMem.Inst_frame5_bit6.Q A_DOUT_BRAM7
+ B_DOUT_BRAM3 Tile_X0Y1_IHP_BRAM_bot.Inst_IHP_BRAM_bot_switch_matrix.J_NS4_BEG4 _0105_
+ Tile_X0Y1_IHP_BRAM_bot.Inst_IHP_BRAM_bot_ConfigMem.Inst_frame5_bit7.Q Tile_X0Y1_IHP_BRAM_bot.Inst_IHP_BRAM_bot_switch_matrix.WW4BEG11
+ VPWR VGND sg13g2_mux4_1
X_0682_ Tile_X0Y0_IHP_BRAM_top.Inst_IHP_BRAM_top_ConfigMem.Inst_frame8_bit0.Q _0155_
+ _0156_ VPWR VGND sg13g2_nor2_1
X_1303_ Tile_X0Y0_FrameData[20] Tile_X0Y1_FrameStrobe[8] Tile_X0Y0_IHP_BRAM_top.Inst_IHP_BRAM_top_ConfigMem.Inst_frame8_bit20.Q
+ VPWR VGND sg13g2_dlhq_1
X_1165_ Tile_X0Y0_FrameData[30] Tile_X0Y1_FrameStrobe[4] Tile_X0Y0_IHP_BRAM_top.Inst_IHP_BRAM_top_ConfigMem.Inst_frame4_bit30.Q
+ VPWR VGND sg13g2_dlhq_1
X_1234_ Tile_X0Y0_FrameData[25] Tile_X0Y1_FrameStrobe[6] Tile_X0Y0_IHP_BRAM_top.Inst_IHP_BRAM_top_ConfigMem.Inst_frame6_bit25.Q
+ VPWR VGND sg13g2_dlhq_1
X_1096_ Tile_X0Y0_FrameData[3] Tile_X0Y1_FrameStrobe[1] Tile_X0Y0_IHP_BRAM_top.Inst_IHP_BRAM_top_ConfigMem.Inst_frame1_bit3.Q
+ VPWR VGND sg13g2_dlhq_1
XFILLER_69_29 VPWR VGND sg13g2_fill_2
X_0949_ Tile_X0Y1_E1END[3] Tile_X0Y1_EE4END[3] Tile_X0Y1_IHP_BRAM_bot.Inst_IHP_BRAM_bot_ConfigMem.Inst_frame8_bit1.Q
+ _0297_ VPWR VGND sg13g2_mux2_1
XFILLER_47_108 VPWR VGND sg13g2_fill_1
XFILLER_70_100 VPWR VGND sg13g2_decap_4
XFILLER_18_55 VPWR VGND sg13g2_fill_2
XFILLER_55_163 VPWR VGND sg13g2_fill_1
XFILLER_7_215 VPWR VGND sg13g2_fill_1
XFILLER_50_31 VPWR VGND sg13g2_decap_8
XFILLER_59_95 VPWR VGND sg13g2_fill_2
XFILLER_59_62 VPWR VGND sg13g2_decap_4
XFILLER_1_0 VPWR VGND sg13g2_fill_1
XFILLER_75_72 VPWR VGND sg13g2_fill_1
XFILLER_61_177 VPWR VGND sg13g2_decap_4
XFILLER_61_133 VPWR VGND sg13g2_decap_8
XFILLER_61_111 VPWR VGND sg13g2_decap_4
X_1852_ Tile_X0Y1_IHP_BRAM_bot.Inst_IHP_BRAM_bot_switch_matrix.S1BEG1 net263 VPWR
+ VGND sg13g2_buf_1
X_1921_ Tile_X0Y1_IHP_BRAM_bot.Inst_IHP_BRAM_bot_switch_matrix.WW4BEG2 net338 VPWR
+ VGND sg13g2_buf_1
X_0665_ Tile_X0Y0_IHP_BRAM_top.Inst_IHP_BRAM_top_ConfigMem.Inst_frame9_bit24.Q Tile_X0Y0_E1END[0]
+ Tile_X0Y0_EE4END[0] Tile_X0Y0_E6END[8] Tile_X0Y0_IHP_BRAM_top.Inst_IHP_BRAM_top_switch_matrix.J_NS4_BEG0
+ Tile_X0Y0_IHP_BRAM_top.Inst_IHP_BRAM_top_ConfigMem.Inst_frame9_bit25.Q _0141_ VPWR
+ VGND sg13g2_mux4_1
X_1783_ Tile_X0Y0_IHP_BRAM_top.Inst_IHP_BRAM_top_switch_matrix.W2BEGb0 net194 VPWR
+ VGND sg13g2_buf_1
X_0734_ Tile_X0Y0_E2END[1] Tile_X0Y0_E2END[2] Tile_X0Y0_IHP_BRAM_top.Inst_IHP_BRAM_top_ConfigMem.Inst_frame2_bit28.Q
+ _0198_ VPWR VGND sg13g2_mux2_1
X_0803_ Tile_X0Y1_IHP_BRAM_bot.Inst_IHP_BRAM_bot_ConfigMem.Inst_frame6_bit20.Q A_DOUT_BRAM2
+ B_DOUT_BRAM6 Tile_X0Y1_IHP_BRAM_bot.Inst_IHP_BRAM_bot_switch_matrix.J_NS4_BEG13
+ _0106_ Tile_X0Y1_IHP_BRAM_bot.Inst_IHP_BRAM_bot_ConfigMem.Inst_frame6_bit21.Q Tile_X0Y1_IHP_BRAM_bot.Inst_IHP_BRAM_bot_switch_matrix.WW4BEG2
+ VPWR VGND sg13g2_mux4_1
X_0596_ Tile_X0Y0_IHP_BRAM_top.Inst_IHP_BRAM_top_ConfigMem.Inst_frame4_bit5.Q A_DOUT_BRAM10
+ Tile_X0Y0_IHP_BRAM_top.Inst_IHP_BRAM_top_switch_matrix.J_NS4_BEG5 Tile_X0Y0_IHP_BRAM_top.Inst_IHP_BRAM_top_switch_matrix.J_NS4_BEG1
+ Tile_X0Y0_IHP_BRAM_top.Inst_IHP_BRAM_top_switch_matrix.J_NS2_BEG6 Tile_X0Y0_IHP_BRAM_top.Inst_IHP_BRAM_top_ConfigMem.Inst_frame4_bit4.Q
+ Tile_X0Y0_IHP_BRAM_top.Inst_IHP_BRAM_top_switch_matrix.W6BEG10 VPWR VGND sg13g2_mux4_1
XFILLER_29_108 VPWR VGND sg13g2_fill_1
XFILLER_34_0 VPWR VGND sg13g2_decap_8
X_1079_ Tile_X0Y0_FrameData[20] Tile_X0Y1_FrameStrobe[1] Tile_X0Y0_IHP_BRAM_top.Inst_IHP_BRAM_top_ConfigMem.Inst_frame1_bit20.Q
+ VPWR VGND sg13g2_dlhq_1
X_1217_ Tile_X0Y0_FrameData[10] Tile_X0Y1_FrameStrobe[5] Tile_X0Y0_IHP_BRAM_top.Inst_IHP_BRAM_top_ConfigMem.Inst_frame5_bit10.Q
+ VPWR VGND sg13g2_dlhq_1
XFILLER_37_141 VPWR VGND sg13g2_decap_8
X_1148_ Tile_X0Y0_FrameData[15] Tile_X0Y1_FrameStrobe[3] Tile_X0Y0_IHP_BRAM_top.Inst_IHP_BRAM_top_ConfigMem.Inst_frame3_bit15.Q
+ VPWR VGND sg13g2_dlhq_1
XFILLER_20_12 VPWR VGND sg13g2_fill_2
XFILLER_20_45 VPWR VGND sg13g2_fill_1
XFILLER_75_203 VPWR VGND sg13g2_fill_1
XFILLER_29_65 VPWR VGND sg13g2_fill_1
XFILLER_43_155 VPWR VGND sg13g2_fill_1
XANTENNA_7 VPWR VGND Tile_X0Y1_FrameStrobe[10] sg13g2_antennanp
X_0381_ VPWR _0004_ Tile_X0Y1_IHP_BRAM_bot.Inst_IHP_BRAM_bot_ConfigMem.Inst_frame3_bit23.Q
+ VGND sg13g2_inv_1
X_0450_ _0004_ Tile_X0Y1_IHP_BRAM_bot.Inst_IHP_BRAM_bot_ConfigMem.Inst_frame3_bit24.Q
+ Tile_X0Y0_IHP_BRAM_top.Inst_IHP_BRAM_top_switch_matrix.S2BEG0 _0066_ VPWR VGND sg13g2_nor3_1
X_1002_ _0345_ Tile_X0Y1_IHP_BRAM_bot.Inst_IHP_BRAM_bot_ConfigMem.Inst_frame3_bit20.Q
+ Tile_X0Y1_IHP_BRAM_bot.Inst_IHP_BRAM_bot_ConfigMem.Inst_frame3_bit19.Q VPWR VGND
+ sg13g2_nand2b_1
X_1904_ Tile_X0Y1_IHP_BRAM_bot.Inst_IHP_BRAM_bot_switch_matrix.W2BEGb5 net315 VPWR
+ VGND sg13g2_buf_1
X_1835_ Tile_X0Y1_FrameData[16] net237 VPWR VGND sg13g2_buf_1
X_1766_ Tile_X0Y0_IHP_BRAM_top.Inst_IHP_BRAM_top_switch_matrix.N4BEG0 net168 VPWR
+ VGND sg13g2_buf_1
XFILLER_103_116 VPWR VGND sg13g2_fill_2
X_1697_ Tile_X0Y0_FrameData[15] net99 VPWR VGND sg13g2_buf_1
X_0648_ Tile_X0Y0_E2MID[1] Tile_X0Y0_IHP_BRAM_top.Inst_IHP_BRAM_top_ConfigMem.Inst_frame2_bit20.Q
+ Tile_X0Y0_IHP_BRAM_top.Inst_IHP_BRAM_top_ConfigMem.Inst_frame2_bit21.Q _0128_ VPWR
+ VGND sg13g2_nor3_1
X_0717_ Tile_X0Y0_IHP_BRAM_top.Inst_IHP_BRAM_top_switch_matrix.J_NS2_BEG7 Tile_X0Y0_IHP_BRAM_top.Inst_IHP_BRAM_top_ConfigMem.Inst_frame7_bit5.Q
+ _0186_ VPWR VGND sg13g2_nor2b_1
XFILLER_111_182 VPWR VGND sg13g2_fill_1
XFILLER_111_171 VPWR VGND sg13g2_fill_2
X_0579_ Tile_X0Y0_IHP_BRAM_top.Inst_IHP_BRAM_top_ConfigMem.Inst_frame5_bit8.Q A_DOUT_BRAM8
+ B_DOUT_BRAM12 Tile_X0Y0_IHP_BRAM_top.Inst_IHP_BRAM_top_switch_matrix.J_NS4_BEG3
+ Tile_X0Y0_IHP_BRAM_top.Inst_IHP_BRAM_top_switch_matrix.J_NS2_BEG3 Tile_X0Y0_IHP_BRAM_top.Inst_IHP_BRAM_top_ConfigMem.Inst_frame5_bit9.Q
+ Tile_X0Y0_IHP_BRAM_top.Inst_IHP_BRAM_top_switch_matrix.WW4BEG12 VPWR VGND sg13g2_mux4_1
XFILLER_15_12 VPWR VGND sg13g2_fill_1
XFILLER_25_133 VPWR VGND sg13g2_fill_1
XFILLER_31_55 VPWR VGND sg13g2_decap_8
Xoutput99 net99 Tile_X0Y0_FrameData_O[15] VPWR VGND sg13g2_buf_1
Xoutput33 net33 A_DIN_BRAM13 VPWR VGND sg13g2_buf_1
Xoutput9 net9 A_ADDR_BRAM8 VPWR VGND sg13g2_buf_1
Xoutput22 net22 A_BM_BRAM5 VPWR VGND sg13g2_buf_1
Xoutput11 net11 A_BM_BRAM0 VPWR VGND sg13g2_buf_1
Xoutput55 net55 B_ADDR_BRAM8 VPWR VGND sg13g2_buf_1
Xoutput77 net77 B_DIN_BRAM11 VPWR VGND sg13g2_buf_1
Xoutput44 net44 A_MEN_BRAM VPWR VGND sg13g2_buf_1
Xoutput88 net88 B_DIN_BRAM8 VPWR VGND sg13g2_buf_1
Xoutput66 net66 B_BM_BRAM3 VPWR VGND sg13g2_buf_1
XFILLER_48_214 VPWR VGND sg13g2_fill_2
XFILLER_16_144 VPWR VGND sg13g2_fill_1
XFILLER_98_147 VPWR VGND sg13g2_decap_8
XFILLER_98_125 VPWR VGND sg13g2_fill_1
X_0502_ Tile_X0Y0_IHP_BRAM_top.Inst_IHP_BRAM_top_ConfigMem.Inst_frame8_bit17.Q Tile_X0Y0_E2MID[5]
+ Tile_X0Y0_E6END[10] Tile_X0Y0_E2END[5] Tile_X0Y0_IHP_BRAM_top.Inst_IHP_BRAM_top_switch_matrix.J_NS2_BEG2
+ Tile_X0Y0_IHP_BRAM_top.Inst_IHP_BRAM_top_ConfigMem.Inst_frame8_bit16.Q Tile_X0Y0_IHP_BRAM_top.Inst_IHP_BRAM_top_switch_matrix.S2BEG2
+ VPWR VGND sg13g2_mux4_1
X_1551_ Tile_X0Y1_FrameData[28] Tile_X0Y1_FrameStrobe[6] Tile_X0Y1_IHP_BRAM_bot.Inst_IHP_BRAM_bot_ConfigMem.Inst_frame6_bit28.Q
+ VPWR VGND sg13g2_dlhq_1
X_1620_ Tile_X0Y1_FrameData[23] Tile_X0Y1_FrameStrobe[8] Tile_X0Y1_IHP_BRAM_bot.Inst_IHP_BRAM_bot_ConfigMem.Inst_frame8_bit23.Q
+ VPWR VGND sg13g2_dlhq_1
X_1482_ Tile_X0Y1_FrameData[1] Tile_X0Y1_FrameStrobe[3] Tile_X0Y1_IHP_BRAM_bot.Inst_IHP_BRAM_bot_ConfigMem.Inst_frame3_bit1.Q
+ VPWR VGND sg13g2_dlhq_1
X_0433_ _0050_ _0048_ _0052_ _0053_ VPWR VGND sg13g2_a21o_1
X_1818_ Tile_X0Y0_IHP_BRAM_top.Inst_IHP_BRAM_top_switch_matrix.WW4BEG15 net220 VPWR
+ VGND sg13g2_buf_1
XFILLER_30_180 VPWR VGND sg13g2_fill_1
X_1749_ Tile_X0Y0_IHP_BRAM_top.Inst_IHP_BRAM_top_switch_matrix.N2BEGb3 net160 VPWR
+ VGND sg13g2_buf_1
XFILLER_26_66 VPWR VGND sg13g2_fill_1
XFILLER_42_43 VPWR VGND sg13g2_fill_2
XFILLER_95_128 VPWR VGND sg13g2_decap_8
X_0982_ Tile_X0Y1_E1END[2] Tile_X0Y1_EE4END[14] Tile_X0Y1_IHP_BRAM_bot.Inst_IHP_BRAM_bot_ConfigMem.Inst_frame7_bit2.Q
+ _0327_ VPWR VGND sg13g2_mux2_1
X_1603_ Tile_X0Y1_FrameData[8] Tile_X0Y1_FrameStrobe[7] Tile_X0Y1_IHP_BRAM_bot.Inst_IHP_BRAM_bot_ConfigMem.Inst_frame7_bit8.Q
+ VPWR VGND sg13g2_dlhq_1
X_1534_ Tile_X0Y1_FrameData[13] Tile_X0Y1_FrameStrobe[5] Tile_X0Y1_IHP_BRAM_bot.Inst_IHP_BRAM_bot_ConfigMem.Inst_frame5_bit13.Q
+ VPWR VGND sg13g2_dlhq_1
X_1465_ Tile_X0Y1_FrameData[18] Tile_X0Y1_FrameStrobe[3] Tile_X0Y1_IHP_BRAM_bot.Inst_IHP_BRAM_bot_ConfigMem.Inst_frame3_bit18.Q
+ VPWR VGND sg13g2_dlhq_1
XFILLER_94_161 VPWR VGND sg13g2_fill_1
X_1396_ Tile_X0Y1_FrameData[23] Tile_X0Y1_FrameStrobe[1] Tile_X0Y1_IHP_BRAM_bot.Inst_IHP_BRAM_bot_ConfigMem.Inst_frame1_bit23.Q
+ VPWR VGND sg13g2_dlhq_1
XFILLER_42_209 VPWR VGND sg13g2_fill_2
X_0416_ VPWR _0039_ Tile_X0Y1_IHP_BRAM_bot.Inst_IHP_BRAM_bot_ConfigMem.Inst_frame3_bit27.Q
+ VGND sg13g2_inv_1
XFILLER_53_42 VPWR VGND sg13g2_fill_1
XFILLER_78_50 VPWR VGND sg13g2_fill_2
X_1181_ Tile_X0Y0_FrameData[14] Tile_X0Y1_FrameStrobe[4] Tile_X0Y0_IHP_BRAM_top.Inst_IHP_BRAM_top_ConfigMem.Inst_frame4_bit14.Q
+ VPWR VGND sg13g2_dlhq_1
X_1250_ Tile_X0Y0_FrameData[9] Tile_X0Y1_FrameStrobe[6] Tile_X0Y0_IHP_BRAM_top.Inst_IHP_BRAM_top_ConfigMem.Inst_frame6_bit9.Q
+ VPWR VGND sg13g2_dlhq_1
Xoutput212 net212 Tile_X0Y0_W6BEG[8] VPWR VGND sg13g2_buf_1
Xoutput223 net223 Tile_X0Y0_WW4BEG[3] VPWR VGND sg13g2_buf_1
Xoutput201 net201 Tile_X0Y0_W2BEGb[7] VPWR VGND sg13g2_buf_1
X_0965_ Tile_X0Y1_IHP_BRAM_bot.Inst_IHP_BRAM_bot_ConfigMem.Inst_frame8_bit30.Q VPWR
+ _0312_ VGND _0309_ _0310_ sg13g2_o21ai_1
X_0896_ _0261_ VPWR net51 VGND Tile_X0Y1_IHP_BRAM_bot.Inst_IHP_BRAM_bot_ConfigMem.Inst_frame2_bit7.Q
+ _0263_ sg13g2_o21ai_1
Xoutput234 net234 Tile_X0Y1_FrameData_O[13] VPWR VGND sg13g2_buf_1
Xoutput245 net245 Tile_X0Y1_FrameData_O[23] VPWR VGND sg13g2_buf_1
Xoutput267 net267 Tile_X0Y1_S2BEG[1] VPWR VGND sg13g2_buf_1
Xoutput278 net278 Tile_X0Y1_S2BEGb[4] VPWR VGND sg13g2_buf_1
Xoutput289 net289 Tile_X0Y1_S4BEG[1] VPWR VGND sg13g2_buf_1
X_1517_ Tile_X0Y1_FrameData[30] Tile_X0Y1_FrameStrobe[5] Tile_X0Y1_IHP_BRAM_bot.Inst_IHP_BRAM_bot_ConfigMem.Inst_frame5_bit30.Q
+ VPWR VGND sg13g2_dlhq_1
X_1448_ Tile_X0Y1_FrameData[3] Tile_X0Y1_FrameStrobe[2] Tile_X0Y1_IHP_BRAM_bot.Inst_IHP_BRAM_bot_ConfigMem.Inst_frame2_bit3.Q
+ VPWR VGND sg13g2_dlhq_1
Xoutput256 net256 Tile_X0Y1_FrameData_O[4] VPWR VGND sg13g2_buf_1
X_1379_ Tile_X0Y1_FrameData[8] Tile_X0Y1_FrameStrobe[0] Tile_X0Y1_IHP_BRAM_bot.Inst_IHP_BRAM_bot_ConfigMem.Inst_frame0_bit8.Q
+ VPWR VGND sg13g2_dlhq_1
XFILLER_23_34 VPWR VGND sg13g2_fill_2
XFILLER_0_49 VPWR VGND sg13g2_fill_1
XFILLER_48_97 VPWR VGND sg13g2_decap_8
X_0681_ Tile_X0Y0_IHP_BRAM_top.Inst_IHP_BRAM_top_ConfigMem.Inst_frame9_bit31.Q Tile_X0Y0_E1END[2]
+ Tile_X0Y0_E6END[10] Tile_X0Y0_EE4END[2] Tile_X0Y0_IHP_BRAM_top.Inst_IHP_BRAM_top_switch_matrix.J_NS4_BEG2
+ Tile_X0Y0_IHP_BRAM_top.Inst_IHP_BRAM_top_ConfigMem.Inst_frame9_bit30.Q _0155_ VPWR
+ VGND sg13g2_mux4_1
X_0750_ Tile_X0Y1_N2MID[3] Tile_X0Y0_E2MID[0] Tile_X0Y0_IHP_BRAM_top.Inst_IHP_BRAM_top_ConfigMem.Inst_frame1_bit4.Q
+ _0213_ VPWR VGND sg13g2_mux2_1
XFILLER_89_71 VPWR VGND sg13g2_fill_1
X_1302_ Tile_X0Y0_FrameData[21] Tile_X0Y1_FrameStrobe[8] Tile_X0Y0_IHP_BRAM_top.Inst_IHP_BRAM_top_ConfigMem.Inst_frame8_bit21.Q
+ VPWR VGND sg13g2_dlhq_1
X_1233_ Tile_X0Y0_FrameData[26] Tile_X0Y1_FrameStrobe[6] Tile_X0Y0_IHP_BRAM_top.Inst_IHP_BRAM_top_ConfigMem.Inst_frame6_bit26.Q
+ VPWR VGND sg13g2_dlhq_1
X_1164_ Tile_X0Y0_FrameData[31] Tile_X0Y1_FrameStrobe[4] Tile_X0Y0_IHP_BRAM_top.Inst_IHP_BRAM_top_ConfigMem.Inst_frame4_bit31.Q
+ VPWR VGND sg13g2_dlhq_1
X_1095_ Tile_X0Y0_FrameData[4] Tile_X0Y1_FrameStrobe[1] Tile_X0Y0_IHP_BRAM_top.Inst_IHP_BRAM_top_ConfigMem.Inst_frame1_bit4.Q
+ VPWR VGND sg13g2_dlhq_1
XFILLER_64_120 VPWR VGND sg13g2_fill_1
XFILLER_49_194 VPWR VGND sg13g2_fill_2
X_0948_ _0295_ VPWR _0296_ VGND _0027_ _0230_ sg13g2_o21ai_1
X_0879_ VGND VPWR Tile_X0Y1_E2END[0] Tile_X0Y1_IHP_BRAM_bot.Inst_IHP_BRAM_bot_ConfigMem.Inst_frame3_bit30.Q
+ _0251_ _0250_ sg13g2_a21oi_1
XFILLER_85_18 VPWR VGND sg13g2_fill_2
XFILLER_55_120 VPWR VGND sg13g2_fill_1
XFILLER_38_109 VPWR VGND sg13g2_fill_1
XFILLER_46_131 VPWR VGND sg13g2_decap_4
XFILLER_61_189 VPWR VGND sg13g2_fill_1
X_1920_ Tile_X0Y1_IHP_BRAM_bot.Inst_IHP_BRAM_bot_switch_matrix.WW4BEG1 net337 VPWR
+ VGND sg13g2_buf_1
X_1851_ Tile_X0Y1_IHP_BRAM_bot.Inst_IHP_BRAM_bot_switch_matrix.S1BEG0 net262 VPWR
+ VGND sg13g2_buf_1
X_0802_ Tile_X0Y1_IHP_BRAM_bot.Inst_IHP_BRAM_bot_ConfigMem.Inst_frame6_bit18.Q A_DOUT_BRAM1
+ B_DOUT_BRAM5 Tile_X0Y1_IHP_BRAM_bot.Inst_IHP_BRAM_bot_switch_matrix.J_NS4_BEG14
+ _0046_ Tile_X0Y1_IHP_BRAM_bot.Inst_IHP_BRAM_bot_ConfigMem.Inst_frame6_bit19.Q Tile_X0Y1_IHP_BRAM_bot.Inst_IHP_BRAM_bot_switch_matrix.WW4BEG1
+ VPWR VGND sg13g2_mux4_1
X_0664_ VGND VPWR _0011_ _0136_ _0140_ _0139_ sg13g2_a21oi_1
X_0733_ _0196_ VPWR _0197_ VGND Tile_X0Y0_E2MID[3] Tile_X0Y0_IHP_BRAM_top.Inst_IHP_BRAM_top_ConfigMem.Inst_frame2_bit28.Q
+ sg13g2_o21ai_1
X_1782_ Tile_X0Y0_IHP_BRAM_top.Inst_IHP_BRAM_top_switch_matrix.W2BEG7 net193 VPWR
+ VGND sg13g2_buf_1
X_0595_ Tile_X0Y0_IHP_BRAM_top.Inst_IHP_BRAM_top_ConfigMem.Inst_frame4_bit3.Q A_DOUT_BRAM9
+ Tile_X0Y0_IHP_BRAM_top.Inst_IHP_BRAM_top_switch_matrix.J_NS4_BEG6 Tile_X0Y0_IHP_BRAM_top.Inst_IHP_BRAM_top_switch_matrix.J_NS4_BEG2
+ Tile_X0Y0_IHP_BRAM_top.Inst_IHP_BRAM_top_switch_matrix.J_NS2_BEG5 Tile_X0Y0_IHP_BRAM_top.Inst_IHP_BRAM_top_ConfigMem.Inst_frame4_bit2.Q
+ Tile_X0Y0_IHP_BRAM_top.Inst_IHP_BRAM_top_switch_matrix.W6BEG9 VPWR VGND sg13g2_mux4_1
X_1216_ Tile_X0Y0_FrameData[11] Tile_X0Y1_FrameStrobe[5] Tile_X0Y0_IHP_BRAM_top.Inst_IHP_BRAM_top_ConfigMem.Inst_frame5_bit11.Q
+ VPWR VGND sg13g2_dlhq_1
X_1078_ Tile_X0Y0_FrameData[21] Tile_X0Y1_FrameStrobe[1] Tile_X0Y0_IHP_BRAM_top.Inst_IHP_BRAM_top_ConfigMem.Inst_frame1_bit21.Q
+ VPWR VGND sg13g2_dlhq_1
X_1147_ Tile_X0Y0_FrameData[16] Tile_X0Y1_FrameStrobe[3] Tile_X0Y0_IHP_BRAM_top.Inst_IHP_BRAM_top_ConfigMem.Inst_frame3_bit16.Q
+ VPWR VGND sg13g2_dlhq_1
XFILLER_29_88 VPWR VGND sg13g2_fill_2
XFILLER_101_93 VPWR VGND sg13g2_fill_1
XFILLER_61_31 VPWR VGND sg13g2_fill_2
XANTENNA_8 VPWR VGND Tile_X0Y1_FrameStrobe[11] sg13g2_antennanp
XFILLER_86_94 VPWR VGND sg13g2_fill_2
X_0380_ VPWR _0003_ Tile_X0Y0_IHP_BRAM_top.Inst_IHP_BRAM_top_ConfigMem.Inst_frame1_bit3.Q
+ VGND sg13g2_inv_1
XFILLER_19_186 VPWR VGND sg13g2_fill_1
X_1001_ Tile_X0Y1_IHP_BRAM_bot.Inst_IHP_BRAM_bot_ConfigMem.Inst_frame3_bit20.Q Tile_X0Y1_IHP_BRAM_bot.Inst_IHP_BRAM_bot_ConfigMem.Inst_frame3_bit19.Q
+ _0344_ VPWR VGND sg13g2_nor2b_1
X_1765_ Tile_X0Y0_IHP_BRAM_top.N4BEG_outbuf_11.A net167 VPWR VGND sg13g2_buf_1
X_1903_ Tile_X0Y1_IHP_BRAM_bot.Inst_IHP_BRAM_bot_switch_matrix.W2BEGb4 net314 VPWR
+ VGND sg13g2_buf_1
X_1834_ Tile_X0Y1_FrameData[15] net236 VPWR VGND sg13g2_buf_1
X_1696_ Tile_X0Y0_FrameData[14] net98 VPWR VGND sg13g2_buf_1
X_0578_ Tile_X0Y0_IHP_BRAM_top.Inst_IHP_BRAM_top_ConfigMem.Inst_frame1_bit14.Q Tile_X0Y0_IHP_BRAM_top.Inst_IHP_BRAM_top_switch_matrix.N1END3
+ Tile_X0Y1_N4END[7] Tile_X0Y0_S1END[3] Tile_X0Y0_S4END[3] Tile_X0Y0_IHP_BRAM_top.Inst_IHP_BRAM_top_ConfigMem.Inst_frame1_bit15.Q
+ Tile_X0Y0_IHP_BRAM_top.Inst_IHP_BRAM_top_switch_matrix.J_NS4_BEG3 VPWR VGND sg13g2_mux4_1
X_0716_ Tile_X0Y0_IHP_BRAM_top.Inst_IHP_BRAM_top_switch_matrix.J_NS4_BEG7 Tile_X0Y0_IHP_BRAM_top.Inst_IHP_BRAM_top_switch_matrix.J_NS4_BEG11
+ Tile_X0Y0_IHP_BRAM_top.Inst_IHP_BRAM_top_ConfigMem.Inst_frame7_bit5.Q _0185_ VPWR
+ VGND sg13g2_mux2_1
X_0647_ VPWR VGND Tile_X0Y0_IHP_BRAM_top.Inst_IHP_BRAM_top_ConfigMem.Inst_frame2_bit18.Q
+ _0126_ _0127_ Tile_X0Y0_IHP_BRAM_top.Inst_IHP_BRAM_top_ConfigMem.Inst_frame2_bit19.Q
+ net52 _0041_ sg13g2_a221oi_1
XFILLER_111_194 VPWR VGND sg13g2_fill_1
XFILLER_57_215 VPWR VGND sg13g2_fill_1
XFILLER_15_46 VPWR VGND sg13g2_fill_2
Xoutput34 net34 A_DIN_BRAM14 VPWR VGND sg13g2_buf_1
Xoutput23 net23 A_BM_BRAM6 VPWR VGND sg13g2_buf_1
Xoutput12 net12 A_BM_BRAM1 VPWR VGND sg13g2_buf_1
Xoutput45 net45 A_REN_BRAM VPWR VGND sg13g2_buf_1
Xoutput56 net56 B_ADDR_BRAM9 VPWR VGND sg13g2_buf_1
Xoutput89 net89 B_DIN_BRAM9 VPWR VGND sg13g2_buf_1
Xoutput67 net67 B_BM_BRAM4 VPWR VGND sg13g2_buf_1
Xoutput78 net78 B_DIN_BRAM12 VPWR VGND sg13g2_buf_1
XFILLER_56_42 VPWR VGND sg13g2_decap_8
XFILLER_56_53 VPWR VGND sg13g2_fill_1
XFILLER_56_75 VPWR VGND sg13g2_fill_2
X_0501_ Tile_X0Y0_IHP_BRAM_top.Inst_IHP_BRAM_top_ConfigMem.Inst_frame9_bit11.Q Tile_X0Y0_E2MID[6]
+ Tile_X0Y0_E6END[6] Tile_X0Y0_E2END[6] Tile_X0Y0_IHP_BRAM_top.Inst_IHP_BRAM_top_switch_matrix.J_NS2_BEG1
+ Tile_X0Y0_IHP_BRAM_top.Inst_IHP_BRAM_top_ConfigMem.Inst_frame9_bit10.Q Tile_X0Y0_IHP_BRAM_top.Inst_IHP_BRAM_top_switch_matrix.N2BEG1
+ VPWR VGND sg13g2_mux4_1
X_0432_ _0051_ Tile_X0Y0_IHP_BRAM_top.Inst_IHP_BRAM_top_ConfigMem.Inst_frame1_bit2.Q
+ _0052_ VPWR VGND sg13g2_nor2b_1
X_1550_ Tile_X0Y1_FrameData[29] Tile_X0Y1_FrameStrobe[6] Tile_X0Y1_IHP_BRAM_bot.Inst_IHP_BRAM_bot_ConfigMem.Inst_frame6_bit29.Q
+ VPWR VGND sg13g2_dlhq_1
X_1481_ Tile_X0Y1_FrameData[2] Tile_X0Y1_FrameStrobe[3] Tile_X0Y1_IHP_BRAM_bot.Inst_IHP_BRAM_bot_ConfigMem.Inst_frame3_bit2.Q
+ VPWR VGND sg13g2_dlhq_1
XFILLER_94_0 VPWR VGND sg13g2_decap_8
X_1748_ Tile_X0Y0_IHP_BRAM_top.Inst_IHP_BRAM_top_switch_matrix.N2BEGb2 net159 VPWR
+ VGND sg13g2_buf_1
X_1817_ Tile_X0Y0_IHP_BRAM_top.Inst_IHP_BRAM_top_switch_matrix.WW4BEG14 net219 VPWR
+ VGND sg13g2_buf_1
XFILLER_97_192 VPWR VGND sg13g2_fill_2
X_1679_ VPWR VGND A_TIE_LOW_BRAM sg13g2_tielo
XFILLER_67_85 VPWR VGND sg13g2_decap_4
XFILLER_83_40 VPWR VGND sg13g2_decap_8
X_0981_ _0325_ VPWR _0326_ VGND _0033_ _0231_ sg13g2_o21ai_1
X_1602_ Tile_X0Y1_FrameData[9] Tile_X0Y1_FrameStrobe[7] Tile_X0Y1_IHP_BRAM_bot.Inst_IHP_BRAM_bot_ConfigMem.Inst_frame7_bit9.Q
+ VPWR VGND sg13g2_dlhq_1
XFILLER_86_118 VPWR VGND sg13g2_decap_8
X_1395_ Tile_X0Y1_FrameData[24] Tile_X0Y1_FrameStrobe[1] Tile_X0Y1_IHP_BRAM_bot.Inst_IHP_BRAM_bot_ConfigMem.Inst_frame1_bit24.Q
+ VPWR VGND sg13g2_dlhq_1
X_1533_ Tile_X0Y1_FrameData[14] Tile_X0Y1_FrameStrobe[5] Tile_X0Y1_IHP_BRAM_bot.Inst_IHP_BRAM_bot_ConfigMem.Inst_frame5_bit14.Q
+ VPWR VGND sg13g2_dlhq_1
X_0415_ VPWR _0038_ Tile_X0Y1_IHP_BRAM_bot.Inst_IHP_BRAM_bot_ConfigMem.Inst_frame3_bit21.Q
+ VGND sg13g2_inv_1
X_1464_ Tile_X0Y1_FrameData[19] Tile_X0Y1_FrameStrobe[3] Tile_X0Y1_IHP_BRAM_bot.Inst_IHP_BRAM_bot_ConfigMem.Inst_frame3_bit19.Q
+ VPWR VGND sg13g2_dlhq_1
XFILLER_37_55 VPWR VGND sg13g2_fill_2
XFILLER_91_154 VPWR VGND sg13g2_decap_8
X_1180_ Tile_X0Y0_FrameData[15] Tile_X0Y1_FrameStrobe[4] Tile_X0Y0_IHP_BRAM_top.Inst_IHP_BRAM_top_ConfigMem.Inst_frame4_bit15.Q
+ VPWR VGND sg13g2_dlhq_1
X_0964_ Tile_X0Y1_IHP_BRAM_bot.Inst_IHP_BRAM_bot_switch_matrix.J_NS4_BEG4 Tile_X0Y1_IHP_BRAM_bot.Inst_IHP_BRAM_bot_switch_matrix.J_NS4_BEG8
+ Tile_X0Y1_IHP_BRAM_bot.Inst_IHP_BRAM_bot_ConfigMem.Inst_frame8_bit28.Q _0311_ VPWR
+ VGND sg13g2_mux2_1
Xoutput202 net202 Tile_X0Y0_W6BEG[0] VPWR VGND sg13g2_buf_1
Xoutput213 net213 Tile_X0Y0_W6BEG[9] VPWR VGND sg13g2_buf_1
Xoutput246 net246 Tile_X0Y1_FrameData_O[24] VPWR VGND sg13g2_buf_1
Xoutput224 net224 Tile_X0Y0_WW4BEG[4] VPWR VGND sg13g2_buf_1
Xoutput268 net268 Tile_X0Y1_S2BEG[2] VPWR VGND sg13g2_buf_1
X_1516_ Tile_X0Y1_FrameData[31] Tile_X0Y1_FrameStrobe[5] Tile_X0Y1_IHP_BRAM_bot.Inst_IHP_BRAM_bot_ConfigMem.Inst_frame5_bit31.Q
+ VPWR VGND sg13g2_dlhq_1
X_0895_ VGND VPWR Tile_X0Y1_E2END[4] Tile_X0Y1_IHP_BRAM_bot.Inst_IHP_BRAM_bot_ConfigMem.Inst_frame2_bit6.Q
+ _0263_ _0262_ sg13g2_a21oi_1
Xoutput257 net257 Tile_X0Y1_FrameData_O[5] VPWR VGND sg13g2_buf_1
Xoutput235 net235 Tile_X0Y1_FrameData_O[14] VPWR VGND sg13g2_buf_1
XFILLER_57_0 VPWR VGND sg13g2_fill_2
XFILLER_67_162 VPWR VGND sg13g2_fill_2
XFILLER_59_129 VPWR VGND sg13g2_decap_4
Xoutput279 net279 Tile_X0Y1_S2BEGb[5] VPWR VGND sg13g2_buf_1
X_1378_ Tile_X0Y1_FrameData[9] Tile_X0Y1_FrameStrobe[0] Tile_X0Y1_IHP_BRAM_bot.Inst_IHP_BRAM_bot_ConfigMem.Inst_frame0_bit9.Q
+ VPWR VGND sg13g2_dlhq_1
X_1447_ Tile_X0Y1_FrameData[4] Tile_X0Y1_FrameStrobe[2] Tile_X0Y1_IHP_BRAM_bot.Inst_IHP_BRAM_bot_ConfigMem.Inst_frame2_bit4.Q
+ VPWR VGND sg13g2_dlhq_1
XFILLER_73_110 VPWR VGND sg13g2_fill_2
XFILLER_58_162 VPWR VGND sg13g2_decap_4
X_0680_ VGND VPWR _0013_ _0150_ _0154_ _0153_ sg13g2_a21oi_1
XFILLER_50_7 VPWR VGND sg13g2_fill_2
X_1301_ Tile_X0Y0_FrameData[22] Tile_X0Y1_FrameStrobe[8] Tile_X0Y0_IHP_BRAM_top.Inst_IHP_BRAM_top_ConfigMem.Inst_frame8_bit22.Q
+ VPWR VGND sg13g2_dlhq_1
X_1232_ Tile_X0Y0_FrameData[27] Tile_X0Y1_FrameStrobe[6] Tile_X0Y0_IHP_BRAM_top.Inst_IHP_BRAM_top_ConfigMem.Inst_frame6_bit27.Q
+ VPWR VGND sg13g2_dlhq_1
XFILLER_29_4 VPWR VGND sg13g2_fill_1
XFILLER_49_151 VPWR VGND sg13g2_decap_8
X_1163_ Tile_X0Y0_FrameData[0] Tile_X0Y1_FrameStrobe[3] Tile_X0Y0_IHP_BRAM_top.Inst_IHP_BRAM_top_ConfigMem.Inst_frame3_bit0.Q
+ VPWR VGND sg13g2_dlhq_1
X_1094_ Tile_X0Y0_FrameData[5] Tile_X0Y1_FrameStrobe[1] Tile_X0Y0_IHP_BRAM_top.Inst_IHP_BRAM_top_ConfigMem.Inst_frame1_bit5.Q
+ VPWR VGND sg13g2_dlhq_1
X_0947_ VPWR _0295_ _0294_ VGND sg13g2_inv_1
X_0878_ Tile_X0Y1_IHP_BRAM_bot.Inst_IHP_BRAM_bot_ConfigMem.Inst_frame3_bit30.Q Tile_X0Y1_E2MID[0]
+ _0250_ VPWR VGND sg13g2_nor2b_1
Xclkload0 clknet_1_1__leaf_Tile_X0Y1_UserCLK clkload0/X VPWR VGND sg13g2_buf_1
XFILLER_59_97 VPWR VGND sg13g2_fill_1
XFILLER_75_63 VPWR VGND sg13g2_decap_8
X_1850_ Tile_X0Y1_FrameData[31] net254 VPWR VGND sg13g2_buf_1
X_1781_ Tile_X0Y0_IHP_BRAM_top.Inst_IHP_BRAM_top_switch_matrix.W2BEG6 net192 VPWR
+ VGND sg13g2_buf_1
X_0801_ Tile_X0Y1_IHP_BRAM_bot.Inst_IHP_BRAM_bot_ConfigMem.Inst_frame6_bit16.Q A_DOUT_BRAM0
+ B_DOUT_BRAM4 Tile_X0Y1_IHP_BRAM_bot.Inst_IHP_BRAM_bot_switch_matrix.J_NS4_BEG15
+ _0107_ Tile_X0Y1_IHP_BRAM_bot.Inst_IHP_BRAM_bot_ConfigMem.Inst_frame6_bit17.Q Tile_X0Y1_IHP_BRAM_bot.Inst_IHP_BRAM_bot_switch_matrix.WW4BEG0
+ VPWR VGND sg13g2_mux4_1
X_0663_ Tile_X0Y0_IHP_BRAM_top.Inst_IHP_BRAM_top_ConfigMem.Inst_frame9_bit26.Q VPWR
+ _0139_ VGND _0137_ _0138_ sg13g2_o21ai_1
X_0594_ Tile_X0Y0_IHP_BRAM_top.Inst_IHP_BRAM_top_ConfigMem.Inst_frame4_bit1.Q A_DOUT_BRAM8
+ Tile_X0Y0_IHP_BRAM_top.Inst_IHP_BRAM_top_switch_matrix.J_NS4_BEG7 Tile_X0Y0_IHP_BRAM_top.Inst_IHP_BRAM_top_switch_matrix.J_NS4_BEG3
+ Tile_X0Y0_IHP_BRAM_top.Inst_IHP_BRAM_top_switch_matrix.J_NS2_BEG4 Tile_X0Y0_IHP_BRAM_top.Inst_IHP_BRAM_top_ConfigMem.Inst_frame4_bit0.Q
+ Tile_X0Y0_IHP_BRAM_top.Inst_IHP_BRAM_top_switch_matrix.W6BEG8 VPWR VGND sg13g2_mux4_1
X_0732_ _0196_ Tile_X0Y0_IHP_BRAM_top.Inst_IHP_BRAM_top_ConfigMem.Inst_frame2_bit28.Q
+ Tile_X0Y0_E2MID[6] VPWR VGND sg13g2_nand2b_1
X_1215_ Tile_X0Y0_FrameData[12] Tile_X0Y1_FrameStrobe[5] Tile_X0Y0_IHP_BRAM_top.Inst_IHP_BRAM_top_ConfigMem.Inst_frame5_bit12.Q
+ VPWR VGND sg13g2_dlhq_1
X_1146_ Tile_X0Y0_FrameData[17] Tile_X0Y1_FrameStrobe[3] Tile_X0Y0_IHP_BRAM_top.Inst_IHP_BRAM_top_ConfigMem.Inst_frame3_bit17.Q
+ VPWR VGND sg13g2_dlhq_1
XFILLER_1_82 VPWR VGND sg13g2_fill_1
X_1077_ Tile_X0Y0_FrameData[22] Tile_X0Y1_FrameStrobe[1] Tile_X0Y0_IHP_BRAM_top.Inst_IHP_BRAM_top_ConfigMem.Inst_frame1_bit22.Q
+ VPWR VGND sg13g2_dlhq_1
XFILLER_60_190 VPWR VGND sg13g2_fill_1
XFILLER_52_157 VPWR VGND sg13g2_fill_1
XANTENNA_9 VPWR VGND Tile_X0Y1_FrameStrobe[11] sg13g2_antennanp
XFILLER_105_170 VPWR VGND sg13g2_fill_2
X_1000_ VGND VPWR _0336_ _0338_ Tile_X0Y1_IHP_BRAM_bot.Inst_IHP_BRAM_bot_switch_matrix.S4BEG3
+ _0343_ sg13g2_a21oi_1
X_1902_ Tile_X0Y1_IHP_BRAM_bot.Inst_IHP_BRAM_bot_switch_matrix.W2BEGb3 net313 VPWR
+ VGND sg13g2_buf_1
X_1764_ Tile_X0Y0_IHP_BRAM_top.N4BEG_outbuf_10.A net166 VPWR VGND sg13g2_buf_1
X_0715_ _0182_ _0184_ Tile_X0Y0_IHP_BRAM_top.Inst_IHP_BRAM_top_switch_matrix.S4BEG2
+ VPWR VGND sg13g2_nor2_1
X_1833_ Tile_X0Y1_FrameData[14] net235 VPWR VGND sg13g2_buf_1
XFILLER_103_118 VPWR VGND sg13g2_fill_1
X_1695_ Tile_X0Y0_FrameData[13] net97 VPWR VGND sg13g2_buf_1
X_0577_ Tile_X0Y0_IHP_BRAM_top.Inst_IHP_BRAM_top_ConfigMem.Inst_frame5_bit6.Q A_DOUT_BRAM15
+ B_DOUT_BRAM11 Tile_X0Y0_IHP_BRAM_top.Inst_IHP_BRAM_top_switch_matrix.J_NS4_BEG4
+ Tile_X0Y0_IHP_BRAM_top.Inst_IHP_BRAM_top_switch_matrix.J_NS2_BEG4 Tile_X0Y0_IHP_BRAM_top.Inst_IHP_BRAM_top_ConfigMem.Inst_frame5_bit7.Q
+ Tile_X0Y0_IHP_BRAM_top.Inst_IHP_BRAM_top_switch_matrix.WW4BEG11 VPWR VGND sg13g2_mux4_1
X_0646_ _0127_ Tile_X0Y0_E2END[0] Tile_X0Y0_IHP_BRAM_top.Inst_IHP_BRAM_top_ConfigMem.Inst_frame2_bit19.Q
+ VPWR VGND sg13g2_nand2b_1
XFILLER_111_173 VPWR VGND sg13g2_fill_1
X_1129_ Tile_X0Y0_FrameData[2] Tile_X0Y1_FrameStrobe[2] Tile_X0Y0_IHP_BRAM_top.Inst_IHP_BRAM_top_ConfigMem.Inst_frame2_bit2.Q
+ VPWR VGND sg13g2_dlhq_1
XFILLER_40_149 VPWR VGND sg13g2_fill_2
Xoutput24 net24 A_BM_BRAM7 VPWR VGND sg13g2_buf_1
Xoutput35 net35 A_DIN_BRAM15 VPWR VGND sg13g2_buf_1
Xoutput46 net46 A_WEN_BRAM VPWR VGND sg13g2_buf_1
Xoutput13 net13 A_BM_BRAM10 VPWR VGND sg13g2_buf_1
Xoutput57 net57 B_BM_BRAM0 VPWR VGND sg13g2_buf_1
XFILLER_102_162 VPWR VGND sg13g2_decap_8
XFILLER_102_140 VPWR VGND sg13g2_decap_8
Xoutput79 net79 B_DIN_BRAM13 VPWR VGND sg13g2_buf_1
Xoutput68 net68 B_BM_BRAM5 VPWR VGND sg13g2_buf_1
XFILLER_31_105 VPWR VGND sg13g2_decap_4
XFILLER_31_127 VPWR VGND sg13g2_decap_4
XFILLER_68_8 VPWR VGND sg13g2_fill_2
X_0500_ Tile_X0Y0_IHP_BRAM_top.Inst_IHP_BRAM_top_ConfigMem.Inst_frame0_bit11.Q Tile_X0Y0_IHP_BRAM_top.Inst_IHP_BRAM_top_switch_matrix.N2BEGb1
+ Tile_X0Y0_S2MID[1] Tile_X0Y1_N2MID[1] Tile_X0Y0_S2END[1] Tile_X0Y0_IHP_BRAM_top.Inst_IHP_BRAM_top_ConfigMem.Inst_frame0_bit10.Q
+ Tile_X0Y0_IHP_BRAM_top.Inst_IHP_BRAM_top_switch_matrix.J_NS2_BEG1 VPWR VGND sg13g2_mux4_1
XFILLER_98_116 VPWR VGND sg13g2_decap_8
X_0431_ Tile_X0Y0_IHP_BRAM_top.Inst_IHP_BRAM_top_ConfigMem.Inst_frame1_bit0.Q Tile_X0Y0_E2MID[3]
+ Tile_X0Y0_E2MID[6] Tile_X0Y0_E2END[1] Tile_X0Y0_E2END[2] Tile_X0Y0_IHP_BRAM_top.Inst_IHP_BRAM_top_ConfigMem.Inst_frame1_bit1.Q
+ _0051_ VPWR VGND sg13g2_mux4_1
X_1480_ Tile_X0Y1_FrameData[3] Tile_X0Y1_FrameStrobe[3] Tile_X0Y1_IHP_BRAM_bot.Inst_IHP_BRAM_bot_ConfigMem.Inst_frame3_bit3.Q
+ VPWR VGND sg13g2_dlhq_1
X_1747_ Tile_X0Y0_IHP_BRAM_top.Inst_IHP_BRAM_top_switch_matrix.N2BEGb1 net158 VPWR
+ VGND sg13g2_buf_1
X_1816_ Tile_X0Y0_IHP_BRAM_top.Inst_IHP_BRAM_top_switch_matrix.WW4BEG13 net218 VPWR
+ VGND sg13g2_buf_1
XFILLER_7_70 VPWR VGND sg13g2_fill_2
X_1678_ VPWR VGND B_TIE_LOW_BRAM sg13g2_tielo
X_0629_ Tile_X0Y0_IHP_BRAM_top.Inst_IHP_BRAM_top_ConfigMem.Inst_frame3_bit18.Q Tile_X0Y0_EE4END[0]
+ Tile_X0Y0_EE4END[8] Tile_X0Y0_E6END[8] Tile_X0Y0_IHP_BRAM_top.Inst_IHP_BRAM_top_switch_matrix.J_NS4_BEG8
+ Tile_X0Y0_IHP_BRAM_top.Inst_IHP_BRAM_top_ConfigMem.Inst_frame3_bit19.Q net88 VPWR
+ VGND sg13g2_mux4_1
XFILLER_107_82 VPWR VGND sg13g2_fill_2
XFILLER_88_171 VPWR VGND sg13g2_fill_1
X_0980_ VPWR _0325_ _0324_ VGND sg13g2_inv_1
XFILLER_8_142 VPWR VGND sg13g2_fill_1
X_1601_ Tile_X0Y1_FrameData[10] Tile_X0Y1_FrameStrobe[7] Tile_X0Y1_IHP_BRAM_bot.Inst_IHP_BRAM_bot_ConfigMem.Inst_frame7_bit10.Q
+ VPWR VGND sg13g2_dlhq_1
X_1532_ Tile_X0Y1_FrameData[15] Tile_X0Y1_FrameStrobe[5] Tile_X0Y1_IHP_BRAM_bot.Inst_IHP_BRAM_bot_ConfigMem.Inst_frame5_bit15.Q
+ VPWR VGND sg13g2_dlhq_1
XFILLER_94_141 VPWR VGND sg13g2_fill_1
X_1394_ Tile_X0Y1_FrameData[25] Tile_X0Y1_FrameStrobe[1] Tile_X0Y1_IHP_BRAM_bot.Inst_IHP_BRAM_bot_ConfigMem.Inst_frame1_bit25.Q
+ VPWR VGND sg13g2_dlhq_1
X_0414_ VPWR _0037_ Tile_X0Y1_IHP_BRAM_bot.Inst_IHP_BRAM_bot_ConfigMem.Inst_frame3_bit18.Q
+ VGND sg13g2_inv_1
X_1463_ Tile_X0Y1_FrameData[20] Tile_X0Y1_FrameStrobe[3] Tile_X0Y1_IHP_BRAM_bot.Inst_IHP_BRAM_bot_ConfigMem.Inst_frame3_bit20.Q
+ VPWR VGND sg13g2_dlhq_1
XFILLER_104_202 VPWR VGND sg13g2_fill_2
XFILLER_85_185 VPWR VGND sg13g2_fill_2
XFILLER_85_163 VPWR VGND sg13g2_fill_1
XFILLER_41_211 VPWR VGND sg13g2_fill_1
XFILLER_91_133 VPWR VGND sg13g2_decap_4
XFILLER_32_211 VPWR VGND sg13g2_fill_1
X_0963_ Tile_X0Y1_IHP_BRAM_bot.Inst_IHP_BRAM_bot_ConfigMem.Inst_frame8_bit29.Q VPWR
+ _0310_ VGND Tile_X0Y1_IHP_BRAM_bot.Inst_IHP_BRAM_bot_ConfigMem.Inst_frame8_bit28.Q
+ Tile_X0Y1_IHP_BRAM_bot.Inst_IHP_BRAM_bot_switch_matrix.J_NS4_BEG12 sg13g2_o21ai_1
X_0894_ Tile_X0Y1_IHP_BRAM_bot.Inst_IHP_BRAM_bot_ConfigMem.Inst_frame2_bit6.Q Tile_X0Y1_E2MID[4]
+ _0262_ VPWR VGND sg13g2_nor2b_1
Xoutput203 net203 Tile_X0Y0_W6BEG[10] VPWR VGND sg13g2_buf_1
Xoutput225 net225 Tile_X0Y0_WW4BEG[5] VPWR VGND sg13g2_buf_1
Xoutput247 net247 Tile_X0Y1_FrameData_O[25] VPWR VGND sg13g2_buf_1
Xoutput214 net214 Tile_X0Y0_WW4BEG[0] VPWR VGND sg13g2_buf_1
Xoutput269 net269 Tile_X0Y1_S2BEG[3] VPWR VGND sg13g2_buf_1
X_1515_ Tile_X0Y1_FrameData[0] Tile_X0Y1_FrameStrobe[4] Tile_X0Y1_IHP_BRAM_bot.Inst_IHP_BRAM_bot_ConfigMem.Inst_frame4_bit0.Q
+ VPWR VGND sg13g2_dlhq_1
Xoutput258 net258 Tile_X0Y1_FrameData_O[6] VPWR VGND sg13g2_buf_1
Xoutput236 net236 Tile_X0Y1_FrameData_O[15] VPWR VGND sg13g2_buf_1
X_1446_ Tile_X0Y1_FrameData[5] Tile_X0Y1_FrameStrobe[2] Tile_X0Y1_IHP_BRAM_bot.Inst_IHP_BRAM_bot_ConfigMem.Inst_frame2_bit5.Q
+ VPWR VGND sg13g2_dlhq_1
X_1377_ Tile_X0Y1_FrameData[10] Tile_X0Y1_FrameStrobe[0] Tile_X0Y1_IHP_BRAM_bot.Inst_IHP_BRAM_bot_ConfigMem.Inst_frame0_bit10.Q
+ VPWR VGND sg13g2_dlhq_1
XFILLER_73_155 VPWR VGND sg13g2_decap_8
XFILLER_73_133 VPWR VGND sg13g2_decap_4
XFILLER_58_185 VPWR VGND sg13g2_decap_8
XFILLER_89_51 VPWR VGND sg13g2_fill_1
X_1162_ Tile_X0Y0_FrameData[1] Tile_X0Y1_FrameStrobe[3] Tile_X0Y0_IHP_BRAM_top.Inst_IHP_BRAM_top_ConfigMem.Inst_frame3_bit1.Q
+ VPWR VGND sg13g2_dlhq_1
X_1231_ Tile_X0Y0_FrameData[28] Tile_X0Y1_FrameStrobe[6] Tile_X0Y0_IHP_BRAM_top.Inst_IHP_BRAM_top_ConfigMem.Inst_frame6_bit28.Q
+ VPWR VGND sg13g2_dlhq_1
X_1300_ Tile_X0Y0_FrameData[23] Tile_X0Y1_FrameStrobe[8] Tile_X0Y0_IHP_BRAM_top.Inst_IHP_BRAM_top_ConfigMem.Inst_frame8_bit23.Q
+ VPWR VGND sg13g2_dlhq_1
X_1093_ Tile_X0Y0_FrameData[6] Tile_X0Y1_FrameStrobe[1] Tile_X0Y0_IHP_BRAM_top.Inst_IHP_BRAM_top_ConfigMem.Inst_frame1_bit6.Q
+ VPWR VGND sg13g2_dlhq_1
XFILLER_64_144 VPWR VGND sg13g2_decap_4
X_0877_ Tile_X0Y1_IHP_BRAM_bot.Inst_IHP_BRAM_bot_ConfigMem.Inst_frame3_bit31.Q _0065_
+ _0249_ VPWR VGND Tile_X0Y1_IHP_BRAM_bot.Inst_IHP_BRAM_bot_ConfigMem.Inst_frame3_bit30.Q
+ sg13g2_nand3b_1
X_0946_ Tile_X0Y1_IHP_BRAM_bot.Inst_IHP_BRAM_bot_ConfigMem.Inst_frame8_bit2.Q VPWR
+ _0294_ VGND Tile_X0Y1_E6END[11] Tile_X0Y1_IHP_BRAM_bot.Inst_IHP_BRAM_bot_ConfigMem.Inst_frame8_bit1.Q
+ sg13g2_o21ai_1
XFILLER_87_214 VPWR VGND sg13g2_fill_2
X_1429_ Tile_X0Y1_FrameData[22] Tile_X0Y1_FrameStrobe[2] Tile_X0Y1_IHP_BRAM_bot.Inst_IHP_BRAM_bot_ConfigMem.Inst_frame2_bit22.Q
+ VPWR VGND sg13g2_dlhq_1
XFILLER_55_100 VPWR VGND sg13g2_fill_2
XFILLER_34_35 VPWR VGND sg13g2_decap_4
XFILLER_34_68 VPWR VGND sg13g2_decap_8
XFILLER_109_157 VPWR VGND sg13g2_fill_1
XFILLER_50_45 VPWR VGND sg13g2_fill_2
X_0731_ VPWR VGND Tile_X0Y0_IHP_BRAM_top.Inst_IHP_BRAM_top_ConfigMem.Inst_frame2_bit29.Q
+ Tile_X0Y0_IHP_BRAM_top.Inst_IHP_BRAM_top_ConfigMem.Inst_frame2_bit30.Q _0194_ _0192_
+ _0195_ _0193_ sg13g2_a221oi_1
X_1780_ Tile_X0Y0_IHP_BRAM_top.Inst_IHP_BRAM_top_switch_matrix.W2BEG5 net191 VPWR
+ VGND sg13g2_buf_1
X_0800_ Tile_X0Y1_IHP_BRAM_bot.Inst_IHP_BRAM_bot_ConfigMem.Inst_frame6_bit14.Q A_DOUT_BRAM7
+ B_DOUT_BRAM7 _0065_ _0107_ Tile_X0Y1_IHP_BRAM_bot.Inst_IHP_BRAM_bot_ConfigMem.Inst_frame6_bit15.Q
+ Tile_X0Y1_IHP_BRAM_bot.Inst_IHP_BRAM_bot_switch_matrix.W2BEGb7 VPWR VGND sg13g2_mux4_1
X_0662_ Tile_X0Y0_IHP_BRAM_top.Inst_IHP_BRAM_top_ConfigMem.Inst_frame9_bit25.Q VPWR
+ _0138_ VGND Tile_X0Y0_IHP_BRAM_top.Inst_IHP_BRAM_top_ConfigMem.Inst_frame9_bit24.Q
+ Tile_X0Y0_IHP_BRAM_top.Inst_IHP_BRAM_top_switch_matrix.J_NS4_BEG12 sg13g2_o21ai_1
X_0593_ Tile_X0Y0_IHP_BRAM_top.Inst_IHP_BRAM_top_ConfigMem.Inst_frame5_bit30.Q A_DOUT_BRAM15
+ Tile_X0Y0_IHP_BRAM_top.Inst_IHP_BRAM_top_switch_matrix.J_NS4_BEG4 Tile_X0Y0_IHP_BRAM_top.Inst_IHP_BRAM_top_switch_matrix.J_NS4_BEG8
+ Tile_X0Y0_IHP_BRAM_top.Inst_IHP_BRAM_top_switch_matrix.J_NS2_BEG3 Tile_X0Y0_IHP_BRAM_top.Inst_IHP_BRAM_top_ConfigMem.Inst_frame5_bit31.Q
+ Tile_X0Y0_IHP_BRAM_top.Inst_IHP_BRAM_top_switch_matrix.W6BEG7 VPWR VGND sg13g2_mux4_1
X_1145_ Tile_X0Y0_FrameData[18] Tile_X0Y1_FrameStrobe[3] Tile_X0Y0_IHP_BRAM_top.Inst_IHP_BRAM_top_ConfigMem.Inst_frame3_bit18.Q
+ VPWR VGND sg13g2_dlhq_1
X_1214_ Tile_X0Y0_FrameData[13] Tile_X0Y1_FrameStrobe[5] Tile_X0Y0_IHP_BRAM_top.Inst_IHP_BRAM_top_ConfigMem.Inst_frame5_bit13.Q
+ VPWR VGND sg13g2_dlhq_1
X_1076_ Tile_X0Y0_FrameData[23] Tile_X0Y1_FrameStrobe[1] Tile_X0Y0_IHP_BRAM_top.Inst_IHP_BRAM_top_ConfigMem.Inst_frame1_bit23.Q
+ VPWR VGND sg13g2_dlhq_1
X_0929_ _0023_ _0102_ _0279_ VPWR VGND sg13g2_nor2_1
XFILLER_61_55 VPWR VGND sg13g2_decap_8
XFILLER_61_33 VPWR VGND sg13g2_fill_1
XFILLER_86_74 VPWR VGND sg13g2_fill_2
XFILLER_34_103 VPWR VGND sg13g2_decap_8
X_1901_ Tile_X0Y1_IHP_BRAM_bot.Inst_IHP_BRAM_bot_switch_matrix.W2BEGb2 net312 VPWR
+ VGND sg13g2_buf_1
X_1832_ Tile_X0Y1_FrameData[13] net234 VPWR VGND sg13g2_buf_1
X_1763_ Tile_X0Y0_IHP_BRAM_top.N4BEG_outbuf_9.A net180 VPWR VGND sg13g2_buf_1
X_1694_ Tile_X0Y0_FrameData[12] net96 VPWR VGND sg13g2_buf_1
X_0714_ Tile_X0Y0_IHP_BRAM_top.Inst_IHP_BRAM_top_ConfigMem.Inst_frame7_bit4.Q _0183_
+ _0184_ VPWR VGND sg13g2_nor2_1
X_0645_ Tile_X0Y0_E2MID[0] Tile_X0Y0_IHP_BRAM_top.Inst_IHP_BRAM_top_ConfigMem.Inst_frame2_bit18.Q
+ Tile_X0Y0_IHP_BRAM_top.Inst_IHP_BRAM_top_ConfigMem.Inst_frame2_bit19.Q _0126_ VPWR
+ VGND sg13g2_nor3_1
X_0576_ Tile_X0Y0_IHP_BRAM_top.Inst_IHP_BRAM_top_ConfigMem.Inst_frame1_bit16.Q Tile_X0Y0_IHP_BRAM_top.Inst_IHP_BRAM_top_switch_matrix.N1END0
+ Tile_X0Y1_N4END[4] Tile_X0Y0_S1END[0] Tile_X0Y0_S4END[0] Tile_X0Y0_IHP_BRAM_top.Inst_IHP_BRAM_top_ConfigMem.Inst_frame1_bit17.Q
+ Tile_X0Y0_IHP_BRAM_top.Inst_IHP_BRAM_top_switch_matrix.J_NS4_BEG4 VPWR VGND sg13g2_mux4_1
XFILLER_32_0 VPWR VGND sg13g2_fill_1
X_1059_ Tile_X0Y0_FrameData[8] Tile_X0Y1_FrameStrobe[0] Tile_X0Y0_IHP_BRAM_top.Inst_IHP_BRAM_top_ConfigMem.Inst_frame0_bit8.Q
+ VPWR VGND sg13g2_dlhq_1
X_1128_ Tile_X0Y0_FrameData[3] Tile_X0Y1_FrameStrobe[2] Tile_X0Y0_IHP_BRAM_top.Inst_IHP_BRAM_top_ConfigMem.Inst_frame2_bit3.Q
+ VPWR VGND sg13g2_dlhq_1
XFILLER_72_209 VPWR VGND sg13g2_fill_2
XFILLER_15_48 VPWR VGND sg13g2_fill_1
Xoutput47 net47 B_ADDR_BRAM0 VPWR VGND sg13g2_buf_1
XFILLER_0_213 VPWR VGND sg13g2_fill_2
Xoutput36 net36 A_DIN_BRAM2 VPWR VGND sg13g2_buf_1
Xoutput14 net14 A_BM_BRAM11 VPWR VGND sg13g2_buf_1
Xoutput25 net25 A_BM_BRAM8 VPWR VGND sg13g2_buf_1
Xoutput69 net69 B_BM_BRAM6 VPWR VGND sg13g2_buf_1
Xoutput58 net58 B_BM_BRAM1 VPWR VGND sg13g2_buf_1
XFILLER_56_22 VPWR VGND sg13g2_fill_2
XFILLER_56_77 VPWR VGND sg13g2_fill_1
X_0430_ VGND VPWR Tile_X0Y0_IHP_BRAM_top.Inst_IHP_BRAM_top_ConfigMem.Inst_frame1_bit1.Q
+ _0049_ _0050_ Tile_X0Y0_IHP_BRAM_top.Inst_IHP_BRAM_top_ConfigMem.Inst_frame1_bit2.Q
+ sg13g2_a21oi_1
X_1815_ Tile_X0Y0_IHP_BRAM_top.Inst_IHP_BRAM_top_switch_matrix.WW4BEG12 net217 VPWR
+ VGND sg13g2_buf_1
X_1746_ Tile_X0Y0_IHP_BRAM_top.Inst_IHP_BRAM_top_switch_matrix.N2BEGb0 net157 VPWR
+ VGND sg13g2_buf_1
X_0628_ VPWR VGND Tile_X0Y0_IHP_BRAM_top.Inst_IHP_BRAM_top_ConfigMem.Inst_frame3_bit16.Q
+ _0124_ _0125_ Tile_X0Y0_IHP_BRAM_top.Inst_IHP_BRAM_top_ConfigMem.Inst_frame3_bit17.Q
+ net10 _0045_ sg13g2_a221oi_1
X_1677_ VPWR VGND A_TIE_HIGH_BRAM sg13g2_tiehi
X_0559_ Tile_X0Y0_IHP_BRAM_top.Inst_IHP_BRAM_top_ConfigMem.Inst_frame6_bit20.Q A_DOUT_BRAM10
+ B_DOUT_BRAM14 Tile_X0Y0_IHP_BRAM_top.Inst_IHP_BRAM_top_switch_matrix.J_NS4_BEG13
+ Tile_X0Y0_IHP_BRAM_top.Inst_IHP_BRAM_top_switch_matrix.J_NS2_BEG5 Tile_X0Y0_IHP_BRAM_top.Inst_IHP_BRAM_top_ConfigMem.Inst_frame6_bit21.Q
+ Tile_X0Y0_IHP_BRAM_top.Inst_IHP_BRAM_top_switch_matrix.WW4BEG2 VPWR VGND sg13g2_mux4_1
XFILLER_83_75 VPWR VGND sg13g2_decap_8
XFILLER_80_8 VPWR VGND sg13g2_fill_2
XFILLER_16_80 VPWR VGND sg13g2_fill_1
X_1531_ Tile_X0Y1_FrameData[16] Tile_X0Y1_FrameStrobe[5] Tile_X0Y1_IHP_BRAM_bot.Inst_IHP_BRAM_bot_ConfigMem.Inst_frame5_bit16.Q
+ VPWR VGND sg13g2_dlhq_1
X_1600_ Tile_X0Y1_FrameData[11] Tile_X0Y1_FrameStrobe[7] Tile_X0Y1_IHP_BRAM_bot.Inst_IHP_BRAM_bot_ConfigMem.Inst_frame7_bit11.Q
+ VPWR VGND sg13g2_dlhq_1
X_1462_ Tile_X0Y1_FrameData[21] Tile_X0Y1_FrameStrobe[3] Tile_X0Y1_IHP_BRAM_bot.Inst_IHP_BRAM_bot_ConfigMem.Inst_frame3_bit21.Q
+ VPWR VGND sg13g2_dlhq_1
X_0413_ VPWR _0036_ Tile_X0Y1_IHP_BRAM_bot.Inst_IHP_BRAM_bot_ConfigMem.Inst_frame7_bit6.Q
+ VGND sg13g2_inv_1
X_1393_ Tile_X0Y1_FrameData[26] Tile_X0Y1_FrameStrobe[1] Tile_X0Y1_IHP_BRAM_bot.Inst_IHP_BRAM_bot_ConfigMem.Inst_frame1_bit26.Q
+ VPWR VGND sg13g2_dlhq_1
X_1729_ Tile_X0Y1_FrameStrobe[15] net131 VPWR VGND sg13g2_buf_1
XFILLER_85_120 VPWR VGND sg13g2_fill_1
XFILLER_94_63 VPWR VGND sg13g2_fill_1
XFILLER_76_153 VPWR VGND sg13g2_decap_4
X_0962_ _0029_ _0105_ _0309_ VPWR VGND sg13g2_nor2_1
X_0893_ Tile_X0Y1_IHP_BRAM_bot.Inst_IHP_BRAM_bot_ConfigMem.Inst_frame2_bit7.Q _0105_
+ _0261_ VPWR VGND Tile_X0Y1_IHP_BRAM_bot.Inst_IHP_BRAM_bot_ConfigMem.Inst_frame2_bit6.Q
+ sg13g2_nand3b_1
Xoutput204 net204 Tile_X0Y0_W6BEG[11] VPWR VGND sg13g2_buf_1
Xoutput215 net215 Tile_X0Y0_WW4BEG[10] VPWR VGND sg13g2_buf_1
Xoutput226 net226 Tile_X0Y0_WW4BEG[6] VPWR VGND sg13g2_buf_1
Xoutput248 net248 Tile_X0Y1_FrameData_O[26] VPWR VGND sg13g2_buf_1
Xoutput237 net237 Tile_X0Y1_FrameData_O[16] VPWR VGND sg13g2_buf_1
X_1514_ Tile_X0Y1_FrameData[1] Tile_X0Y1_FrameStrobe[4] Tile_X0Y1_IHP_BRAM_bot.Inst_IHP_BRAM_bot_ConfigMem.Inst_frame4_bit1.Q
+ VPWR VGND sg13g2_dlhq_1
X_1445_ Tile_X0Y1_FrameData[6] Tile_X0Y1_FrameStrobe[2] Tile_X0Y1_IHP_BRAM_bot.Inst_IHP_BRAM_bot_ConfigMem.Inst_frame2_bit6.Q
+ VPWR VGND sg13g2_dlhq_1
Xoutput259 net259 Tile_X0Y1_FrameData_O[7] VPWR VGND sg13g2_buf_1
XFILLER_57_2 VPWR VGND sg13g2_fill_1
X_1376_ Tile_X0Y1_FrameData[11] Tile_X0Y1_FrameStrobe[0] Tile_X0Y1_IHP_BRAM_bot.Inst_IHP_BRAM_bot_ConfigMem.Inst_frame0_bit11.Q
+ VPWR VGND sg13g2_dlhq_1
XFILLER_58_120 VPWR VGND sg13g2_fill_1
XFILLER_80_10 VPWR VGND sg13g2_fill_1
XFILLER_96_215 VPWR VGND sg13g2_fill_1
XFILLER_50_9 VPWR VGND sg13g2_fill_1
X_1161_ Tile_X0Y0_FrameData[2] Tile_X0Y1_FrameStrobe[3] Tile_X0Y0_IHP_BRAM_top.Inst_IHP_BRAM_top_ConfigMem.Inst_frame3_bit2.Q
+ VPWR VGND sg13g2_dlhq_1
X_1230_ Tile_X0Y0_FrameData[29] Tile_X0Y1_FrameStrobe[6] Tile_X0Y0_IHP_BRAM_top.Inst_IHP_BRAM_top_ConfigMem.Inst_frame6_bit29.Q
+ VPWR VGND sg13g2_dlhq_1
X_1092_ Tile_X0Y0_FrameData[7] Tile_X0Y1_FrameStrobe[1] Tile_X0Y0_IHP_BRAM_top.Inst_IHP_BRAM_top_ConfigMem.Inst_frame1_bit7.Q
+ VPWR VGND sg13g2_dlhq_1
XFILLER_20_215 VPWR VGND sg13g2_fill_1
XFILLER_109_18 VPWR VGND sg13g2_fill_2
XFILLER_62_0 VPWR VGND sg13g2_fill_1
X_0876_ Tile_X0Y1_IHP_BRAM_bot.Inst_IHP_BRAM_bot_ConfigMem.Inst_frame3_bit16.Q Tile_X0Y1_EE4END[7]
+ Tile_X0Y1_EE4END[15] Tile_X0Y1_E6END[7] Tile_X0Y1_IHP_BRAM_bot.Inst_IHP_BRAM_bot_switch_matrix.J_NS4_BEG7
+ Tile_X0Y1_IHP_BRAM_bot.Inst_IHP_BRAM_bot_ConfigMem.Inst_frame3_bit17.Q net24 VPWR
+ VGND sg13g2_mux4_1
X_0945_ VGND VPWR _0286_ _0288_ Tile_X0Y0_IHP_BRAM_top.N4BEG_outbuf_10.A _0293_ sg13g2_a21oi_1
X_1428_ Tile_X0Y1_FrameData[23] Tile_X0Y1_FrameStrobe[2] Tile_X0Y1_IHP_BRAM_bot.Inst_IHP_BRAM_bot_ConfigMem.Inst_frame2_bit23.Q
+ VPWR VGND sg13g2_dlhq_1
XFILLER_70_104 VPWR VGND sg13g2_fill_2
X_1359_ Tile_X0Y1_FrameData[28] Tile_X0Y1_FrameStrobe[0] Tile_X0Y1_IHP_BRAM_bot.Inst_IHP_BRAM_bot_ConfigMem.Inst_frame0_bit28.Q
+ VPWR VGND sg13g2_dlhq_1
XFILLER_55_145 VPWR VGND sg13g2_fill_1
XFILLER_59_66 VPWR VGND sg13g2_fill_1
XFILLER_50_68 VPWR VGND sg13g2_fill_2
XFILLER_75_76 VPWR VGND sg13g2_fill_2
XFILLER_59_88 VPWR VGND sg13g2_decap_8
XFILLER_61_148 VPWR VGND sg13g2_fill_1
XFILLER_61_115 VPWR VGND sg13g2_fill_1
XFILLER_61_104 VPWR VGND sg13g2_decap_8
X_0661_ Tile_X0Y0_IHP_BRAM_top.Inst_IHP_BRAM_top_switch_matrix.J_NS2_BEG0 Tile_X0Y0_IHP_BRAM_top.Inst_IHP_BRAM_top_ConfigMem.Inst_frame9_bit24.Q
+ _0137_ VPWR VGND sg13g2_nor2b_1
X_0730_ Tile_X0Y1_N2MID[3] Tile_X0Y0_E2MID[0] Tile_X0Y0_IHP_BRAM_top.Inst_IHP_BRAM_top_ConfigMem.Inst_frame2_bit28.Q
+ _0194_ VPWR VGND sg13g2_mux2_1
X_0592_ Tile_X0Y0_IHP_BRAM_top.Inst_IHP_BRAM_top_ConfigMem.Inst_frame5_bit28.Q A_DOUT_BRAM14
+ Tile_X0Y0_IHP_BRAM_top.Inst_IHP_BRAM_top_switch_matrix.J_NS4_BEG5 Tile_X0Y0_IHP_BRAM_top.Inst_IHP_BRAM_top_switch_matrix.J_NS4_BEG9
+ Tile_X0Y0_IHP_BRAM_top.Inst_IHP_BRAM_top_switch_matrix.J_NS2_BEG2 Tile_X0Y0_IHP_BRAM_top.Inst_IHP_BRAM_top_ConfigMem.Inst_frame5_bit29.Q
+ Tile_X0Y0_IHP_BRAM_top.Inst_IHP_BRAM_top_switch_matrix.W6BEG6 VPWR VGND sg13g2_mux4_1
X_1213_ Tile_X0Y0_FrameData[14] Tile_X0Y1_FrameStrobe[5] Tile_X0Y0_IHP_BRAM_top.Inst_IHP_BRAM_top_ConfigMem.Inst_frame5_bit14.Q
+ VPWR VGND sg13g2_dlhq_1
X_1075_ Tile_X0Y0_FrameData[24] Tile_X0Y1_FrameStrobe[1] Tile_X0Y0_IHP_BRAM_top.Inst_IHP_BRAM_top_ConfigMem.Inst_frame1_bit24.Q
+ VPWR VGND sg13g2_dlhq_1
X_1144_ Tile_X0Y0_FrameData[19] Tile_X0Y1_FrameStrobe[3] Tile_X0Y0_IHP_BRAM_top.Inst_IHP_BRAM_top_ConfigMem.Inst_frame3_bit19.Q
+ VPWR VGND sg13g2_dlhq_1
XFILLER_37_134 VPWR VGND sg13g2_decap_8
XFILLER_60_170 VPWR VGND sg13g2_decap_4
X_0859_ VGND VPWR Tile_X0Y1_E2END[4] Tile_X0Y1_IHP_BRAM_bot.Inst_IHP_BRAM_bot_ConfigMem.Inst_frame4_bit16.Q
+ _0248_ _0247_ sg13g2_a21oi_1
X_0928_ VGND VPWR _0024_ _0277_ _0278_ Tile_X0Y1_IHP_BRAM_bot.Inst_IHP_BRAM_bot_ConfigMem.Inst_frame9_bit29.Q
+ sg13g2_a21oi_1
XFILLER_101_52 VPWR VGND sg13g2_fill_2
XFILLER_61_12 VPWR VGND sg13g2_fill_2
XFILLER_43_148 VPWR VGND sg13g2_decap_8
XFILLER_105_183 VPWR VGND sg13g2_fill_2
X_1900_ Tile_X0Y1_IHP_BRAM_bot.Inst_IHP_BRAM_bot_switch_matrix.W2BEGb1 net311 VPWR
+ VGND sg13g2_buf_1
X_1831_ Tile_X0Y1_FrameData[12] net233 VPWR VGND sg13g2_buf_1
X_1762_ Tile_X0Y0_IHP_BRAM_top.N4BEG_outbuf_8.A net179 VPWR VGND sg13g2_buf_1
X_0713_ Tile_X0Y0_IHP_BRAM_top.Inst_IHP_BRAM_top_ConfigMem.Inst_frame7_bit3.Q Tile_X0Y0_E1END[2]
+ Tile_X0Y0_E6END[6] Tile_X0Y0_EE4END[14] Tile_X0Y0_IHP_BRAM_top.Inst_IHP_BRAM_top_switch_matrix.J_NS4_BEG2
+ Tile_X0Y0_IHP_BRAM_top.Inst_IHP_BRAM_top_ConfigMem.Inst_frame7_bit2.Q _0183_ VPWR
+ VGND sg13g2_mux4_1
X_1693_ Tile_X0Y0_FrameData[11] net95 VPWR VGND sg13g2_buf_1
X_0644_ Tile_X0Y0_IHP_BRAM_top.Inst_IHP_BRAM_top_ConfigMem.Inst_frame2_bit16.Q Tile_X0Y0_E1END[3]
+ Tile_X0Y0_EE4END[7] Tile_X0Y0_EE4END[15] Tile_X0Y0_IHP_BRAM_top.Inst_IHP_BRAM_top_switch_matrix.J_NS4_BEG15
+ Tile_X0Y0_IHP_BRAM_top.Inst_IHP_BRAM_top_ConfigMem.Inst_frame2_bit17.Q net64 VPWR
+ VGND sg13g2_mux4_1
XFILLER_111_186 VPWR VGND sg13g2_fill_1
X_0575_ Tile_X0Y0_IHP_BRAM_top.Inst_IHP_BRAM_top_ConfigMem.Inst_frame5_bit4.Q A_DOUT_BRAM14
+ B_DOUT_BRAM10 Tile_X0Y0_IHP_BRAM_top.Inst_IHP_BRAM_top_switch_matrix.J_NS4_BEG5
+ Tile_X0Y0_IHP_BRAM_top.Inst_IHP_BRAM_top_switch_matrix.J_NS2_BEG5 Tile_X0Y0_IHP_BRAM_top.Inst_IHP_BRAM_top_ConfigMem.Inst_frame5_bit5.Q
+ Tile_X0Y0_IHP_BRAM_top.Inst_IHP_BRAM_top_switch_matrix.WW4BEG10 VPWR VGND sg13g2_mux4_1
X_1127_ Tile_X0Y0_FrameData[4] Tile_X0Y1_FrameStrobe[2] Tile_X0Y0_IHP_BRAM_top.Inst_IHP_BRAM_top_ConfigMem.Inst_frame2_bit4.Q
+ VPWR VGND sg13g2_dlhq_1
X_1058_ Tile_X0Y0_FrameData[9] Tile_X0Y1_FrameStrobe[0] Tile_X0Y0_IHP_BRAM_top.Inst_IHP_BRAM_top_ConfigMem.Inst_frame0_bit9.Q
+ VPWR VGND sg13g2_dlhq_1
Xoutput26 net26 A_BM_BRAM9 VPWR VGND sg13g2_buf_1
Xoutput48 net48 B_ADDR_BRAM1 VPWR VGND sg13g2_buf_1
Xoutput37 net37 A_DIN_BRAM3 VPWR VGND sg13g2_buf_1
Xoutput15 net15 A_BM_BRAM12 VPWR VGND sg13g2_buf_1
Xoutput59 net59 B_BM_BRAM10 VPWR VGND sg13g2_buf_1
XFILLER_97_30 VPWR VGND sg13g2_fill_1
X_1745_ Tile_X0Y0_IHP_BRAM_top.Inst_IHP_BRAM_top_switch_matrix.N2BEG7 net156 VPWR
+ VGND sg13g2_buf_1
X_1814_ Tile_X0Y0_IHP_BRAM_top.Inst_IHP_BRAM_top_switch_matrix.WW4BEG11 net216 VPWR
+ VGND sg13g2_buf_1
XFILLER_7_72 VPWR VGND sg13g2_fill_1
X_0558_ Tile_X0Y0_IHP_BRAM_top.Inst_IHP_BRAM_top_ConfigMem.Inst_frame6_bit18.Q A_DOUT_BRAM9
+ B_DOUT_BRAM13 Tile_X0Y0_IHP_BRAM_top.Inst_IHP_BRAM_top_switch_matrix.J_NS4_BEG14
+ Tile_X0Y0_IHP_BRAM_top.Inst_IHP_BRAM_top_switch_matrix.J_NS2_BEG6 Tile_X0Y0_IHP_BRAM_top.Inst_IHP_BRAM_top_ConfigMem.Inst_frame6_bit19.Q
+ Tile_X0Y0_IHP_BRAM_top.Inst_IHP_BRAM_top_switch_matrix.WW4BEG1 VPWR VGND sg13g2_mux4_1
X_0627_ _0125_ Tile_X0Y0_E2END[4] Tile_X0Y0_IHP_BRAM_top.Inst_IHP_BRAM_top_ConfigMem.Inst_frame3_bit17.Q
+ VPWR VGND sg13g2_nand2b_1
X_1676_ VPWR VGND B_TIE_HIGH_BRAM sg13g2_tiehi
XFILLER_26_26 VPWR VGND sg13g2_fill_2
X_0489_ Tile_X0Y1_IHP_BRAM_bot.Inst_IHP_BRAM_bot_ConfigMem.Inst_frame0_bit31.Q _0097_
+ _0098_ VPWR VGND Tile_X0Y1_IHP_BRAM_bot.Inst_IHP_BRAM_bot_ConfigMem.Inst_frame0_bit30.Q
+ sg13g2_nand3b_1
XFILLER_83_54 VPWR VGND sg13g2_fill_1
X_1530_ Tile_X0Y1_FrameData[17] Tile_X0Y1_FrameStrobe[5] Tile_X0Y1_IHP_BRAM_bot.Inst_IHP_BRAM_bot_ConfigMem.Inst_frame5_bit17.Q
+ VPWR VGND sg13g2_dlhq_1
X_0412_ VPWR _0035_ Tile_X0Y1_IHP_BRAM_bot.Inst_IHP_BRAM_bot_ConfigMem.Inst_frame7_bit5.Q
+ VGND sg13g2_inv_1
X_1392_ Tile_X0Y1_FrameData[27] Tile_X0Y1_FrameStrobe[1] Tile_X0Y1_IHP_BRAM_bot.Inst_IHP_BRAM_bot_ConfigMem.Inst_frame1_bit27.Q
+ VPWR VGND sg13g2_dlhq_1
X_1461_ Tile_X0Y1_FrameData[22] Tile_X0Y1_FrameStrobe[3] Tile_X0Y1_IHP_BRAM_bot.Inst_IHP_BRAM_bot_ConfigMem.Inst_frame3_bit22.Q
+ VPWR VGND sg13g2_dlhq_1
XFILLER_92_0 VPWR VGND sg13g2_decap_8
X_1728_ Tile_X0Y1_FrameStrobe[14] net130 VPWR VGND sg13g2_buf_1
X_1659_ Tile_X0Y1_FrameData[16] Tile_X0Y1_FrameStrobe[9] Tile_X0Y1_IHP_BRAM_bot.Inst_IHP_BRAM_bot_ConfigMem.Inst_frame9_bit16.Q
+ VPWR VGND sg13g2_dlhq_1
XFILLER_53_35 VPWR VGND sg13g2_decap_8
XFILLER_5_169 VPWR VGND sg13g2_fill_2
XFILLER_94_75 VPWR VGND sg13g2_fill_2
XFILLER_91_168 VPWR VGND sg13g2_decap_4
X_0961_ VGND VPWR _0030_ _0307_ _0308_ Tile_X0Y1_IHP_BRAM_bot.Inst_IHP_BRAM_bot_ConfigMem.Inst_frame8_bit30.Q
+ sg13g2_a21oi_1
Xoutput205 net205 Tile_X0Y0_W6BEG[1] VPWR VGND sg13g2_buf_1
Xoutput216 net216 Tile_X0Y0_WW4BEG[11] VPWR VGND sg13g2_buf_1
XFILLER_64_4 VPWR VGND sg13g2_fill_2
X_0892_ _0258_ VPWR net50 VGND Tile_X0Y1_IHP_BRAM_bot.Inst_IHP_BRAM_bot_ConfigMem.Inst_frame2_bit5.Q
+ _0260_ sg13g2_o21ai_1
Xoutput227 net227 Tile_X0Y0_WW4BEG[7] VPWR VGND sg13g2_buf_1
Xoutput249 net249 Tile_X0Y1_FrameData_O[27] VPWR VGND sg13g2_buf_1
Xoutput238 net238 Tile_X0Y1_FrameData_O[17] VPWR VGND sg13g2_buf_1
X_1513_ Tile_X0Y1_FrameData[2] Tile_X0Y1_FrameStrobe[4] Tile_X0Y1_IHP_BRAM_bot.Inst_IHP_BRAM_bot_ConfigMem.Inst_frame4_bit2.Q
+ VPWR VGND sg13g2_dlhq_1
X_1444_ Tile_X0Y1_FrameData[7] Tile_X0Y1_FrameStrobe[2] Tile_X0Y1_IHP_BRAM_bot.Inst_IHP_BRAM_bot_ConfigMem.Inst_frame2_bit7.Q
+ VPWR VGND sg13g2_dlhq_1
X_1375_ Tile_X0Y1_FrameData[12] Tile_X0Y1_FrameStrobe[0] Tile_X0Y1_IHP_BRAM_bot.Inst_IHP_BRAM_bot_ConfigMem.Inst_frame0_bit12.Q
+ VPWR VGND sg13g2_dlhq_1
XFILLER_48_68 VPWR VGND sg13g2_fill_1
XFILLER_104_85 VPWR VGND sg13g2_fill_1
XFILLER_9_29 VPWR VGND sg13g2_fill_1
XFILLER_14_213 VPWR VGND sg13g2_fill_2
XFILLER_89_42 VPWR VGND sg13g2_decap_8
XFILLER_89_75 VPWR VGND sg13g2_fill_2
X_1160_ Tile_X0Y0_FrameData[3] Tile_X0Y1_FrameStrobe[3] Tile_X0Y0_IHP_BRAM_top.Inst_IHP_BRAM_top_ConfigMem.Inst_frame3_bit3.Q
+ VPWR VGND sg13g2_dlhq_1
X_1091_ Tile_X0Y0_FrameData[8] Tile_X0Y1_FrameStrobe[1] Tile_X0Y0_IHP_BRAM_top.Inst_IHP_BRAM_top_ConfigMem.Inst_frame1_bit8.Q
+ VPWR VGND sg13g2_dlhq_1
XFILLER_64_113 VPWR VGND sg13g2_decap_8
X_0944_ VGND VPWR _0026_ _0291_ _0293_ _0292_ sg13g2_a21oi_1
X_0875_ Tile_X0Y1_IHP_BRAM_bot.Inst_IHP_BRAM_bot_ConfigMem.Inst_frame3_bit14.Q Tile_X0Y1_EE4END[6]
+ Tile_X0Y1_EE4END[14] Tile_X0Y1_E6END[6] Tile_X0Y1_IHP_BRAM_bot.Inst_IHP_BRAM_bot_switch_matrix.J_NS4_BEG6
+ Tile_X0Y1_IHP_BRAM_bot.Inst_IHP_BRAM_bot_ConfigMem.Inst_frame3_bit15.Q net23 VPWR
+ VGND sg13g2_mux4_1
XFILLER_55_0 VPWR VGND sg13g2_fill_2
X_1427_ Tile_X0Y1_FrameData[24] Tile_X0Y1_FrameStrobe[2] Tile_X0Y1_IHP_BRAM_bot.Inst_IHP_BRAM_bot_ConfigMem.Inst_frame2_bit24.Q
+ VPWR VGND sg13g2_dlhq_1
X_1358_ Tile_X0Y1_FrameData[29] Tile_X0Y1_FrameStrobe[0] Tile_X0Y1_IHP_BRAM_bot.Inst_IHP_BRAM_bot_ConfigMem.Inst_frame0_bit29.Q
+ VPWR VGND sg13g2_dlhq_1
XFILLER_55_102 VPWR VGND sg13g2_fill_1
X_1289_ Tile_X0Y0_FrameData[2] Tile_X0Y1_FrameStrobe[7] Tile_X0Y0_IHP_BRAM_top.Inst_IHP_BRAM_top_ConfigMem.Inst_frame7_bit2.Q
+ VPWR VGND sg13g2_dlhq_1
XFILLER_91_76 VPWR VGND sg13g2_fill_2
X_0660_ Tile_X0Y0_IHP_BRAM_top.Inst_IHP_BRAM_top_switch_matrix.J_NS4_BEG4 Tile_X0Y0_IHP_BRAM_top.Inst_IHP_BRAM_top_switch_matrix.J_NS4_BEG8
+ Tile_X0Y0_IHP_BRAM_top.Inst_IHP_BRAM_top_ConfigMem.Inst_frame9_bit24.Q _0136_ VPWR
+ VGND sg13g2_mux2_1
X_0591_ Tile_X0Y0_IHP_BRAM_top.Inst_IHP_BRAM_top_ConfigMem.Inst_frame5_bit27.Q A_DOUT_BRAM13
+ Tile_X0Y0_IHP_BRAM_top.Inst_IHP_BRAM_top_switch_matrix.J_NS4_BEG10 Tile_X0Y0_IHP_BRAM_top.Inst_IHP_BRAM_top_switch_matrix.J_NS4_BEG6
+ Tile_X0Y0_IHP_BRAM_top.Inst_IHP_BRAM_top_switch_matrix.J_NS2_BEG1 Tile_X0Y0_IHP_BRAM_top.Inst_IHP_BRAM_top_ConfigMem.Inst_frame5_bit26.Q
+ Tile_X0Y0_IHP_BRAM_top.Inst_IHP_BRAM_top_switch_matrix.W6BEG5 VPWR VGND sg13g2_mux4_1
X_1212_ Tile_X0Y0_FrameData[15] Tile_X0Y1_FrameStrobe[5] Tile_X0Y0_IHP_BRAM_top.Inst_IHP_BRAM_top_ConfigMem.Inst_frame5_bit15.Q
+ VPWR VGND sg13g2_dlhq_1
XFILLER_27_4 VPWR VGND sg13g2_fill_2
X_1143_ Tile_X0Y0_FrameData[20] Tile_X0Y1_FrameStrobe[3] Tile_X0Y0_IHP_BRAM_top.Inst_IHP_BRAM_top_ConfigMem.Inst_frame3_bit20.Q
+ VPWR VGND sg13g2_dlhq_1
X_1074_ Tile_X0Y0_FrameData[25] Tile_X0Y1_FrameStrobe[1] Tile_X0Y0_IHP_BRAM_top.Inst_IHP_BRAM_top_ConfigMem.Inst_frame1_bit25.Q
+ VPWR VGND sg13g2_dlhq_1
XFILLER_52_105 VPWR VGND sg13g2_fill_1
X_0927_ Tile_X0Y1_E1END[1] Tile_X0Y1_EE4END[1] Tile_X0Y1_IHP_BRAM_bot.Inst_IHP_BRAM_bot_ConfigMem.Inst_frame9_bit27.Q
+ _0277_ VPWR VGND sg13g2_mux2_1
X_0789_ Tile_X0Y1_IHP_BRAM_bot.Inst_IHP_BRAM_bot_ConfigMem.Inst_frame7_bit24.Q A_DOUT_BRAM4
+ B_DOUT_BRAM4 _0104_ _0105_ Tile_X0Y1_IHP_BRAM_bot.Inst_IHP_BRAM_bot_ConfigMem.Inst_frame7_bit25.Q
+ Tile_X0Y1_IHP_BRAM_bot.Inst_IHP_BRAM_bot_switch_matrix.W2BEG4 VPWR VGND sg13g2_mux4_1
X_0858_ Tile_X0Y1_IHP_BRAM_bot.Inst_IHP_BRAM_bot_ConfigMem.Inst_frame4_bit16.Q Tile_X0Y1_E2MID[4]
+ _0247_ VPWR VGND sg13g2_nor2b_1
XFILLER_29_37 VPWR VGND sg13g2_fill_2
XFILLER_86_76 VPWR VGND sg13g2_fill_1
XFILLER_86_32 VPWR VGND sg13g2_decap_4
XFILLER_34_127 VPWR VGND sg13g2_fill_1
X_1761_ Tile_X0Y1_N4END[15] net178 VPWR VGND sg13g2_buf_1
X_1830_ Tile_X0Y1_FrameData[11] net232 VPWR VGND sg13g2_buf_1
X_0574_ Tile_X0Y0_IHP_BRAM_top.Inst_IHP_BRAM_top_ConfigMem.Inst_frame1_bit18.Q Tile_X0Y0_IHP_BRAM_top.Inst_IHP_BRAM_top_switch_matrix.N1END1
+ Tile_X0Y1_N4END[5] Tile_X0Y0_S1END[1] Tile_X0Y0_S4END[1] Tile_X0Y0_IHP_BRAM_top.Inst_IHP_BRAM_top_ConfigMem.Inst_frame1_bit19.Q
+ Tile_X0Y0_IHP_BRAM_top.Inst_IHP_BRAM_top_switch_matrix.J_NS4_BEG5 VPWR VGND sg13g2_mux4_1
X_0712_ VGND VPWR _0017_ _0178_ _0182_ _0181_ sg13g2_a21oi_1
X_1692_ Tile_X0Y0_FrameData[10] net94 VPWR VGND sg13g2_buf_1
X_0643_ Tile_X0Y0_IHP_BRAM_top.Inst_IHP_BRAM_top_ConfigMem.Inst_frame2_bit14.Q Tile_X0Y0_E1END[2]
+ Tile_X0Y0_EE4END[6] Tile_X0Y0_EE4END[14] Tile_X0Y0_IHP_BRAM_top.Inst_IHP_BRAM_top_switch_matrix.J_NS4_BEG14
+ Tile_X0Y0_IHP_BRAM_top.Inst_IHP_BRAM_top_ConfigMem.Inst_frame2_bit15.Q net63 VPWR
+ VGND sg13g2_mux4_1
X_1126_ Tile_X0Y0_FrameData[5] Tile_X0Y1_FrameStrobe[2] Tile_X0Y0_IHP_BRAM_top.Inst_IHP_BRAM_top_ConfigMem.Inst_frame2_bit5.Q
+ VPWR VGND sg13g2_dlhq_1
X_1057_ Tile_X0Y0_FrameData[10] Tile_X0Y1_FrameStrobe[0] Tile_X0Y0_IHP_BRAM_top.Inst_IHP_BRAM_top_ConfigMem.Inst_frame0_bit10.Q
+ VPWR VGND sg13g2_dlhq_1
XFILLER_102_176 VPWR VGND sg13g2_decap_4
Xoutput27 net27 A_CLK_BRAM VPWR VGND sg13g2_buf_1
Xoutput16 net16 A_BM_BRAM13 VPWR VGND sg13g2_buf_1
XFILLER_0_215 VPWR VGND sg13g2_fill_1
Xoutput38 net38 A_DIN_BRAM4 VPWR VGND sg13g2_buf_1
Xoutput49 net49 B_ADDR_BRAM2 VPWR VGND sg13g2_buf_1
XFILLER_71_211 VPWR VGND sg13g2_fill_1
XFILLER_56_24 VPWR VGND sg13g2_fill_1
XFILLER_97_97 VPWR VGND sg13g2_fill_2
X_1744_ Tile_X0Y0_IHP_BRAM_top.Inst_IHP_BRAM_top_switch_matrix.N2BEG6 net155 VPWR
+ VGND sg13g2_buf_1
X_1813_ Tile_X0Y0_IHP_BRAM_top.Inst_IHP_BRAM_top_switch_matrix.WW4BEG10 net215 VPWR
+ VGND sg13g2_buf_1
X_0557_ Tile_X0Y0_IHP_BRAM_top.Inst_IHP_BRAM_top_ConfigMem.Inst_frame6_bit16.Q A_DOUT_BRAM8
+ B_DOUT_BRAM12 Tile_X0Y0_IHP_BRAM_top.Inst_IHP_BRAM_top_switch_matrix.J_NS4_BEG15
+ Tile_X0Y0_IHP_BRAM_top.Inst_IHP_BRAM_top_switch_matrix.J_NS2_BEG7 Tile_X0Y0_IHP_BRAM_top.Inst_IHP_BRAM_top_ConfigMem.Inst_frame6_bit17.Q
+ Tile_X0Y0_IHP_BRAM_top.Inst_IHP_BRAM_top_switch_matrix.WW4BEG0 VPWR VGND sg13g2_mux4_1
X_0626_ Tile_X0Y0_E2MID[4] Tile_X0Y0_IHP_BRAM_top.Inst_IHP_BRAM_top_ConfigMem.Inst_frame3_bit16.Q
+ Tile_X0Y0_IHP_BRAM_top.Inst_IHP_BRAM_top_ConfigMem.Inst_frame3_bit17.Q _0124_ VPWR
+ VGND sg13g2_nor3_1
X_1675_ Tile_X0Y1_FrameData[0] Tile_X0Y1_FrameStrobe[9] Tile_X0Y1_IHP_BRAM_bot.Inst_IHP_BRAM_bot_ConfigMem.Inst_frame9_bit0.Q
+ VPWR VGND sg13g2_dlhq_1
X_0488_ Tile_X0Y0_IHP_BRAM_top.Inst_IHP_BRAM_top_ConfigMem.Inst_frame8_bit10.Q Tile_X0Y0_E1END[3]
+ Tile_X0Y0_E6END[11] Tile_X0Y0_IHP_BRAM_top.Inst_IHP_BRAM_top_switch_matrix.J_NS4_BEG15
+ _0096_ Tile_X0Y0_IHP_BRAM_top.Inst_IHP_BRAM_top_ConfigMem.Inst_frame8_bit11.Q _0097_
+ VPWR VGND sg13g2_mux4_1
X_1109_ Tile_X0Y0_FrameData[22] Tile_X0Y1_FrameStrobe[2] Tile_X0Y0_IHP_BRAM_top.Inst_IHP_BRAM_top_ConfigMem.Inst_frame2_bit22.Q
+ VPWR VGND sg13g2_dlhq_1
XFILLER_21_152 VPWR VGND sg13g2_fill_2
XFILLER_107_63 VPWR VGND sg13g2_fill_2
XFILLER_88_141 VPWR VGND sg13g2_decap_4
X_0411_ VPWR _0034_ Tile_X0Y1_IHP_BRAM_bot.Inst_IHP_BRAM_bot_ConfigMem.Inst_frame7_bit3.Q
+ VGND sg13g2_inv_1
X_1460_ Tile_X0Y1_FrameData[23] Tile_X0Y1_FrameStrobe[3] Tile_X0Y1_IHP_BRAM_bot.Inst_IHP_BRAM_bot_ConfigMem.Inst_frame3_bit23.Q
+ VPWR VGND sg13g2_dlhq_1
X_1391_ Tile_X0Y1_FrameData[28] Tile_X0Y1_FrameStrobe[1] Tile_X0Y1_IHP_BRAM_bot.Inst_IHP_BRAM_bot_ConfigMem.Inst_frame1_bit28.Q
+ VPWR VGND sg13g2_dlhq_1
XFILLER_85_0 VPWR VGND sg13g2_fill_1
X_1727_ Tile_X0Y1_FrameStrobe[13] net129 VPWR VGND sg13g2_buf_1
X_1658_ Tile_X0Y1_FrameData[17] Tile_X0Y1_FrameStrobe[9] Tile_X0Y1_IHP_BRAM_bot.Inst_IHP_BRAM_bot_ConfigMem.Inst_frame9_bit17.Q
+ VPWR VGND sg13g2_dlhq_1
X_0609_ Tile_X0Y0_IHP_BRAM_top.Inst_IHP_BRAM_top_ConfigMem.Inst_frame4_bit30.Q Tile_X0Y0_EE4END[3]
+ Tile_X0Y0_EE4END[11] Tile_X0Y0_E6END[3] Tile_X0Y0_IHP_BRAM_top.Inst_IHP_BRAM_top_switch_matrix.J_NS4_BEG3
+ Tile_X0Y0_IHP_BRAM_top.Inst_IHP_BRAM_top_ConfigMem.Inst_frame4_bit31.Q net14 VPWR
+ VGND sg13g2_mux4_1
X_1589_ Tile_X0Y1_FrameData[22] Tile_X0Y1_FrameStrobe[7] Tile_X0Y1_IHP_BRAM_bot.Inst_IHP_BRAM_bot_ConfigMem.Inst_frame7_bit22.Q
+ VPWR VGND sg13g2_dlhq_1
XFILLER_76_144 VPWR VGND sg13g2_decap_4
X_0960_ Tile_X0Y1_E1END[0] Tile_X0Y1_EE4END[12] Tile_X0Y1_IHP_BRAM_bot.Inst_IHP_BRAM_bot_ConfigMem.Inst_frame8_bit28.Q
+ _0307_ VPWR VGND sg13g2_mux2_1
XFILLER_99_214 VPWR VGND sg13g2_fill_2
Xoutput228 net228 Tile_X0Y0_WW4BEG[8] VPWR VGND sg13g2_buf_1
Xoutput206 net206 Tile_X0Y0_W6BEG[2] VPWR VGND sg13g2_buf_1
Xoutput217 net217 Tile_X0Y0_WW4BEG[12] VPWR VGND sg13g2_buf_1
Xoutput239 net239 Tile_X0Y1_FrameData_O[18] VPWR VGND sg13g2_buf_1
X_1512_ Tile_X0Y1_FrameData[3] Tile_X0Y1_FrameStrobe[4] Tile_X0Y1_IHP_BRAM_bot.Inst_IHP_BRAM_bot_ConfigMem.Inst_frame4_bit3.Q
+ VPWR VGND sg13g2_dlhq_1
X_0891_ VGND VPWR Tile_X0Y1_E2END[3] Tile_X0Y1_IHP_BRAM_bot.Inst_IHP_BRAM_bot_ConfigMem.Inst_frame2_bit4.Q
+ _0260_ _0259_ sg13g2_a21oi_1
X_1443_ Tile_X0Y1_FrameData[8] Tile_X0Y1_FrameStrobe[2] Tile_X0Y1_IHP_BRAM_bot.Inst_IHP_BRAM_bot_ConfigMem.Inst_frame2_bit8.Q
+ VPWR VGND sg13g2_dlhq_1
X_1374_ Tile_X0Y1_FrameData[13] Tile_X0Y1_FrameStrobe[0] Tile_X0Y1_IHP_BRAM_bot.Inst_IHP_BRAM_bot_ConfigMem.Inst_frame0_bit13.Q
+ VPWR VGND sg13g2_dlhq_1
XFILLER_67_188 VPWR VGND sg13g2_fill_2
XFILLER_73_103 VPWR VGND sg13g2_decap_8
XFILLER_58_166 VPWR VGND sg13g2_fill_2
XFILLER_58_144 VPWR VGND sg13g2_fill_1
XFILLER_58_100 VPWR VGND sg13g2_fill_1
XFILLER_73_169 VPWR VGND sg13g2_fill_2
XFILLER_64_57 VPWR VGND sg13g2_decap_4
XFILLER_89_98 VPWR VGND sg13g2_decap_4
XFILLER_1_151 VPWR VGND sg13g2_fill_1
XFILLER_49_144 VPWR VGND sg13g2_decap_8
X_1090_ Tile_X0Y0_FrameData[9] Tile_X0Y1_FrameStrobe[1] Tile_X0Y0_IHP_BRAM_top.Inst_IHP_BRAM_top_ConfigMem.Inst_frame1_bit9.Q
+ VPWR VGND sg13g2_dlhq_1
XFILLER_64_158 VPWR VGND sg13g2_decap_4
X_0874_ Tile_X0Y1_IHP_BRAM_bot.Inst_IHP_BRAM_bot_ConfigMem.Inst_frame3_bit12.Q Tile_X0Y1_EE4END[5]
+ Tile_X0Y1_EE4END[13] Tile_X0Y1_E6END[5] Tile_X0Y1_IHP_BRAM_bot.Inst_IHP_BRAM_bot_switch_matrix.J_NS4_BEG5
+ Tile_X0Y1_IHP_BRAM_bot.Inst_IHP_BRAM_bot_ConfigMem.Inst_frame3_bit13.Q net22 VPWR
+ VGND sg13g2_mux4_1
X_0943_ Tile_X0Y1_IHP_BRAM_bot.Inst_IHP_BRAM_bot_ConfigMem.Inst_frame8_bit0.Q VPWR
+ _0292_ VGND _0289_ _0290_ sg13g2_o21ai_1
X_1288_ Tile_X0Y0_FrameData[3] Tile_X0Y1_FrameStrobe[7] Tile_X0Y0_IHP_BRAM_top.Inst_IHP_BRAM_top_ConfigMem.Inst_frame7_bit3.Q
+ VPWR VGND sg13g2_dlhq_1
X_1426_ Tile_X0Y1_FrameData[25] Tile_X0Y1_FrameStrobe[2] Tile_X0Y1_IHP_BRAM_bot.Inst_IHP_BRAM_bot_ConfigMem.Inst_frame2_bit25.Q
+ VPWR VGND sg13g2_dlhq_1
X_1357_ Tile_X0Y1_FrameData[30] Tile_X0Y1_FrameStrobe[0] Tile_X0Y1_IHP_BRAM_bot.Inst_IHP_BRAM_bot_ConfigMem.Inst_frame0_bit30.Q
+ VPWR VGND sg13g2_dlhq_1
Xclkbuf_1_1__f_Tile_X0Y1_UserCLK clknet_0_Tile_X0Y1_UserCLK clknet_1_1__leaf_Tile_X0Y1_UserCLK
+ VPWR VGND sg13g2_buf_8
XFILLER_54_180 VPWR VGND sg13g2_decap_4
X_0590_ Tile_X0Y0_IHP_BRAM_top.Inst_IHP_BRAM_top_ConfigMem.Inst_frame5_bit25.Q A_DOUT_BRAM12
+ Tile_X0Y0_IHP_BRAM_top.Inst_IHP_BRAM_top_switch_matrix.J_NS4_BEG11 Tile_X0Y0_IHP_BRAM_top.Inst_IHP_BRAM_top_switch_matrix.J_NS4_BEG7
+ Tile_X0Y0_IHP_BRAM_top.Inst_IHP_BRAM_top_switch_matrix.J_NS2_BEG0 Tile_X0Y0_IHP_BRAM_top.Inst_IHP_BRAM_top_ConfigMem.Inst_frame5_bit24.Q
+ Tile_X0Y0_IHP_BRAM_top.Inst_IHP_BRAM_top_switch_matrix.W6BEG4 VPWR VGND sg13g2_mux4_1
XFILLER_40_81 VPWR VGND sg13g2_fill_1
X_1142_ Tile_X0Y0_FrameData[21] Tile_X0Y1_FrameStrobe[3] Tile_X0Y0_IHP_BRAM_top.Inst_IHP_BRAM_top_ConfigMem.Inst_frame3_bit21.Q
+ VPWR VGND sg13g2_dlhq_1
X_1211_ Tile_X0Y0_FrameData[16] Tile_X0Y1_FrameStrobe[5] Tile_X0Y0_IHP_BRAM_top.Inst_IHP_BRAM_top_ConfigMem.Inst_frame5_bit16.Q
+ VPWR VGND sg13g2_dlhq_1
XFILLER_1_20 VPWR VGND sg13g2_fill_1
X_1073_ Tile_X0Y0_FrameData[26] Tile_X0Y1_FrameStrobe[1] Tile_X0Y0_IHP_BRAM_top.Inst_IHP_BRAM_top_ConfigMem.Inst_frame1_bit26.Q
+ VPWR VGND sg13g2_dlhq_1
X_0857_ Tile_X0Y1_IHP_BRAM_bot.Inst_IHP_BRAM_bot_ConfigMem.Inst_frame4_bit17.Q _0105_
+ _0246_ VPWR VGND Tile_X0Y1_IHP_BRAM_bot.Inst_IHP_BRAM_bot_ConfigMem.Inst_frame4_bit16.Q
+ sg13g2_nand3b_1
X_0926_ _0275_ VPWR _0276_ VGND _0023_ _0232_ sg13g2_o21ai_1
X_0788_ Tile_X0Y1_IHP_BRAM_bot.Inst_IHP_BRAM_bot_ConfigMem.Inst_frame7_bit22.Q A_DOUT_BRAM3
+ B_DOUT_BRAM3 _0104_ _0105_ Tile_X0Y1_IHP_BRAM_bot.Inst_IHP_BRAM_bot_ConfigMem.Inst_frame7_bit23.Q
+ Tile_X0Y1_IHP_BRAM_bot.Inst_IHP_BRAM_bot_switch_matrix.W2BEG3 VPWR VGND sg13g2_mux4_1
X_1409_ Tile_X0Y1_FrameData[10] Tile_X0Y1_FrameStrobe[1] Tile_X0Y1_IHP_BRAM_bot.Inst_IHP_BRAM_bot_ConfigMem.Inst_frame1_bit10.Q
+ VPWR VGND sg13g2_dlhq_1
XFILLER_45_59 VPWR VGND sg13g2_fill_1
XFILLER_10_40 VPWR VGND sg13g2_fill_1
XFILLER_35_70 VPWR VGND sg13g2_fill_1
XFILLER_42_172 VPWR VGND sg13g2_fill_1
X_0711_ Tile_X0Y0_IHP_BRAM_top.Inst_IHP_BRAM_top_ConfigMem.Inst_frame7_bit4.Q VPWR
+ _0181_ VGND _0179_ _0180_ sg13g2_o21ai_1
X_1691_ Tile_X0Y0_FrameData[9] net124 VPWR VGND sg13g2_buf_1
X_1760_ Tile_X0Y1_N4END[14] net177 VPWR VGND sg13g2_buf_1
X_0642_ Tile_X0Y0_IHP_BRAM_top.Inst_IHP_BRAM_top_ConfigMem.Inst_frame2_bit12.Q Tile_X0Y0_E1END[1]
+ Tile_X0Y0_EE4END[5] Tile_X0Y0_EE4END[13] Tile_X0Y0_IHP_BRAM_top.Inst_IHP_BRAM_top_switch_matrix.J_NS4_BEG13
+ Tile_X0Y0_IHP_BRAM_top.Inst_IHP_BRAM_top_ConfigMem.Inst_frame2_bit13.Q net62 VPWR
+ VGND sg13g2_mux4_1
X_0573_ Tile_X0Y0_IHP_BRAM_top.Inst_IHP_BRAM_top_ConfigMem.Inst_frame5_bit2.Q A_DOUT_BRAM13
+ B_DOUT_BRAM9 Tile_X0Y0_IHP_BRAM_top.Inst_IHP_BRAM_top_switch_matrix.J_NS4_BEG6 Tile_X0Y0_IHP_BRAM_top.Inst_IHP_BRAM_top_switch_matrix.J_NS2_BEG6
+ Tile_X0Y0_IHP_BRAM_top.Inst_IHP_BRAM_top_ConfigMem.Inst_frame5_bit3.Q Tile_X0Y0_IHP_BRAM_top.Inst_IHP_BRAM_top_switch_matrix.WW4BEG9
+ VPWR VGND sg13g2_mux4_1
X_1125_ Tile_X0Y0_FrameData[6] Tile_X0Y1_FrameStrobe[2] Tile_X0Y0_IHP_BRAM_top.Inst_IHP_BRAM_top_ConfigMem.Inst_frame2_bit6.Q
+ VPWR VGND sg13g2_dlhq_1
X_1056_ Tile_X0Y0_FrameData[11] Tile_X0Y1_FrameStrobe[0] Tile_X0Y0_IHP_BRAM_top.Inst_IHP_BRAM_top_ConfigMem.Inst_frame0_bit11.Q
+ VPWR VGND sg13g2_dlhq_1
XFILLER_33_183 VPWR VGND sg13g2_fill_1
Xoutput17 net17 A_BM_BRAM14 VPWR VGND sg13g2_buf_1
Xoutput39 net39 A_DIN_BRAM5 VPWR VGND sg13g2_buf_1
X_1889_ Tile_X0Y1_IHP_BRAM_bot.Inst_IHP_BRAM_bot_switch_matrix.W1BEG2 net300 VPWR
+ VGND sg13g2_buf_1
X_0909_ Tile_X0Y1_IHP_BRAM_bot.Inst_IHP_BRAM_bot_ConfigMem.Inst_frame1_bit0.Q Tile_X0Y1_E1END[0]
+ Tile_X0Y1_EE4END[4] Tile_X0Y1_EE4END[12] Tile_X0Y1_IHP_BRAM_bot.Inst_IHP_BRAM_bot_switch_matrix.J_NS4_BEG12
+ Tile_X0Y1_IHP_BRAM_bot.Inst_IHP_BRAM_bot_ConfigMem.Inst_frame1_bit1.Q net67 VPWR
+ VGND sg13g2_mux4_1
Xoutput28 net28 A_DIN_BRAM0 VPWR VGND sg13g2_buf_1
XFILLER_102_155 VPWR VGND sg13g2_decap_8
XFILLER_102_133 VPWR VGND sg13g2_decap_8
XFILLER_31_109 VPWR VGND sg13g2_fill_1
XFILLER_46_80 VPWR VGND sg13g2_decap_8
XFILLER_46_91 VPWR VGND sg13g2_fill_2
X_1743_ Tile_X0Y0_IHP_BRAM_top.Inst_IHP_BRAM_top_switch_matrix.N2BEG5 net154 VPWR
+ VGND sg13g2_buf_1
X_1812_ Tile_X0Y0_IHP_BRAM_top.Inst_IHP_BRAM_top_switch_matrix.WW4BEG9 net229 VPWR
+ VGND sg13g2_buf_1
X_1674_ Tile_X0Y1_FrameData[1] Tile_X0Y1_FrameStrobe[9] Tile_X0Y1_IHP_BRAM_bot.Inst_IHP_BRAM_bot_ConfigMem.Inst_frame9_bit1.Q
+ VPWR VGND sg13g2_dlhq_1
X_0625_ VPWR VGND Tile_X0Y0_IHP_BRAM_top.Inst_IHP_BRAM_top_ConfigMem.Inst_frame3_bit14.Q
+ _0122_ _0123_ Tile_X0Y0_IHP_BRAM_top.Inst_IHP_BRAM_top_ConfigMem.Inst_frame3_bit15.Q
+ net9 _0044_ sg13g2_a221oi_1
X_0487_ VPWR VGND _0094_ _0095_ Tile_X0Y0_IHP_BRAM_top.Inst_IHP_BRAM_top_ConfigMem.Inst_frame0_bit31.Q
+ _0009_ _0096_ Tile_X0Y0_IHP_BRAM_top.Inst_IHP_BRAM_top_ConfigMem.Inst_frame0_bit30.Q
+ sg13g2_a221oi_1
X_0556_ Tile_X0Y0_IHP_BRAM_top.Inst_IHP_BRAM_top_ConfigMem.Inst_frame6_bit14.Q A_DOUT_BRAM15
+ B_DOUT_BRAM15 Tile_X0Y0_IHP_BRAM_top.Inst_IHP_BRAM_top_switch_matrix.J_NS2_BEG0
+ Tile_X0Y0_IHP_BRAM_top.Inst_IHP_BRAM_top_switch_matrix.J_NS2_BEG7 Tile_X0Y0_IHP_BRAM_top.Inst_IHP_BRAM_top_ConfigMem.Inst_frame6_bit15.Q
+ Tile_X0Y0_IHP_BRAM_top.Inst_IHP_BRAM_top_switch_matrix.W2BEGb7 VPWR VGND sg13g2_mux4_1
XFILLER_30_0 VPWR VGND sg13g2_fill_1
X_1039_ Tile_X0Y0_FrameData[28] Tile_X0Y1_FrameStrobe[0] Tile_X0Y0_IHP_BRAM_top.Inst_IHP_BRAM_top_ConfigMem.Inst_frame0_bit28.Q
+ VPWR VGND sg13g2_dlhq_1
X_1108_ Tile_X0Y0_FrameData[23] Tile_X0Y1_FrameStrobe[2] Tile_X0Y0_IHP_BRAM_top.Inst_IHP_BRAM_top_ConfigMem.Inst_frame2_bit23.Q
+ VPWR VGND sg13g2_dlhq_1
XFILLER_12_131 VPWR VGND sg13g2_fill_1
XFILLER_8_168 VPWR VGND sg13g2_fill_2
XFILLER_79_175 VPWR VGND sg13g2_fill_2
XFILLER_79_120 VPWR VGND sg13g2_fill_2
X_0410_ VPWR _0033_ Tile_X0Y1_IHP_BRAM_bot.Inst_IHP_BRAM_bot_ConfigMem.Inst_frame7_bit2.Q
+ VGND sg13g2_inv_1
X_1390_ Tile_X0Y1_FrameData[29] Tile_X0Y1_FrameStrobe[1] Tile_X0Y1_IHP_BRAM_bot.Inst_IHP_BRAM_bot_ConfigMem.Inst_frame1_bit29.Q
+ VPWR VGND sg13g2_dlhq_1
X_1726_ Tile_X0Y1_FrameStrobe[12] net128 VPWR VGND sg13g2_buf_1
X_0608_ Tile_X0Y0_IHP_BRAM_top.Inst_IHP_BRAM_top_ConfigMem.Inst_frame4_bit28.Q Tile_X0Y0_EE4END[2]
+ Tile_X0Y0_EE4END[10] Tile_X0Y0_E6END[2] Tile_X0Y0_IHP_BRAM_top.Inst_IHP_BRAM_top_switch_matrix.J_NS4_BEG2
+ Tile_X0Y0_IHP_BRAM_top.Inst_IHP_BRAM_top_ConfigMem.Inst_frame4_bit29.Q net13 VPWR
+ VGND sg13g2_mux4_1
X_1588_ Tile_X0Y1_FrameData[23] Tile_X0Y1_FrameStrobe[7] Tile_X0Y1_IHP_BRAM_bot.Inst_IHP_BRAM_bot_ConfigMem.Inst_frame7_bit23.Q
+ VPWR VGND sg13g2_dlhq_1
X_1657_ Tile_X0Y1_FrameData[18] Tile_X0Y1_FrameStrobe[9] Tile_X0Y1_IHP_BRAM_bot.Inst_IHP_BRAM_bot_ConfigMem.Inst_frame9_bit18.Q
+ VPWR VGND sg13g2_dlhq_1
X_0539_ Tile_X0Y0_IHP_BRAM_top.Inst_IHP_BRAM_top_ConfigMem.Inst_frame7_bit13.Q Tile_X0Y0_IHP_BRAM_top.Inst_IHP_BRAM_top_switch_matrix.N1END2
+ A_DOUT_BRAM8 Tile_X0Y0_S1END[2] A_DOUT_BRAM13 Tile_X0Y0_IHP_BRAM_top.Inst_IHP_BRAM_top_ConfigMem.Inst_frame7_bit12.Q
+ Tile_X0Y0_IHP_BRAM_top.Inst_IHP_BRAM_top_switch_matrix.W1BEG2 VPWR VGND sg13g2_mux4_1
XFILLER_78_12 VPWR VGND sg13g2_fill_2
XFILLER_94_77 VPWR VGND sg13g2_fill_1
XFILLER_91_126 VPWR VGND sg13g2_decap_8
X_0890_ _0005_ Tile_X0Y1_IHP_BRAM_bot.Inst_IHP_BRAM_bot_ConfigMem.Inst_frame2_bit4.Q
+ _0259_ VPWR VGND sg13g2_nor2_1
Xoutput207 net207 Tile_X0Y0_W6BEG[3] VPWR VGND sg13g2_buf_1
Xoutput229 net229 Tile_X0Y0_WW4BEG[9] VPWR VGND sg13g2_buf_1
Xoutput218 net218 Tile_X0Y0_WW4BEG[13] VPWR VGND sg13g2_buf_1
XFILLER_64_6 VPWR VGND sg13g2_fill_1
X_1442_ Tile_X0Y1_FrameData[9] Tile_X0Y1_FrameStrobe[2] Tile_X0Y1_IHP_BRAM_bot.Inst_IHP_BRAM_bot_ConfigMem.Inst_frame2_bit9.Q
+ VPWR VGND sg13g2_dlhq_1
X_1511_ Tile_X0Y1_FrameData[4] Tile_X0Y1_FrameStrobe[4] Tile_X0Y1_IHP_BRAM_bot.Inst_IHP_BRAM_bot_ConfigMem.Inst_frame4_bit4.Q
+ VPWR VGND sg13g2_dlhq_1
XFILLER_67_123 VPWR VGND sg13g2_fill_2
X_1373_ Tile_X0Y1_FrameData[14] Tile_X0Y1_FrameStrobe[0] Tile_X0Y1_IHP_BRAM_bot.Inst_IHP_BRAM_bot_ConfigMem.Inst_frame0_bit14.Q
+ VPWR VGND sg13g2_dlhq_1
X_1709_ Tile_X0Y0_FrameData[27] net112 VPWR VGND sg13g2_buf_1
XFILLER_104_65 VPWR VGND sg13g2_fill_2
XFILLER_73_137 VPWR VGND sg13g2_fill_1
XFILLER_14_215 VPWR VGND sg13g2_fill_1
XFILLER_89_77 VPWR VGND sg13g2_fill_1
XFILLER_49_112 VPWR VGND sg13g2_decap_8
X_0873_ Tile_X0Y1_IHP_BRAM_bot.Inst_IHP_BRAM_bot_ConfigMem.Inst_frame3_bit10.Q Tile_X0Y1_EE4END[4]
+ Tile_X0Y1_EE4END[12] Tile_X0Y1_E6END[4] Tile_X0Y1_IHP_BRAM_bot.Inst_IHP_BRAM_bot_switch_matrix.J_NS4_BEG4
+ Tile_X0Y1_IHP_BRAM_bot.Inst_IHP_BRAM_bot_ConfigMem.Inst_frame3_bit11.Q net21 VPWR
+ VGND sg13g2_mux4_1
X_0942_ Tile_X0Y1_IHP_BRAM_bot.Inst_IHP_BRAM_bot_switch_matrix.J_NS4_BEG6 Tile_X0Y1_IHP_BRAM_bot.Inst_IHP_BRAM_bot_switch_matrix.J_NS4_BEG10
+ Tile_X0Y1_IHP_BRAM_bot.Inst_IHP_BRAM_bot_ConfigMem.Inst_frame9_bit30.Q _0291_ VPWR
+ VGND sg13g2_mux2_1
X_1425_ Tile_X0Y1_FrameData[26] Tile_X0Y1_FrameStrobe[2] Tile_X0Y1_IHP_BRAM_bot.Inst_IHP_BRAM_bot_ConfigMem.Inst_frame2_bit26.Q
+ VPWR VGND sg13g2_dlhq_1
X_1287_ Tile_X0Y0_FrameData[4] Tile_X0Y1_FrameStrobe[7] Tile_X0Y0_IHP_BRAM_top.Inst_IHP_BRAM_top_ConfigMem.Inst_frame7_bit4.Q
+ VPWR VGND sg13g2_dlhq_1
X_1356_ Tile_X0Y1_FrameData[31] Tile_X0Y1_FrameStrobe[0] Tile_X0Y1_IHP_BRAM_bot.Inst_IHP_BRAM_bot_ConfigMem.Inst_frame0_bit31.Q
+ VPWR VGND sg13g2_dlhq_1
XFILLER_34_28 VPWR VGND sg13g2_decap_8
XFILLER_34_39 VPWR VGND sg13g2_fill_1
XFILLER_50_38 VPWR VGND sg13g2_decap_8
XFILLER_91_67 VPWR VGND sg13g2_fill_1
XFILLER_91_45 VPWR VGND sg13g2_fill_1
XFILLER_108_194 VPWR VGND sg13g2_fill_1
X_1072_ Tile_X0Y0_FrameData[27] Tile_X0Y1_FrameStrobe[1] Tile_X0Y0_IHP_BRAM_top.Inst_IHP_BRAM_top_ConfigMem.Inst_frame1_bit27.Q
+ VPWR VGND sg13g2_dlhq_1
X_1141_ Tile_X0Y0_FrameData[22] Tile_X0Y1_FrameStrobe[3] Tile_X0Y0_IHP_BRAM_top.Inst_IHP_BRAM_top_ConfigMem.Inst_frame3_bit22.Q
+ VPWR VGND sg13g2_dlhq_1
XFILLER_92_210 VPWR VGND sg13g2_fill_2
X_1210_ Tile_X0Y0_FrameData[17] Tile_X0Y1_FrameStrobe[5] Tile_X0Y0_IHP_BRAM_top.Inst_IHP_BRAM_top_ConfigMem.Inst_frame5_bit17.Q
+ VPWR VGND sg13g2_dlhq_1
XFILLER_27_6 VPWR VGND sg13g2_fill_1
XFILLER_37_148 VPWR VGND sg13g2_fill_2
X_0787_ Tile_X0Y1_IHP_BRAM_bot.Inst_IHP_BRAM_bot_ConfigMem.Inst_frame7_bit20.Q A_DOUT_BRAM2
+ B_DOUT_BRAM2 _0103_ _0106_ Tile_X0Y1_IHP_BRAM_bot.Inst_IHP_BRAM_bot_ConfigMem.Inst_frame7_bit21.Q
+ Tile_X0Y1_IHP_BRAM_bot.Inst_IHP_BRAM_bot_switch_matrix.W2BEG2 VPWR VGND sg13g2_mux4_1
X_0925_ VPWR _0275_ _0274_ VGND sg13g2_inv_1
X_0856_ _0243_ VPWR net4 VGND Tile_X0Y1_IHP_BRAM_bot.Inst_IHP_BRAM_bot_ConfigMem.Inst_frame4_bit15.Q
+ _0245_ sg13g2_o21ai_1
XFILLER_29_39 VPWR VGND sg13g2_fill_1
X_1408_ Tile_X0Y1_FrameData[11] Tile_X0Y1_FrameStrobe[1] Tile_X0Y1_IHP_BRAM_bot.Inst_IHP_BRAM_bot_ConfigMem.Inst_frame1_bit11.Q
+ VPWR VGND sg13g2_dlhq_1
XFILLER_101_33 VPWR VGND sg13g2_fill_2
X_1339_ Tile_X0Y0_FrameData[16] Tile_X0Y1_FrameStrobe[9] Tile_X0Y0_IHP_BRAM_top.Inst_IHP_BRAM_top_ConfigMem.Inst_frame9_bit16.Q
+ VPWR VGND sg13g2_dlhq_1
XFILLER_51_195 VPWR VGND sg13g2_fill_2
XFILLER_105_164 VPWR VGND sg13g2_fill_2
XFILLER_10_74 VPWR VGND sg13g2_fill_2
X_0710_ Tile_X0Y0_IHP_BRAM_top.Inst_IHP_BRAM_top_ConfigMem.Inst_frame7_bit3.Q VPWR
+ _0180_ VGND Tile_X0Y0_IHP_BRAM_top.Inst_IHP_BRAM_top_ConfigMem.Inst_frame7_bit2.Q
+ Tile_X0Y0_IHP_BRAM_top.Inst_IHP_BRAM_top_switch_matrix.J_NS4_BEG14 sg13g2_o21ai_1
X_1690_ Tile_X0Y0_FrameData[8] net123 VPWR VGND sg13g2_buf_1
X_0641_ Tile_X0Y0_IHP_BRAM_top.Inst_IHP_BRAM_top_ConfigMem.Inst_frame2_bit10.Q Tile_X0Y0_E1END[0]
+ Tile_X0Y0_EE4END[4] Tile_X0Y0_EE4END[12] Tile_X0Y0_IHP_BRAM_top.Inst_IHP_BRAM_top_switch_matrix.J_NS4_BEG12
+ Tile_X0Y0_IHP_BRAM_top.Inst_IHP_BRAM_top_ConfigMem.Inst_frame2_bit11.Q net61 VPWR
+ VGND sg13g2_mux4_1
X_0572_ Tile_X0Y0_IHP_BRAM_top.Inst_IHP_BRAM_top_ConfigMem.Inst_frame1_bit20.Q Tile_X0Y0_IHP_BRAM_top.Inst_IHP_BRAM_top_switch_matrix.N1END2
+ Tile_X0Y1_N4END[6] Tile_X0Y0_S1END[2] Tile_X0Y0_S4END[2] Tile_X0Y0_IHP_BRAM_top.Inst_IHP_BRAM_top_ConfigMem.Inst_frame1_bit21.Q
+ Tile_X0Y0_IHP_BRAM_top.Inst_IHP_BRAM_top_switch_matrix.J_NS4_BEG6 VPWR VGND sg13g2_mux4_1
X_1124_ Tile_X0Y0_FrameData[7] Tile_X0Y1_FrameStrobe[2] Tile_X0Y0_IHP_BRAM_top.Inst_IHP_BRAM_top_ConfigMem.Inst_frame2_bit7.Q
+ VPWR VGND sg13g2_dlhq_1
XFILLER_80_213 VPWR VGND sg13g2_fill_2
XFILLER_65_210 VPWR VGND sg13g2_fill_2
X_1055_ Tile_X0Y0_FrameData[12] Tile_X0Y1_FrameStrobe[0] Tile_X0Y0_IHP_BRAM_top.Inst_IHP_BRAM_top_ConfigMem.Inst_frame0_bit12.Q
+ VPWR VGND sg13g2_dlhq_1
Xoutput29 net29 A_DIN_BRAM1 VPWR VGND sg13g2_buf_1
Xoutput18 net18 A_BM_BRAM15 VPWR VGND sg13g2_buf_1
X_0839_ Tile_X0Y1_IHP_BRAM_bot.Inst_IHP_BRAM_bot_ConfigMem.Inst_frame4_bit5.Q A_DOUT_BRAM2
+ Tile_X0Y1_IHP_BRAM_bot.Inst_IHP_BRAM_bot_switch_matrix.J_NS4_BEG5 _0232_ _0046_
+ Tile_X0Y1_IHP_BRAM_bot.Inst_IHP_BRAM_bot_ConfigMem.Inst_frame4_bit4.Q Tile_X0Y1_IHP_BRAM_bot.Inst_IHP_BRAM_bot_switch_matrix.W6BEG10
+ VPWR VGND sg13g2_mux4_1
X_1888_ Tile_X0Y1_IHP_BRAM_bot.Inst_IHP_BRAM_bot_switch_matrix.W1BEG1 net299 VPWR
+ VGND sg13g2_buf_1
X_0908_ Tile_X0Y1_IHP_BRAM_bot.Inst_IHP_BRAM_bot_ConfigMem.Inst_frame2_bit30.Q Tile_X0Y1_EE4END[3]
+ Tile_X0Y1_EE4END[11] Tile_X0Y1_E6END[11] Tile_X0Y1_IHP_BRAM_bot.Inst_IHP_BRAM_bot_switch_matrix.J_NS4_BEG11
+ Tile_X0Y1_IHP_BRAM_bot.Inst_IHP_BRAM_bot_ConfigMem.Inst_frame2_bit31.Q net66 VPWR
+ VGND sg13g2_mux4_1
XANTENNA_80 VPWR VGND net290 sg13g2_antennanp
XFILLER_108_0 VPWR VGND sg13g2_fill_1
XFILLER_97_99 VPWR VGND sg13g2_fill_1
XFILLER_97_66 VPWR VGND sg13g2_fill_1
X_1811_ Tile_X0Y0_IHP_BRAM_top.Inst_IHP_BRAM_top_switch_matrix.WW4BEG8 net228 VPWR
+ VGND sg13g2_buf_1
XFILLER_15_140 VPWR VGND sg13g2_fill_2
X_1742_ Tile_X0Y0_IHP_BRAM_top.Inst_IHP_BRAM_top_switch_matrix.N2BEG4 net153 VPWR
+ VGND sg13g2_buf_1
X_1673_ Tile_X0Y1_FrameData[2] Tile_X0Y1_FrameStrobe[9] Tile_X0Y1_IHP_BRAM_bot.Inst_IHP_BRAM_bot_ConfigMem.Inst_frame9_bit2.Q
+ VPWR VGND sg13g2_dlhq_1
X_0624_ _0123_ Tile_X0Y0_E2END[3] Tile_X0Y0_IHP_BRAM_top.Inst_IHP_BRAM_top_ConfigMem.Inst_frame3_bit15.Q
+ VPWR VGND sg13g2_nand2b_1
X_0486_ Tile_X0Y0_IHP_BRAM_top.Inst_IHP_BRAM_top_ConfigMem.Inst_frame0_bit30.Q Tile_X0Y0_IHP_BRAM_top.Inst_IHP_BRAM_top_ConfigMem.Inst_frame0_bit31.Q
+ Tile_X0Y0_IHP_BRAM_top.Inst_IHP_BRAM_top_switch_matrix.N1END3 _0095_ VPWR VGND sg13g2_nor3_1
X_0555_ Tile_X0Y0_IHP_BRAM_top.Inst_IHP_BRAM_top_ConfigMem.Inst_frame6_bit12.Q A_DOUT_BRAM14
+ B_DOUT_BRAM14 Tile_X0Y0_IHP_BRAM_top.Inst_IHP_BRAM_top_switch_matrix.J_NS2_BEG1
+ Tile_X0Y0_IHP_BRAM_top.Inst_IHP_BRAM_top_switch_matrix.J_NS2_BEG6 Tile_X0Y0_IHP_BRAM_top.Inst_IHP_BRAM_top_ConfigMem.Inst_frame6_bit13.Q
+ Tile_X0Y0_IHP_BRAM_top.Inst_IHP_BRAM_top_switch_matrix.W2BEGb6 VPWR VGND sg13g2_mux4_1
X_1038_ Tile_X0Y0_FrameData[29] Tile_X0Y1_FrameStrobe[0] Tile_X0Y0_IHP_BRAM_top.Inst_IHP_BRAM_top_ConfigMem.Inst_frame0_bit29.Q
+ VPWR VGND sg13g2_dlhq_1
X_1107_ Tile_X0Y0_FrameData[24] Tile_X0Y1_FrameStrobe[2] Tile_X0Y0_IHP_BRAM_top.Inst_IHP_BRAM_top_ConfigMem.Inst_frame2_bit24.Q
+ VPWR VGND sg13g2_dlhq_1
XFILLER_42_39 VPWR VGND sg13g2_decap_4
X_1725_ Tile_X0Y1_FrameStrobe[11] net127 VPWR VGND sg13g2_buf_1
X_0607_ Tile_X0Y0_IHP_BRAM_top.Inst_IHP_BRAM_top_ConfigMem.Inst_frame4_bit26.Q Tile_X0Y0_EE4END[1]
+ Tile_X0Y0_EE4END[9] Tile_X0Y0_E6END[1] Tile_X0Y0_IHP_BRAM_top.Inst_IHP_BRAM_top_switch_matrix.J_NS4_BEG1
+ Tile_X0Y0_IHP_BRAM_top.Inst_IHP_BRAM_top_ConfigMem.Inst_frame4_bit27.Q net26 VPWR
+ VGND sg13g2_mux4_1
X_0538_ Tile_X0Y0_IHP_BRAM_top.Inst_IHP_BRAM_top_ConfigMem.Inst_frame7_bit11.Q Tile_X0Y0_IHP_BRAM_top.Inst_IHP_BRAM_top_switch_matrix.N1END1
+ A_DOUT_BRAM11 Tile_X0Y0_S1END[1] A_DOUT_BRAM14 Tile_X0Y0_IHP_BRAM_top.Inst_IHP_BRAM_top_ConfigMem.Inst_frame7_bit10.Q
+ Tile_X0Y0_IHP_BRAM_top.Inst_IHP_BRAM_top_switch_matrix.W1BEG1 VPWR VGND sg13g2_mux4_1
X_1587_ Tile_X0Y1_FrameData[24] Tile_X0Y1_FrameStrobe[7] Tile_X0Y1_IHP_BRAM_bot.Inst_IHP_BRAM_bot_ConfigMem.Inst_frame7_bit24.Q
+ VPWR VGND sg13g2_dlhq_1
X_1656_ Tile_X0Y1_FrameData[19] Tile_X0Y1_FrameStrobe[9] Tile_X0Y1_IHP_BRAM_bot.Inst_IHP_BRAM_bot_ConfigMem.Inst_frame9_bit19.Q
+ VPWR VGND sg13g2_dlhq_1
XFILLER_93_190 VPWR VGND sg13g2_fill_2
X_0469_ VGND VPWR Tile_X0Y1_E6END[1] Tile_X0Y1_IHP_BRAM_bot.Inst_IHP_BRAM_bot_ConfigMem.Inst_frame0_bit26.Q
+ _0084_ _0083_ sg13g2_a21oi_1
XFILLER_76_157 VPWR VGND sg13g2_fill_2
Xoutput208 net208 Tile_X0Y0_W6BEG[4] VPWR VGND sg13g2_buf_1
Xoutput219 net219 Tile_X0Y0_WW4BEG[14] VPWR VGND sg13g2_buf_1
XFILLER_4_183 VPWR VGND sg13g2_fill_2
X_1510_ Tile_X0Y1_FrameData[5] Tile_X0Y1_FrameStrobe[4] Tile_X0Y1_IHP_BRAM_bot.Inst_IHP_BRAM_bot_ConfigMem.Inst_frame4_bit5.Q
+ VPWR VGND sg13g2_dlhq_1
X_1441_ Tile_X0Y1_FrameData[10] Tile_X0Y1_FrameStrobe[2] Tile_X0Y1_IHP_BRAM_bot.Inst_IHP_BRAM_bot_ConfigMem.Inst_frame2_bit10.Q
+ VPWR VGND sg13g2_dlhq_1
X_1372_ Tile_X0Y1_FrameData[15] Tile_X0Y1_FrameStrobe[0] Tile_X0Y1_IHP_BRAM_bot.Inst_IHP_BRAM_bot_ConfigMem.Inst_frame0_bit15.Q
+ VPWR VGND sg13g2_dlhq_1
XFILLER_90_0 VPWR VGND sg13g2_fill_2
X_1708_ Tile_X0Y0_FrameData[26] net111 VPWR VGND sg13g2_buf_1
X_1639_ Tile_X0Y1_FrameData[4] Tile_X0Y1_FrameStrobe[8] Tile_X0Y1_IHP_BRAM_bot.Inst_IHP_BRAM_bot_ConfigMem.Inst_frame8_bit4.Q
+ VPWR VGND sg13g2_dlhq_1
XFILLER_80_36 VPWR VGND sg13g2_fill_2
XFILLER_64_138 VPWR VGND sg13g2_fill_2
X_0941_ Tile_X0Y1_IHP_BRAM_bot.Inst_IHP_BRAM_bot_ConfigMem.Inst_frame9_bit31.Q VPWR
+ _0290_ VGND Tile_X0Y1_IHP_BRAM_bot.Inst_IHP_BRAM_bot_ConfigMem.Inst_frame9_bit30.Q
+ Tile_X0Y1_IHP_BRAM_bot.Inst_IHP_BRAM_bot_switch_matrix.J_NS4_BEG14 sg13g2_o21ai_1
X_0872_ Tile_X0Y1_IHP_BRAM_bot.Inst_IHP_BRAM_bot_ConfigMem.Inst_frame3_bit8.Q Tile_X0Y1_EE4END[3]
+ Tile_X0Y1_EE4END[11] Tile_X0Y1_E6END[3] _0230_ Tile_X0Y1_IHP_BRAM_bot.Inst_IHP_BRAM_bot_ConfigMem.Inst_frame3_bit9.Q
+ net20 VPWR VGND sg13g2_mux4_1
X_1355_ Tile_X0Y0_FrameData[0] Tile_X0Y1_FrameStrobe[9] Tile_X0Y0_IHP_BRAM_top.Inst_IHP_BRAM_top_ConfigMem.Inst_frame9_bit0.Q
+ VPWR VGND sg13g2_dlhq_1
X_1424_ Tile_X0Y1_FrameData[27] Tile_X0Y1_FrameStrobe[2] Tile_X0Y1_IHP_BRAM_bot.Inst_IHP_BRAM_bot_ConfigMem.Inst_frame2_bit27.Q
+ VPWR VGND sg13g2_dlhq_1
X_1286_ Tile_X0Y0_FrameData[5] Tile_X0Y1_FrameStrobe[7] Tile_X0Y0_IHP_BRAM_top.Inst_IHP_BRAM_top_ConfigMem.Inst_frame7_bit5.Q
+ VPWR VGND sg13g2_dlhq_1
XFILLER_55_138 VPWR VGND sg13g2_decap_8
XFILLER_24_51 VPWR VGND sg13g2_fill_2
XFILLER_40_61 VPWR VGND sg13g2_fill_2
X_1071_ Tile_X0Y0_FrameData[28] Tile_X0Y1_FrameStrobe[1] Tile_X0Y0_IHP_BRAM_top.Inst_IHP_BRAM_top_ConfigMem.Inst_frame1_bit28.Q
+ VPWR VGND sg13g2_dlhq_1
X_1140_ Tile_X0Y0_FrameData[23] Tile_X0Y1_FrameStrobe[3] Tile_X0Y0_IHP_BRAM_top.Inst_IHP_BRAM_top_ConfigMem.Inst_frame3_bit23.Q
+ VPWR VGND sg13g2_dlhq_1
XFILLER_60_163 VPWR VGND sg13g2_decap_8
X_0924_ Tile_X0Y1_IHP_BRAM_bot.Inst_IHP_BRAM_bot_ConfigMem.Inst_frame9_bit28.Q VPWR
+ _0274_ VGND Tile_X0Y1_E6END[9] Tile_X0Y1_IHP_BRAM_bot.Inst_IHP_BRAM_bot_ConfigMem.Inst_frame9_bit27.Q
+ sg13g2_o21ai_1
X_0786_ Tile_X0Y1_IHP_BRAM_bot.Inst_IHP_BRAM_bot_ConfigMem.Inst_frame7_bit18.Q A_DOUT_BRAM1
+ B_DOUT_BRAM1 _0102_ _0046_ Tile_X0Y1_IHP_BRAM_bot.Inst_IHP_BRAM_bot_ConfigMem.Inst_frame7_bit19.Q
+ Tile_X0Y1_IHP_BRAM_bot.Inst_IHP_BRAM_bot_switch_matrix.W2BEG1 VPWR VGND sg13g2_mux4_1
X_0855_ VGND VPWR Tile_X0Y1_E2END[3] Tile_X0Y1_IHP_BRAM_bot.Inst_IHP_BRAM_bot_ConfigMem.Inst_frame4_bit14.Q
+ _0245_ _0244_ sg13g2_a21oi_1
XFILLER_53_0 VPWR VGND sg13g2_fill_1
X_1338_ Tile_X0Y0_FrameData[17] Tile_X0Y1_FrameStrobe[9] Tile_X0Y0_IHP_BRAM_top.Inst_IHP_BRAM_top_ConfigMem.Inst_frame9_bit17.Q
+ VPWR VGND sg13g2_dlhq_1
X_1407_ Tile_X0Y1_FrameData[12] Tile_X0Y1_FrameStrobe[1] Tile_X0Y1_IHP_BRAM_bot.Inst_IHP_BRAM_bot_ConfigMem.Inst_frame1_bit12.Q
+ VPWR VGND sg13g2_dlhq_1
X_1269_ Tile_X0Y0_FrameData[22] Tile_X0Y1_FrameStrobe[7] Tile_X0Y0_IHP_BRAM_top.Inst_IHP_BRAM_top_ConfigMem.Inst_frame7_bit22.Q
+ VPWR VGND sg13g2_dlhq_1
XFILLER_105_176 VPWR VGND sg13g2_decap_8
XFILLER_3_215 VPWR VGND sg13g2_fill_1
X_0640_ Tile_X0Y0_IHP_BRAM_top.Inst_IHP_BRAM_top_ConfigMem.Inst_frame2_bit8.Q Tile_X0Y0_EE4END[3]
+ Tile_X0Y0_EE4END[11] Tile_X0Y0_E6END[11] Tile_X0Y0_IHP_BRAM_top.Inst_IHP_BRAM_top_switch_matrix.J_NS4_BEG11
+ Tile_X0Y0_IHP_BRAM_top.Inst_IHP_BRAM_top_ConfigMem.Inst_frame2_bit9.Q net60 VPWR
+ VGND sg13g2_mux4_1
X_0571_ Tile_X0Y0_IHP_BRAM_top.Inst_IHP_BRAM_top_ConfigMem.Inst_frame5_bit0.Q A_DOUT_BRAM12
+ B_DOUT_BRAM8 Tile_X0Y0_IHP_BRAM_top.Inst_IHP_BRAM_top_switch_matrix.J_NS4_BEG7 Tile_X0Y0_IHP_BRAM_top.Inst_IHP_BRAM_top_switch_matrix.J_NS2_BEG7
+ Tile_X0Y0_IHP_BRAM_top.Inst_IHP_BRAM_top_ConfigMem.Inst_frame5_bit1.Q Tile_X0Y0_IHP_BRAM_top.Inst_IHP_BRAM_top_switch_matrix.WW4BEG8
+ VPWR VGND sg13g2_mux4_1
X_1123_ Tile_X0Y0_FrameData[8] Tile_X0Y1_FrameStrobe[2] Tile_X0Y0_IHP_BRAM_top.Inst_IHP_BRAM_top_ConfigMem.Inst_frame2_bit8.Q
+ VPWR VGND sg13g2_dlhq_1
X_1054_ Tile_X0Y0_FrameData[13] Tile_X0Y1_FrameStrobe[0] Tile_X0Y0_IHP_BRAM_top.Inst_IHP_BRAM_top_ConfigMem.Inst_frame0_bit13.Q
+ VPWR VGND sg13g2_dlhq_1
X_1887_ Tile_X0Y1_IHP_BRAM_bot.Inst_IHP_BRAM_bot_switch_matrix.W1BEG0 net298 VPWR
+ VGND sg13g2_buf_1
X_0907_ Tile_X0Y1_IHP_BRAM_bot.Inst_IHP_BRAM_bot_ConfigMem.Inst_frame2_bit28.Q Tile_X0Y1_EE4END[2]
+ Tile_X0Y1_EE4END[10] Tile_X0Y1_E6END[10] Tile_X0Y1_IHP_BRAM_bot.Inst_IHP_BRAM_bot_switch_matrix.J_NS4_BEG10
+ Tile_X0Y1_IHP_BRAM_bot.Inst_IHP_BRAM_bot_ConfigMem.Inst_frame2_bit29.Q net65 VPWR
+ VGND sg13g2_mux4_1
Xoutput19 net19 A_BM_BRAM2 VPWR VGND sg13g2_buf_1
X_0838_ Tile_X0Y1_IHP_BRAM_bot.Inst_IHP_BRAM_bot_ConfigMem.Inst_frame4_bit3.Q A_DOUT_BRAM1
+ Tile_X0Y1_IHP_BRAM_bot.Inst_IHP_BRAM_bot_switch_matrix.J_NS4_BEG6 _0231_ _0106_
+ Tile_X0Y1_IHP_BRAM_bot.Inst_IHP_BRAM_bot_ConfigMem.Inst_frame4_bit2.Q Tile_X0Y1_IHP_BRAM_bot.Inst_IHP_BRAM_bot_switch_matrix.W6BEG9
+ VPWR VGND sg13g2_mux4_1
X_0769_ Tile_X0Y1_IHP_BRAM_bot.Inst_IHP_BRAM_bot_ConfigMem.Inst_frame8_bit4.Q Tile_X0Y1_E1END[0]
+ Tile_X0Y1_E6END[8] Tile_X0Y1_IHP_BRAM_bot.Inst_IHP_BRAM_bot_switch_matrix.J_NS4_BEG12
+ _0115_ Tile_X0Y1_IHP_BRAM_bot.Inst_IHP_BRAM_bot_ConfigMem.Inst_frame8_bit5.Q Tile_X0Y1_IHP_BRAM_bot.Inst_IHP_BRAM_bot_switch_matrix.S1BEG0
+ VPWR VGND sg13g2_mux4_1
XFILLER_56_49 VPWR VGND sg13g2_decap_4
XANTENNA_70 VPWR VGND Tile_X0Y1_N4END[5] sg13g2_antennanp
XANTENNA_81 VPWR VGND net290 sg13g2_antennanp
X_1741_ Tile_X0Y0_IHP_BRAM_top.Inst_IHP_BRAM_top_switch_matrix.N2BEG3 net152 VPWR
+ VGND sg13g2_buf_1
XFILLER_94_7 VPWR VGND sg13g2_fill_1
X_1810_ Tile_X0Y0_IHP_BRAM_top.Inst_IHP_BRAM_top_switch_matrix.WW4BEG7 net227 VPWR
+ VGND sg13g2_buf_1
X_0554_ Tile_X0Y0_IHP_BRAM_top.Inst_IHP_BRAM_top_ConfigMem.Inst_frame6_bit10.Q A_DOUT_BRAM13
+ B_DOUT_BRAM13 Tile_X0Y0_IHP_BRAM_top.Inst_IHP_BRAM_top_switch_matrix.J_NS2_BEG2
+ Tile_X0Y0_IHP_BRAM_top.Inst_IHP_BRAM_top_switch_matrix.J_NS2_BEG5 Tile_X0Y0_IHP_BRAM_top.Inst_IHP_BRAM_top_ConfigMem.Inst_frame6_bit11.Q
+ Tile_X0Y0_IHP_BRAM_top.Inst_IHP_BRAM_top_switch_matrix.W2BEGb5 VPWR VGND sg13g2_mux4_1
X_1672_ Tile_X0Y1_FrameData[3] Tile_X0Y1_FrameStrobe[9] Tile_X0Y1_IHP_BRAM_bot.Inst_IHP_BRAM_bot_ConfigMem.Inst_frame9_bit3.Q
+ VPWR VGND sg13g2_dlhq_1
X_0623_ Tile_X0Y0_E2MID[3] Tile_X0Y0_IHP_BRAM_top.Inst_IHP_BRAM_top_ConfigMem.Inst_frame3_bit14.Q
+ Tile_X0Y0_IHP_BRAM_top.Inst_IHP_BRAM_top_ConfigMem.Inst_frame3_bit15.Q _0122_ VPWR
+ VGND sg13g2_nor3_1
X_0485_ _0094_ Tile_X0Y0_S1END[3] Tile_X0Y0_IHP_BRAM_top.Inst_IHP_BRAM_top_ConfigMem.Inst_frame0_bit30.Q
+ VPWR VGND sg13g2_nand2b_1
X_1106_ Tile_X0Y0_FrameData[25] Tile_X0Y1_FrameStrobe[2] Tile_X0Y0_IHP_BRAM_top.Inst_IHP_BRAM_top_ConfigMem.Inst_frame2_bit25.Q
+ VPWR VGND sg13g2_dlhq_1
X_1037_ Tile_X0Y0_FrameData[30] Tile_X0Y1_FrameStrobe[0] Tile_X0Y0_IHP_BRAM_top.Inst_IHP_BRAM_top_ConfigMem.Inst_frame0_bit30.Q
+ VPWR VGND sg13g2_dlhq_1
XFILLER_21_122 VPWR VGND sg13g2_fill_1
XFILLER_42_18 VPWR VGND sg13g2_decap_4
XFILLER_107_55 VPWR VGND sg13g2_fill_1
XFILLER_83_47 VPWR VGND sg13g2_decap_8
X_1724_ Tile_X0Y1_FrameStrobe[10] net126 VPWR VGND sg13g2_buf_1
X_0606_ Tile_X0Y0_IHP_BRAM_top.Inst_IHP_BRAM_top_ConfigMem.Inst_frame4_bit24.Q Tile_X0Y0_EE4END[0]
+ Tile_X0Y0_EE4END[8] Tile_X0Y0_E6END[0] Tile_X0Y0_IHP_BRAM_top.Inst_IHP_BRAM_top_switch_matrix.J_NS4_BEG0
+ Tile_X0Y0_IHP_BRAM_top.Inst_IHP_BRAM_top_ConfigMem.Inst_frame4_bit25.Q net25 VPWR
+ VGND sg13g2_mux4_1
X_0537_ Tile_X0Y0_IHP_BRAM_top.Inst_IHP_BRAM_top_ConfigMem.Inst_frame7_bit9.Q Tile_X0Y0_IHP_BRAM_top.Inst_IHP_BRAM_top_switch_matrix.N1END0
+ A_DOUT_BRAM10 Tile_X0Y0_S1END[0] A_DOUT_BRAM15 Tile_X0Y0_IHP_BRAM_top.Inst_IHP_BRAM_top_ConfigMem.Inst_frame7_bit8.Q
+ Tile_X0Y0_IHP_BRAM_top.Inst_IHP_BRAM_top_switch_matrix.W1BEG0 VPWR VGND sg13g2_mux4_1
X_1586_ Tile_X0Y1_FrameData[25] Tile_X0Y1_FrameStrobe[7] Tile_X0Y1_IHP_BRAM_bot.Inst_IHP_BRAM_bot_ConfigMem.Inst_frame7_bit25.Q
+ VPWR VGND sg13g2_dlhq_1
X_1655_ Tile_X0Y1_FrameData[20] Tile_X0Y1_FrameStrobe[9] Tile_X0Y1_IHP_BRAM_bot.Inst_IHP_BRAM_bot_ConfigMem.Inst_frame9_bit20.Q
+ VPWR VGND sg13g2_dlhq_1
X_0399_ VPWR _0022_ Tile_X0Y1_IHP_BRAM_bot.Inst_IHP_BRAM_bot_ConfigMem.Inst_frame9_bit25.Q
+ VGND sg13g2_inv_1
X_0468_ Tile_X0Y1_IHP_BRAM_bot.Inst_IHP_BRAM_bot_ConfigMem.Inst_frame0_bit26.Q Tile_X0Y1_N1END[1]
+ _0083_ VPWR VGND sg13g2_nor2b_1
XFILLER_78_36 VPWR VGND sg13g2_fill_2
XFILLER_78_14 VPWR VGND sg13g2_fill_1
Xoutput209 net209 Tile_X0Y0_W6BEG[5] VPWR VGND sg13g2_buf_1
X_1440_ Tile_X0Y1_FrameData[11] Tile_X0Y1_FrameStrobe[2] Tile_X0Y1_IHP_BRAM_bot.Inst_IHP_BRAM_bot_ConfigMem.Inst_frame2_bit11.Q
+ VPWR VGND sg13g2_dlhq_1
X_1371_ Tile_X0Y1_FrameData[16] Tile_X0Y1_FrameStrobe[0] Tile_X0Y1_IHP_BRAM_bot.Inst_IHP_BRAM_bot_ConfigMem.Inst_frame0_bit16.Q
+ VPWR VGND sg13g2_dlhq_1
XFILLER_83_0 VPWR VGND sg13g2_fill_1
X_1707_ Tile_X0Y0_FrameData[25] net110 VPWR VGND sg13g2_buf_1
X_1638_ Tile_X0Y1_FrameData[5] Tile_X0Y1_FrameStrobe[8] Tile_X0Y1_IHP_BRAM_bot.Inst_IHP_BRAM_bot_ConfigMem.Inst_frame8_bit5.Q
+ VPWR VGND sg13g2_dlhq_1
X_1569_ Tile_X0Y1_FrameData[10] Tile_X0Y1_FrameStrobe[6] Tile_X0Y1_IHP_BRAM_bot.Inst_IHP_BRAM_bot_ConfigMem.Inst_frame6_bit10.Q
+ VPWR VGND sg13g2_dlhq_1
XFILLER_104_67 VPWR VGND sg13g2_fill_1
XFILLER_81_172 VPWR VGND sg13g2_fill_1
XFILLER_1_176 VPWR VGND sg13g2_fill_2
X_0940_ _0025_ _0103_ _0289_ VPWR VGND sg13g2_nor2_1
XFILLER_54_60 VPWR VGND sg13g2_fill_1
XFILLER_54_82 VPWR VGND sg13g2_fill_1
XFILLER_70_81 VPWR VGND sg13g2_fill_2
X_0871_ Tile_X0Y1_IHP_BRAM_bot.Inst_IHP_BRAM_bot_ConfigMem.Inst_frame3_bit6.Q Tile_X0Y1_EE4END[2]
+ Tile_X0Y1_EE4END[10] Tile_X0Y1_E6END[2] _0231_ Tile_X0Y1_IHP_BRAM_bot.Inst_IHP_BRAM_bot_ConfigMem.Inst_frame3_bit7.Q
+ net19 VPWR VGND sg13g2_mux4_1
X_1354_ Tile_X0Y0_FrameData[1] Tile_X0Y1_FrameStrobe[9] Tile_X0Y0_IHP_BRAM_top.Inst_IHP_BRAM_top_ConfigMem.Inst_frame9_bit1.Q
+ VPWR VGND sg13g2_dlhq_1
X_1285_ Tile_X0Y0_FrameData[6] Tile_X0Y1_FrameStrobe[7] Tile_X0Y0_IHP_BRAM_top.Inst_IHP_BRAM_top_ConfigMem.Inst_frame7_bit6.Q
+ VPWR VGND sg13g2_dlhq_1
X_1423_ Tile_X0Y1_FrameData[28] Tile_X0Y1_FrameStrobe[2] Tile_X0Y1_IHP_BRAM_bot.Inst_IHP_BRAM_bot_ConfigMem.Inst_frame2_bit28.Q
+ VPWR VGND sg13g2_dlhq_1
XFILLER_63_172 VPWR VGND sg13g2_fill_2
XFILLER_108_174 VPWR VGND sg13g2_fill_1
XFILLER_6_213 VPWR VGND sg13g2_fill_2
XFILLER_49_71 VPWR VGND sg13g2_fill_1
XFILLER_49_93 VPWR VGND sg13g2_fill_2
X_1070_ Tile_X0Y0_FrameData[29] Tile_X0Y1_FrameStrobe[1] Tile_X0Y0_IHP_BRAM_top.Inst_IHP_BRAM_top_ConfigMem.Inst_frame1_bit29.Q
+ VPWR VGND sg13g2_dlhq_1
XFILLER_37_128 VPWR VGND sg13g2_fill_1
X_0923_ VGND VPWR _0266_ _0268_ Tile_X0Y0_IHP_BRAM_top.N4BEG_outbuf_8.A _0273_ sg13g2_a21oi_1
X_0854_ _0005_ Tile_X0Y1_IHP_BRAM_bot.Inst_IHP_BRAM_bot_ConfigMem.Inst_frame4_bit14.Q
+ _0244_ VPWR VGND sg13g2_nor2_1
X_0785_ Tile_X0Y1_IHP_BRAM_bot.Inst_IHP_BRAM_bot_ConfigMem.Inst_frame7_bit16.Q A_DOUT_BRAM0
+ B_DOUT_BRAM0 _0065_ _0107_ Tile_X0Y1_IHP_BRAM_bot.Inst_IHP_BRAM_bot_ConfigMem.Inst_frame7_bit17.Q
+ Tile_X0Y1_IHP_BRAM_bot.Inst_IHP_BRAM_bot_switch_matrix.W2BEG0 VPWR VGND sg13g2_mux4_1
XFILLER_46_0 VPWR VGND sg13g2_fill_1
X_1337_ Tile_X0Y0_FrameData[18] Tile_X0Y1_FrameStrobe[9] Tile_X0Y0_IHP_BRAM_top.Inst_IHP_BRAM_top_ConfigMem.Inst_frame9_bit18.Q
+ VPWR VGND sg13g2_dlhq_1
X_1406_ Tile_X0Y1_FrameData[13] Tile_X0Y1_FrameStrobe[1] Tile_X0Y1_IHP_BRAM_bot.Inst_IHP_BRAM_bot_ConfigMem.Inst_frame1_bit13.Q
+ VPWR VGND sg13g2_dlhq_1
X_1268_ Tile_X0Y0_FrameData[23] Tile_X0Y1_FrameStrobe[7] Tile_X0Y0_IHP_BRAM_top.Inst_IHP_BRAM_top_ConfigMem.Inst_frame7_bit23.Q
+ VPWR VGND sg13g2_dlhq_1
XFILLER_101_57 VPWR VGND sg13g2_fill_2
X_1199_ Tile_X0Y0_FrameData[28] Tile_X0Y1_FrameStrobe[5] Tile_X0Y0_IHP_BRAM_top.Inst_IHP_BRAM_top_ConfigMem.Inst_frame5_bit28.Q
+ VPWR VGND sg13g2_dlhq_1
XFILLER_86_36 VPWR VGND sg13g2_fill_1
XFILLER_86_25 VPWR VGND sg13g2_decap_8
XFILLER_27_172 VPWR VGND sg13g2_fill_1
XFILLER_27_194 VPWR VGND sg13g2_fill_1
XFILLER_35_40 VPWR VGND sg13g2_decap_4
XFILLER_42_153 VPWR VGND sg13g2_fill_2
X_0570_ Tile_X0Y0_IHP_BRAM_top.Inst_IHP_BRAM_top_ConfigMem.Inst_frame1_bit22.Q Tile_X0Y0_IHP_BRAM_top.Inst_IHP_BRAM_top_switch_matrix.N1END3
+ Tile_X0Y1_N4END[7] Tile_X0Y0_S1END[3] Tile_X0Y0_S4END[3] Tile_X0Y0_IHP_BRAM_top.Inst_IHP_BRAM_top_ConfigMem.Inst_frame1_bit23.Q
+ Tile_X0Y0_IHP_BRAM_top.Inst_IHP_BRAM_top_switch_matrix.J_NS4_BEG7 VPWR VGND sg13g2_mux4_1
X_1122_ Tile_X0Y0_FrameData[9] Tile_X0Y1_FrameStrobe[2] Tile_X0Y0_IHP_BRAM_top.Inst_IHP_BRAM_top_ConfigMem.Inst_frame2_bit9.Q
+ VPWR VGND sg13g2_dlhq_1
XFILLER_80_215 VPWR VGND sg13g2_fill_1
X_1053_ Tile_X0Y0_FrameData[14] Tile_X0Y1_FrameStrobe[0] Tile_X0Y0_IHP_BRAM_top.Inst_IHP_BRAM_top_ConfigMem.Inst_frame0_bit14.Q
+ VPWR VGND sg13g2_dlhq_1
X_0837_ Tile_X0Y1_IHP_BRAM_bot.Inst_IHP_BRAM_bot_ConfigMem.Inst_frame4_bit1.Q A_DOUT_BRAM0
+ Tile_X0Y1_IHP_BRAM_bot.Inst_IHP_BRAM_bot_switch_matrix.J_NS4_BEG7 _0230_ _0105_
+ Tile_X0Y1_IHP_BRAM_bot.Inst_IHP_BRAM_bot_ConfigMem.Inst_frame4_bit0.Q Tile_X0Y1_IHP_BRAM_bot.Inst_IHP_BRAM_bot_switch_matrix.W6BEG8
+ VPWR VGND sg13g2_mux4_1
X_1886_ Tile_X0Y1_IHP_BRAM_bot.Inst_IHP_BRAM_bot_switch_matrix.S4BEG3 net288 VPWR
+ VGND sg13g2_buf_1
X_0906_ Tile_X0Y1_IHP_BRAM_bot.Inst_IHP_BRAM_bot_ConfigMem.Inst_frame2_bit26.Q Tile_X0Y1_EE4END[1]
+ Tile_X0Y1_EE4END[9] Tile_X0Y1_E6END[9] Tile_X0Y1_IHP_BRAM_bot.Inst_IHP_BRAM_bot_switch_matrix.J_NS4_BEG9
+ Tile_X0Y1_IHP_BRAM_bot.Inst_IHP_BRAM_bot_ConfigMem.Inst_frame2_bit27.Q net58 VPWR
+ VGND sg13g2_mux4_1
XFILLER_102_169 VPWR VGND sg13g2_fill_2
X_0768_ Tile_X0Y0_IHP_BRAM_top.Inst_IHP_BRAM_top_ConfigMem.Inst_frame9_bit1.Q Tile_X0Y0_E1END[0]
+ Tile_X0Y0_IHP_BRAM_top.Inst_IHP_BRAM_top_switch_matrix.J_NS4_BEG12 Tile_X0Y0_E6END[4]
+ _0110_ Tile_X0Y0_IHP_BRAM_top.Inst_IHP_BRAM_top_ConfigMem.Inst_frame9_bit0.Q Tile_X0Y0_IHP_BRAM_top.Inst_IHP_BRAM_top_switch_matrix.N1BEG0
+ VPWR VGND sg13g2_mux4_1
X_0699_ _0168_ _0170_ Tile_X0Y0_IHP_BRAM_top.Inst_IHP_BRAM_top_switch_matrix.S4BEG0
+ VPWR VGND sg13g2_nor2_1
XFILLER_24_197 VPWR VGND sg13g2_fill_1
XANTENNA_60 VPWR VGND Tile_X0Y1_N4END[5] sg13g2_antennanp
XANTENNA_71 VPWR VGND Tile_X0Y1_N4END[5] sg13g2_antennanp
XFILLER_62_215 VPWR VGND sg13g2_fill_1
XFILLER_15_142 VPWR VGND sg13g2_fill_1
X_1740_ Tile_X0Y0_IHP_BRAM_top.Inst_IHP_BRAM_top_switch_matrix.N2BEG2 net151 VPWR
+ VGND sg13g2_buf_1
XFILLER_30_178 VPWR VGND sg13g2_fill_2
X_1671_ Tile_X0Y1_FrameData[4] Tile_X0Y1_FrameStrobe[9] Tile_X0Y1_IHP_BRAM_bot.Inst_IHP_BRAM_bot_ConfigMem.Inst_frame9_bit4.Q
+ VPWR VGND sg13g2_dlhq_1
X_0484_ Tile_X0Y0_IHP_BRAM_top.Inst_IHP_BRAM_top_ConfigMem.Inst_frame9_bit4.Q Tile_X0Y0_E1END[2]
+ Tile_X0Y0_E6END[6] Tile_X0Y0_IHP_BRAM_top.Inst_IHP_BRAM_top_switch_matrix.J_NS4_BEG14
+ _0088_ Tile_X0Y0_IHP_BRAM_top.Inst_IHP_BRAM_top_ConfigMem.Inst_frame9_bit5.Q Tile_X0Y0_IHP_BRAM_top.Inst_IHP_BRAM_top_switch_matrix.N1BEG2
+ VPWR VGND sg13g2_mux4_1
X_0553_ Tile_X0Y0_IHP_BRAM_top.Inst_IHP_BRAM_top_ConfigMem.Inst_frame6_bit8.Q A_DOUT_BRAM12
+ B_DOUT_BRAM12 Tile_X0Y0_IHP_BRAM_top.Inst_IHP_BRAM_top_switch_matrix.J_NS2_BEG3
+ Tile_X0Y0_IHP_BRAM_top.Inst_IHP_BRAM_top_switch_matrix.J_NS2_BEG4 Tile_X0Y0_IHP_BRAM_top.Inst_IHP_BRAM_top_ConfigMem.Inst_frame6_bit9.Q
+ Tile_X0Y0_IHP_BRAM_top.Inst_IHP_BRAM_top_switch_matrix.W2BEGb4 VPWR VGND sg13g2_mux4_1
X_0622_ VPWR VGND Tile_X0Y0_IHP_BRAM_top.Inst_IHP_BRAM_top_ConfigMem.Inst_frame3_bit12.Q
+ _0120_ _0121_ Tile_X0Y0_IHP_BRAM_top.Inst_IHP_BRAM_top_ConfigMem.Inst_frame3_bit13.Q
+ net8 _0043_ sg13g2_a221oi_1
X_1105_ Tile_X0Y0_FrameData[26] Tile_X0Y1_FrameStrobe[2] Tile_X0Y0_IHP_BRAM_top.Inst_IHP_BRAM_top_ConfigMem.Inst_frame2_bit26.Q
+ VPWR VGND sg13g2_dlhq_1
X_1036_ Tile_X0Y0_FrameData[31] Tile_X0Y1_FrameStrobe[0] Tile_X0Y0_IHP_BRAM_top.Inst_IHP_BRAM_top_ConfigMem.Inst_frame0_bit31.Q
+ VPWR VGND sg13g2_dlhq_1
X_1869_ Tile_X0Y0_IHP_BRAM_top.Inst_IHP_BRAM_top_switch_matrix.S2BEG6 net280 VPWR
+ VGND sg13g2_buf_1
XFILLER_88_189 VPWR VGND sg13g2_fill_2
XFILLER_88_167 VPWR VGND sg13g2_decap_4
XFILLER_88_145 VPWR VGND sg13g2_fill_1
XFILLER_44_215 VPWR VGND sg13g2_fill_1
XFILLER_32_96 VPWR VGND sg13g2_decap_8
XFILLER_94_159 VPWR VGND sg13g2_fill_2
XFILLER_94_137 VPWR VGND sg13g2_decap_4
X_1723_ Tile_X0Y1_FrameStrobe[9] net144 VPWR VGND sg13g2_buf_1
XFILLER_7_193 VPWR VGND sg13g2_fill_1
X_1654_ Tile_X0Y1_FrameData[21] Tile_X0Y1_FrameStrobe[9] Tile_X0Y1_IHP_BRAM_bot.Inst_IHP_BRAM_bot_ConfigMem.Inst_frame9_bit21.Q
+ VPWR VGND sg13g2_dlhq_1
X_0605_ Tile_X0Y0_IHP_BRAM_top.Inst_IHP_BRAM_top_ConfigMem.Inst_frame4_bit22.Q Tile_X0Y0_EE4END[7]
+ Tile_X0Y0_EE4END[15] Tile_X0Y0_E6END[7] Tile_X0Y0_IHP_BRAM_top.Inst_IHP_BRAM_top_switch_matrix.J_NS4_BEG7
+ Tile_X0Y0_IHP_BRAM_top.Inst_IHP_BRAM_top_ConfigMem.Inst_frame4_bit23.Q net35 VPWR
+ VGND sg13g2_mux4_1
X_1585_ Tile_X0Y1_FrameData[26] Tile_X0Y1_FrameStrobe[7] Tile_X0Y1_IHP_BRAM_bot.Inst_IHP_BRAM_bot_ConfigMem.Inst_frame7_bit26.Q
+ VPWR VGND sg13g2_dlhq_1
X_0536_ Tile_X0Y1_IHP_BRAM_bot.Inst_IHP_BRAM_bot_ConfigMem.Inst_frame9_bit1.Q Tile_X0Y1_E1END[0]
+ Tile_X0Y1_IHP_BRAM_bot.Inst_IHP_BRAM_bot_switch_matrix.J_NS4_BEG12 Tile_X0Y1_E6END[4]
+ _0115_ Tile_X0Y1_IHP_BRAM_bot.Inst_IHP_BRAM_bot_ConfigMem.Inst_frame9_bit0.Q Tile_X0Y0_IHP_BRAM_top.Inst_IHP_BRAM_top_switch_matrix.N1END0
+ VPWR VGND sg13g2_mux4_1
X_0467_ Tile_X0Y1_IHP_BRAM_bot.Inst_IHP_BRAM_bot_ConfigMem.Inst_frame0_bit27.Q _0081_
+ _0082_ VPWR VGND Tile_X0Y1_IHP_BRAM_bot.Inst_IHP_BRAM_bot_ConfigMem.Inst_frame0_bit26.Q
+ sg13g2_nand3b_1
XFILLER_93_192 VPWR VGND sg13g2_fill_1
X_0398_ VPWR _0021_ Tile_X0Y1_IHP_BRAM_bot.Inst_IHP_BRAM_bot_ConfigMem.Inst_frame9_bit24.Q
+ VGND sg13g2_inv_1
X_1019_ Tile_X0Y1_E2END[3] Tile_X0Y1_IHP_BRAM_bot.Inst_IHP_BRAM_bot_ConfigMem.Inst_frame3_bit19.Q
+ Tile_X0Y1_IHP_BRAM_bot.Inst_IHP_BRAM_bot_ConfigMem.Inst_frame3_bit20.Q _0362_ VPWR
+ VGND sg13g2_nor3_1
XFILLER_76_148 VPWR VGND sg13g2_fill_1
XFILLER_17_215 VPWR VGND sg13g2_fill_1
XFILLER_43_40 VPWR VGND sg13g2_fill_1
XFILLER_4_185 VPWR VGND sg13g2_fill_1
XFILLER_4_12 VPWR VGND sg13g2_fill_1
X_1370_ Tile_X0Y1_FrameData[17] Tile_X0Y1_FrameStrobe[0] Tile_X0Y1_IHP_BRAM_bot.Inst_IHP_BRAM_bot_ConfigMem.Inst_frame0_bit17.Q
+ VPWR VGND sg13g2_dlhq_1
XFILLER_90_2 VPWR VGND sg13g2_fill_1
XFILLER_76_0 VPWR VGND sg13g2_fill_1
X_1706_ Tile_X0Y0_FrameData[24] net109 VPWR VGND sg13g2_buf_1
X_1637_ Tile_X0Y1_FrameData[6] Tile_X0Y1_FrameStrobe[8] Tile_X0Y1_IHP_BRAM_bot.Inst_IHP_BRAM_bot_ConfigMem.Inst_frame8_bit6.Q
+ VPWR VGND sg13g2_dlhq_1
XFILLER_66_170 VPWR VGND sg13g2_fill_2
X_1568_ Tile_X0Y1_FrameData[11] Tile_X0Y1_FrameStrobe[6] Tile_X0Y1_IHP_BRAM_bot.Inst_IHP_BRAM_bot_ConfigMem.Inst_frame6_bit11.Q
+ VPWR VGND sg13g2_dlhq_1
X_1499_ Tile_X0Y1_FrameData[16] Tile_X0Y1_FrameStrobe[4] Tile_X0Y1_IHP_BRAM_bot.Inst_IHP_BRAM_bot_ConfigMem.Inst_frame4_bit16.Q
+ VPWR VGND sg13g2_dlhq_1
X_0519_ Tile_X0Y1_IHP_BRAM_bot.Inst_IHP_BRAM_bot_ConfigMem.Inst_frame9_bit19.Q Tile_X0Y1_E2MID[2]
+ Tile_X0Y1_E6END[2] Tile_X0Y1_E2END[2] _0106_ Tile_X0Y1_IHP_BRAM_bot.Inst_IHP_BRAM_bot_ConfigMem.Inst_frame9_bit18.Q
+ Tile_X0Y0_IHP_BRAM_top.Inst_IHP_BRAM_top_switch_matrix.N2BEGb5 VPWR VGND sg13g2_mux4_1
XFILLER_80_38 VPWR VGND sg13g2_fill_1
XFILLER_89_69 VPWR VGND sg13g2_fill_2
X_0870_ Tile_X0Y1_IHP_BRAM_bot.Inst_IHP_BRAM_bot_ConfigMem.Inst_frame3_bit4.Q Tile_X0Y1_EE4END[1]
+ Tile_X0Y1_EE4END[9] Tile_X0Y1_E6END[1] _0232_ Tile_X0Y1_IHP_BRAM_bot.Inst_IHP_BRAM_bot_ConfigMem.Inst_frame3_bit5.Q
+ net12 VPWR VGND sg13g2_mux4_1
X_1422_ Tile_X0Y1_FrameData[29] Tile_X0Y1_FrameStrobe[2] Tile_X0Y1_IHP_BRAM_bot.Inst_IHP_BRAM_bot_ConfigMem.Inst_frame2_bit29.Q
+ VPWR VGND sg13g2_dlhq_1
X_1353_ Tile_X0Y0_FrameData[2] Tile_X0Y1_FrameStrobe[9] Tile_X0Y0_IHP_BRAM_top.Inst_IHP_BRAM_top_ConfigMem.Inst_frame9_bit2.Q
+ VPWR VGND sg13g2_dlhq_1
X_1284_ Tile_X0Y0_FrameData[7] Tile_X0Y1_FrameStrobe[7] Tile_X0Y0_IHP_BRAM_top.Inst_IHP_BRAM_top_ConfigMem.Inst_frame7_bit7.Q
+ VPWR VGND sg13g2_dlhq_1
XFILLER_109_109 VPWR VGND sg13g2_fill_2
X_0999_ VGND VPWR _0036_ _0341_ _0343_ _0342_ sg13g2_a21oi_1
XFILLER_86_210 VPWR VGND sg13g2_fill_2
XFILLER_10_210 VPWR VGND sg13g2_fill_2
XFILLER_54_173 VPWR VGND sg13g2_decap_8
XFILLER_54_184 VPWR VGND sg13g2_fill_2
XFILLER_108_164 VPWR VGND sg13g2_decap_4
XFILLER_6_0 VPWR VGND sg13g2_fill_1
XFILLER_40_63 VPWR VGND sg13g2_fill_1
XFILLER_1_46 VPWR VGND sg13g2_fill_2
XFILLER_45_151 VPWR VGND sg13g2_fill_1
XFILLER_81_70 VPWR VGND sg13g2_fill_2
X_0922_ VGND VPWR _0022_ _0271_ _0273_ _0272_ sg13g2_a21oi_1
X_0853_ Tile_X0Y1_IHP_BRAM_bot.Inst_IHP_BRAM_bot_ConfigMem.Inst_frame4_bit15.Q _0104_
+ _0243_ VPWR VGND Tile_X0Y1_IHP_BRAM_bot.Inst_IHP_BRAM_bot_ConfigMem.Inst_frame4_bit14.Q
+ sg13g2_nand3b_1
X_1405_ Tile_X0Y1_FrameData[14] Tile_X0Y1_FrameStrobe[1] Tile_X0Y1_IHP_BRAM_bot.Inst_IHP_BRAM_bot_ConfigMem.Inst_frame1_bit14.Q
+ VPWR VGND sg13g2_dlhq_1
X_0784_ Tile_X0Y1_IHP_BRAM_bot.Inst_IHP_BRAM_bot_ConfigMem.Inst_frame7_bit15.Q Tile_X0Y1_N1END[3]
+ A_DOUT_BRAM1 _0097_ A_DOUT_BRAM4 Tile_X0Y1_IHP_BRAM_bot.Inst_IHP_BRAM_bot_ConfigMem.Inst_frame7_bit14.Q
+ Tile_X0Y1_IHP_BRAM_bot.Inst_IHP_BRAM_bot_switch_matrix.W1BEG3 VPWR VGND sg13g2_mux4_1
XFILLER_39_0 VPWR VGND sg13g2_decap_8
X_1336_ Tile_X0Y0_FrameData[19] Tile_X0Y1_FrameStrobe[9] Tile_X0Y0_IHP_BRAM_top.Inst_IHP_BRAM_top_ConfigMem.Inst_frame9_bit19.Q
+ VPWR VGND sg13g2_dlhq_1
X_1198_ Tile_X0Y0_FrameData[29] Tile_X0Y1_FrameStrobe[5] Tile_X0Y0_IHP_BRAM_top.Inst_IHP_BRAM_top_ConfigMem.Inst_frame5_bit29.Q
+ VPWR VGND sg13g2_dlhq_1
XFILLER_28_129 VPWR VGND sg13g2_fill_1
X_1267_ Tile_X0Y0_FrameData[24] Tile_X0Y1_FrameStrobe[7] Tile_X0Y0_IHP_BRAM_top.Inst_IHP_BRAM_top_ConfigMem.Inst_frame7_bit24.Q
+ VPWR VGND sg13g2_dlhq_1
XFILLER_105_134 VPWR VGND sg13g2_decap_4
XFILLER_74_213 VPWR VGND sg13g2_fill_2
XFILLER_35_63 VPWR VGND sg13g2_decap_8
X_1121_ Tile_X0Y0_FrameData[10] Tile_X0Y1_FrameStrobe[2] Tile_X0Y0_IHP_BRAM_top.Inst_IHP_BRAM_top_ConfigMem.Inst_frame2_bit10.Q
+ VPWR VGND sg13g2_dlhq_1
XFILLER_76_81 VPWR VGND sg13g2_decap_8
X_1052_ Tile_X0Y0_FrameData[15] Tile_X0Y1_FrameStrobe[0] Tile_X0Y0_IHP_BRAM_top.Inst_IHP_BRAM_top_ConfigMem.Inst_frame0_bit15.Q
+ VPWR VGND sg13g2_dlhq_1
X_0767_ _0229_ VPWR net91 VGND _0214_ _0220_ sg13g2_o21ai_1
X_1885_ Tile_X0Y1_IHP_BRAM_bot.Inst_IHP_BRAM_bot_switch_matrix.S4BEG2 net287 VPWR
+ VGND sg13g2_buf_1
X_0836_ Tile_X0Y1_IHP_BRAM_bot.Inst_IHP_BRAM_bot_ConfigMem.Inst_frame5_bit30.Q A_DOUT_BRAM7
+ Tile_X0Y1_IHP_BRAM_bot.Inst_IHP_BRAM_bot_switch_matrix.J_NS4_BEG4 Tile_X0Y1_IHP_BRAM_bot.Inst_IHP_BRAM_bot_switch_matrix.J_NS4_BEG8
+ _0104_ Tile_X0Y1_IHP_BRAM_bot.Inst_IHP_BRAM_bot_ConfigMem.Inst_frame5_bit31.Q Tile_X0Y1_IHP_BRAM_bot.Inst_IHP_BRAM_bot_switch_matrix.W6BEG7
+ VPWR VGND sg13g2_mux4_1
X_0905_ Tile_X0Y1_IHP_BRAM_bot.Inst_IHP_BRAM_bot_ConfigMem.Inst_frame2_bit24.Q Tile_X0Y1_EE4END[0]
+ Tile_X0Y1_EE4END[8] Tile_X0Y1_E6END[8] Tile_X0Y1_IHP_BRAM_bot.Inst_IHP_BRAM_bot_switch_matrix.J_NS4_BEG8
+ Tile_X0Y1_IHP_BRAM_bot.Inst_IHP_BRAM_bot_ConfigMem.Inst_frame2_bit25.Q net57 VPWR
+ VGND sg13g2_mux4_1
X_0698_ Tile_X0Y0_IHP_BRAM_top.Inst_IHP_BRAM_top_ConfigMem.Inst_frame8_bit30.Q _0169_
+ _0170_ VPWR VGND sg13g2_nor2_1
XFILLER_56_213 VPWR VGND sg13g2_fill_2
X_1319_ Tile_X0Y0_FrameData[4] Tile_X0Y1_FrameStrobe[8] Tile_X0Y0_IHP_BRAM_top.Inst_IHP_BRAM_top_ConfigMem.Inst_frame8_bit4.Q
+ VPWR VGND sg13g2_dlhq_1
XFILLER_24_110 VPWR VGND sg13g2_fill_1
XANTENNA_61 VPWR VGND Tile_X0Y1_N4END[5] sg13g2_antennanp
XANTENNA_72 VPWR VGND Tile_X0Y1_N4END[5] sg13g2_antennanp
XANTENNA_50 VPWR VGND Tile_X0Y1_N4END[4] sg13g2_antennanp
Xoutput190 net190 Tile_X0Y0_W2BEG[4] VPWR VGND sg13g2_buf_1
X_0621_ _0121_ Tile_X0Y0_E2END[2] Tile_X0Y0_IHP_BRAM_top.Inst_IHP_BRAM_top_ConfigMem.Inst_frame3_bit13.Q
+ VPWR VGND sg13g2_nand2b_1
X_1670_ Tile_X0Y1_FrameData[5] Tile_X0Y1_FrameStrobe[9] Tile_X0Y1_IHP_BRAM_bot.Inst_IHP_BRAM_bot_ConfigMem.Inst_frame9_bit5.Q
+ VPWR VGND sg13g2_dlhq_1
X_0483_ Tile_X0Y0_IHP_BRAM_top.Inst_IHP_BRAM_top_ConfigMem.Inst_frame0_bit4.Q Tile_X0Y0_IHP_BRAM_top.Inst_IHP_BRAM_top_switch_matrix.N1END2
+ Tile_X0Y1_N4END[6] Tile_X0Y0_S1END[2] Tile_X0Y0_S4END[2] Tile_X0Y0_IHP_BRAM_top.Inst_IHP_BRAM_top_ConfigMem.Inst_frame0_bit5.Q
+ Tile_X0Y0_IHP_BRAM_top.Inst_IHP_BRAM_top_switch_matrix.J_NS4_BEG14 VPWR VGND sg13g2_mux4_1
X_0552_ Tile_X0Y0_IHP_BRAM_top.Inst_IHP_BRAM_top_ConfigMem.Inst_frame6_bit6.Q A_DOUT_BRAM11
+ B_DOUT_BRAM11 Tile_X0Y0_IHP_BRAM_top.Inst_IHP_BRAM_top_switch_matrix.J_NS2_BEG3
+ Tile_X0Y0_IHP_BRAM_top.Inst_IHP_BRAM_top_switch_matrix.J_NS2_BEG4 Tile_X0Y0_IHP_BRAM_top.Inst_IHP_BRAM_top_ConfigMem.Inst_frame6_bit7.Q
+ Tile_X0Y0_IHP_BRAM_top.Inst_IHP_BRAM_top_switch_matrix.W2BEGb3 VPWR VGND sg13g2_mux4_1
X_1104_ Tile_X0Y0_FrameData[27] Tile_X0Y1_FrameStrobe[2] Tile_X0Y0_IHP_BRAM_top.Inst_IHP_BRAM_top_ConfigMem.Inst_frame2_bit27.Q
+ VPWR VGND sg13g2_dlhq_1
X_1035_ VGND VPWR _0040_ _0376_ net45 _0372_ sg13g2_a21oi_1
X_1799_ Tile_X0Y0_IHP_BRAM_top.Inst_IHP_BRAM_top_switch_matrix.W6BEG8 net212 VPWR
+ VGND sg13g2_buf_1
X_0819_ Tile_X0Y1_IHP_BRAM_bot.Inst_IHP_BRAM_bot_ConfigMem.Inst_frame1_bit16.Q Tile_X0Y1_N1END[0]
+ Tile_X0Y1_N4END[0] _0111_ Tile_X0Y0_S4END[4] Tile_X0Y1_IHP_BRAM_bot.Inst_IHP_BRAM_bot_ConfigMem.Inst_frame1_bit17.Q
+ Tile_X0Y1_IHP_BRAM_bot.Inst_IHP_BRAM_bot_switch_matrix.J_NS4_BEG4 VPWR VGND sg13g2_mux4_1
X_1868_ Tile_X0Y0_IHP_BRAM_top.Inst_IHP_BRAM_top_switch_matrix.S2BEG5 net279 VPWR
+ VGND sg13g2_buf_1
XFILLER_16_98 VPWR VGND sg13g2_fill_1
XFILLER_12_157 VPWR VGND sg13g2_fill_1
XFILLER_106_0 VPWR VGND sg13g2_fill_1
XFILLER_35_205 VPWR VGND sg13g2_fill_2
X_1722_ Tile_X0Y1_FrameStrobe[8] net143 VPWR VGND sg13g2_buf_1
X_0604_ Tile_X0Y0_IHP_BRAM_top.Inst_IHP_BRAM_top_ConfigMem.Inst_frame4_bit20.Q Tile_X0Y0_EE4END[6]
+ Tile_X0Y0_EE4END[14] Tile_X0Y0_E6END[6] Tile_X0Y0_IHP_BRAM_top.Inst_IHP_BRAM_top_switch_matrix.J_NS4_BEG6
+ Tile_X0Y0_IHP_BRAM_top.Inst_IHP_BRAM_top_ConfigMem.Inst_frame4_bit21.Q net34 VPWR
+ VGND sg13g2_mux4_1
X_1584_ Tile_X0Y1_FrameData[27] Tile_X0Y1_FrameStrobe[7] Tile_X0Y1_IHP_BRAM_bot.Inst_IHP_BRAM_bot_ConfigMem.Inst_frame7_bit27.Q
+ VPWR VGND sg13g2_dlhq_1
X_1653_ Tile_X0Y1_FrameData[22] Tile_X0Y1_FrameStrobe[9] Tile_X0Y1_IHP_BRAM_bot.Inst_IHP_BRAM_bot_ConfigMem.Inst_frame9_bit22.Q
+ VPWR VGND sg13g2_dlhq_1
X_0466_ Tile_X0Y0_IHP_BRAM_top.Inst_IHP_BRAM_top_ConfigMem.Inst_frame8_bit6.Q Tile_X0Y0_E1END[1]
+ Tile_X0Y0_E6END[9] Tile_X0Y0_IHP_BRAM_top.Inst_IHP_BRAM_top_switch_matrix.J_NS4_BEG13
+ _0080_ Tile_X0Y0_IHP_BRAM_top.Inst_IHP_BRAM_top_ConfigMem.Inst_frame8_bit7.Q _0081_
+ VPWR VGND sg13g2_mux4_1
XFILLER_85_138 VPWR VGND sg13g2_decap_4
X_0397_ VPWR _0020_ Tile_X0Y0_IHP_BRAM_top.Inst_IHP_BRAM_top_ConfigMem.Inst_frame1_bit4.Q
+ VGND sg13g2_inv_1
X_0535_ _0112_ VPWR _0115_ VGND Tile_X0Y1_IHP_BRAM_bot.Inst_IHP_BRAM_bot_ConfigMem.Inst_frame0_bit25.Q
+ _0114_ sg13g2_o21ai_1
XFILLER_21_0 VPWR VGND sg13g2_fill_1
X_1018_ _0361_ Tile_X0Y1_E2END[5] Tile_X0Y1_IHP_BRAM_bot.Inst_IHP_BRAM_bot_ConfigMem.Inst_frame3_bit20.Q
+ VPWR VGND sg13g2_nand2b_1
XFILLER_94_59 VPWR VGND sg13g2_decap_4
XFILLER_94_37 VPWR VGND sg13g2_fill_2
XFILLER_91_119 VPWR VGND sg13g2_decap_8
XFILLER_90_152 VPWR VGND sg13g2_fill_2
X_1705_ Tile_X0Y0_FrameData[23] net108 VPWR VGND sg13g2_buf_1
X_1567_ Tile_X0Y1_FrameData[12] Tile_X0Y1_FrameStrobe[6] Tile_X0Y1_IHP_BRAM_bot.Inst_IHP_BRAM_bot_ConfigMem.Inst_frame6_bit12.Q
+ VPWR VGND sg13g2_dlhq_1
X_1636_ Tile_X0Y1_FrameData[7] Tile_X0Y1_FrameStrobe[8] Tile_X0Y1_IHP_BRAM_bot.Inst_IHP_BRAM_bot_ConfigMem.Inst_frame8_bit7.Q
+ VPWR VGND sg13g2_dlhq_1
X_0518_ Tile_X0Y1_IHP_BRAM_bot.Inst_IHP_BRAM_bot_ConfigMem.Inst_frame0_bit18.Q Tile_X0Y1_N2MID[5]
+ Tile_X0Y1_N2END[5] Tile_X0Y0_IHP_BRAM_top.Inst_IHP_BRAM_top_switch_matrix.S2BEG5
+ Tile_X0Y0_S2MID[5] Tile_X0Y1_IHP_BRAM_bot.Inst_IHP_BRAM_bot_ConfigMem.Inst_frame0_bit19.Q
+ _0106_ VPWR VGND sg13g2_mux4_1
X_0449_ Tile_X0Y0_IHP_BRAM_top.Inst_IHP_BRAM_top_ConfigMem.Inst_frame0_bit8.Q Tile_X0Y0_IHP_BRAM_top.Inst_IHP_BRAM_top_switch_matrix.N2BEGb0
+ Tile_X0Y1_N2MID[0] Tile_X0Y0_S2MID[0] Tile_X0Y0_S2END[0] Tile_X0Y0_IHP_BRAM_top.Inst_IHP_BRAM_top_ConfigMem.Inst_frame0_bit9.Q
+ Tile_X0Y0_IHP_BRAM_top.Inst_IHP_BRAM_top_switch_matrix.J_NS2_BEG0 VPWR VGND sg13g2_mux4_1
XFILLER_58_138 VPWR VGND sg13g2_fill_1
X_1498_ Tile_X0Y1_FrameData[17] Tile_X0Y1_FrameStrobe[4] Tile_X0Y1_IHP_BRAM_bot.Inst_IHP_BRAM_bot_ConfigMem.Inst_frame4_bit17.Q
+ VPWR VGND sg13g2_dlhq_1
XFILLER_81_152 VPWR VGND sg13g2_decap_8
XFILLER_1_178 VPWR VGND sg13g2_fill_1
XFILLER_38_30 VPWR VGND sg13g2_fill_2
XFILLER_72_130 VPWR VGND sg13g2_decap_8
XFILLER_57_160 VPWR VGND sg13g2_fill_2
XFILLER_79_70 VPWR VGND sg13g2_fill_2
X_1421_ Tile_X0Y1_FrameData[30] Tile_X0Y1_FrameStrobe[2] Tile_X0Y1_IHP_BRAM_bot.Inst_IHP_BRAM_bot_ConfigMem.Inst_frame2_bit30.Q
+ VPWR VGND sg13g2_dlhq_1
X_1352_ Tile_X0Y0_FrameData[3] Tile_X0Y1_FrameStrobe[9] Tile_X0Y0_IHP_BRAM_top.Inst_IHP_BRAM_top_ConfigMem.Inst_frame9_bit3.Q
+ VPWR VGND sg13g2_dlhq_1
X_1283_ Tile_X0Y0_FrameData[8] Tile_X0Y1_FrameStrobe[7] Tile_X0Y0_IHP_BRAM_top.Inst_IHP_BRAM_top_ConfigMem.Inst_frame7_bit8.Q
+ VPWR VGND sg13g2_dlhq_1
X_0998_ Tile_X0Y1_IHP_BRAM_bot.Inst_IHP_BRAM_bot_ConfigMem.Inst_frame7_bit7.Q VPWR
+ _0342_ VGND _0339_ _0340_ sg13g2_o21ai_1
X_1619_ Tile_X0Y1_FrameData[24] Tile_X0Y1_FrameStrobe[8] Tile_X0Y1_IHP_BRAM_bot.Inst_IHP_BRAM_bot_ConfigMem.Inst_frame8_bit24.Q
+ VPWR VGND sg13g2_dlhq_1
XFILLER_91_38 VPWR VGND sg13g2_decap_8
XFILLER_6_215 VPWR VGND sg13g2_fill_1
XFILLER_24_87 VPWR VGND sg13g2_fill_2
XFILLER_108_154 VPWR VGND sg13g2_decap_4
XFILLER_49_40 VPWR VGND sg13g2_decap_8
X_0921_ Tile_X0Y1_IHP_BRAM_bot.Inst_IHP_BRAM_bot_ConfigMem.Inst_frame9_bit26.Q VPWR
+ _0272_ VGND _0269_ _0270_ sg13g2_o21ai_1
XFILLER_81_93 VPWR VGND sg13g2_decap_4
X_0783_ Tile_X0Y1_IHP_BRAM_bot.Inst_IHP_BRAM_bot_ConfigMem.Inst_frame7_bit13.Q Tile_X0Y1_N1END[2]
+ A_DOUT_BRAM0 _0089_ A_DOUT_BRAM5 Tile_X0Y1_IHP_BRAM_bot.Inst_IHP_BRAM_bot_ConfigMem.Inst_frame7_bit12.Q
+ Tile_X0Y1_IHP_BRAM_bot.Inst_IHP_BRAM_bot_switch_matrix.W1BEG2 VPWR VGND sg13g2_mux4_1
X_0852_ _0240_ VPWR net3 VGND Tile_X0Y1_IHP_BRAM_bot.Inst_IHP_BRAM_bot_ConfigMem.Inst_frame4_bit13.Q
+ _0242_ sg13g2_o21ai_1
X_1335_ Tile_X0Y0_FrameData[20] Tile_X0Y1_FrameStrobe[9] Tile_X0Y0_IHP_BRAM_top.Inst_IHP_BRAM_top_ConfigMem.Inst_frame9_bit20.Q
+ VPWR VGND sg13g2_dlhq_1
XFILLER_68_211 VPWR VGND sg13g2_fill_1
X_1404_ Tile_X0Y1_FrameData[15] Tile_X0Y1_FrameStrobe[1] Tile_X0Y1_IHP_BRAM_bot.Inst_IHP_BRAM_bot_ConfigMem.Inst_frame1_bit15.Q
+ VPWR VGND sg13g2_dlhq_1
X_1197_ Tile_X0Y0_FrameData[30] Tile_X0Y1_FrameStrobe[5] Tile_X0Y0_IHP_BRAM_top.Inst_IHP_BRAM_top_ConfigMem.Inst_frame5_bit30.Q
+ VPWR VGND sg13g2_dlhq_1
XFILLER_36_174 VPWR VGND sg13g2_decap_4
X_1266_ Tile_X0Y0_FrameData[25] Tile_X0Y1_FrameStrobe[7] Tile_X0Y0_IHP_BRAM_top.Inst_IHP_BRAM_top_ConfigMem.Inst_frame7_bit25.Q
+ VPWR VGND sg13g2_dlhq_1
XFILLER_101_59 VPWR VGND sg13g2_fill_1
XFILLER_51_74 VPWR VGND sg13g2_decap_4
X_1051_ Tile_X0Y0_FrameData[16] Tile_X0Y1_FrameStrobe[0] Tile_X0Y0_IHP_BRAM_top.Inst_IHP_BRAM_top_ConfigMem.Inst_frame0_bit16.Q
+ VPWR VGND sg13g2_dlhq_1
X_1120_ Tile_X0Y0_FrameData[11] Tile_X0Y1_FrameStrobe[2] Tile_X0Y0_IHP_BRAM_top.Inst_IHP_BRAM_top_ConfigMem.Inst_frame2_bit11.Q
+ VPWR VGND sg13g2_dlhq_1
X_1884_ Tile_X0Y1_IHP_BRAM_bot.Inst_IHP_BRAM_bot_switch_matrix.S4BEG1 net286 VPWR
+ VGND sg13g2_buf_1
X_0904_ Tile_X0Y1_IHP_BRAM_bot.Inst_IHP_BRAM_bot_ConfigMem.Inst_frame2_bit22.Q Tile_X0Y1_E1END[3]
+ Tile_X0Y1_EE4END[7] Tile_X0Y1_EE4END[15] Tile_X0Y1_IHP_BRAM_bot.Inst_IHP_BRAM_bot_switch_matrix.J_NS4_BEG15
+ Tile_X0Y1_IHP_BRAM_bot.Inst_IHP_BRAM_bot_ConfigMem.Inst_frame2_bit23.Q net87 VPWR
+ VGND sg13g2_mux4_1
X_0697_ Tile_X0Y0_IHP_BRAM_top.Inst_IHP_BRAM_top_ConfigMem.Inst_frame8_bit28.Q Tile_X0Y0_E1END[0]
+ Tile_X0Y0_EE4END[12] Tile_X0Y0_E6END[4] Tile_X0Y0_IHP_BRAM_top.Inst_IHP_BRAM_top_switch_matrix.J_NS4_BEG0
+ Tile_X0Y0_IHP_BRAM_top.Inst_IHP_BRAM_top_ConfigMem.Inst_frame8_bit29.Q _0169_ VPWR
+ VGND sg13g2_mux4_1
X_0766_ Tile_X0Y0_IHP_BRAM_top.Inst_IHP_BRAM_top_ConfigMem.Inst_frame1_bit7.Q VPWR
+ _0229_ VGND _0224_ _0228_ sg13g2_o21ai_1
X_0835_ Tile_X0Y1_IHP_BRAM_bot.Inst_IHP_BRAM_bot_ConfigMem.Inst_frame5_bit28.Q A_DOUT_BRAM6
+ Tile_X0Y1_IHP_BRAM_bot.Inst_IHP_BRAM_bot_switch_matrix.J_NS4_BEG5 Tile_X0Y1_IHP_BRAM_bot.Inst_IHP_BRAM_bot_switch_matrix.J_NS4_BEG9
+ _0103_ Tile_X0Y1_IHP_BRAM_bot.Inst_IHP_BRAM_bot_ConfigMem.Inst_frame5_bit29.Q Tile_X0Y1_IHP_BRAM_bot.Inst_IHP_BRAM_bot_switch_matrix.W6BEG6
+ VPWR VGND sg13g2_mux4_1
XFILLER_51_0 VPWR VGND sg13g2_fill_1
X_1318_ Tile_X0Y0_FrameData[5] Tile_X0Y1_FrameStrobe[8] Tile_X0Y0_IHP_BRAM_top.Inst_IHP_BRAM_top_ConfigMem.Inst_frame8_bit5.Q
+ VPWR VGND sg13g2_dlhq_1
X_1249_ Tile_X0Y0_FrameData[10] Tile_X0Y1_FrameStrobe[6] Tile_X0Y0_IHP_BRAM_top.Inst_IHP_BRAM_top_ConfigMem.Inst_frame6_bit10.Q
+ VPWR VGND sg13g2_dlhq_1
XANTENNA_62 VPWR VGND Tile_X0Y1_N4END[5] sg13g2_antennanp
XANTENNA_51 VPWR VGND Tile_X0Y1_N4END[4] sg13g2_antennanp
XANTENNA_73 VPWR VGND Tile_X0Y1_N4END[5] sg13g2_antennanp
XANTENNA_40 VPWR VGND Tile_X0Y1_N4END[4] sg13g2_antennanp
Xoutput180 net180 Tile_X0Y0_N4BEG[9] VPWR VGND sg13g2_buf_1
Xoutput191 net191 Tile_X0Y0_W2BEG[5] VPWR VGND sg13g2_buf_1
XFILLER_21_99 VPWR VGND sg13g2_fill_2
XFILLER_47_214 VPWR VGND sg13g2_fill_2
X_0551_ Tile_X0Y0_IHP_BRAM_top.Inst_IHP_BRAM_top_ConfigMem.Inst_frame6_bit4.Q A_DOUT_BRAM10
+ B_DOUT_BRAM10 Tile_X0Y0_IHP_BRAM_top.Inst_IHP_BRAM_top_switch_matrix.J_NS2_BEG2
+ Tile_X0Y0_IHP_BRAM_top.Inst_IHP_BRAM_top_switch_matrix.J_NS2_BEG5 Tile_X0Y0_IHP_BRAM_top.Inst_IHP_BRAM_top_ConfigMem.Inst_frame6_bit5.Q
+ Tile_X0Y0_IHP_BRAM_top.Inst_IHP_BRAM_top_switch_matrix.W2BEGb2 VPWR VGND sg13g2_mux4_1
X_0620_ Tile_X0Y0_E2MID[2] Tile_X0Y0_IHP_BRAM_top.Inst_IHP_BRAM_top_ConfigMem.Inst_frame3_bit12.Q
+ Tile_X0Y0_IHP_BRAM_top.Inst_IHP_BRAM_top_ConfigMem.Inst_frame3_bit13.Q _0120_ VPWR
+ VGND sg13g2_nor3_1
XFILLER_87_92 VPWR VGND sg13g2_decap_4
XFILLER_87_70 VPWR VGND sg13g2_fill_1
XFILLER_23_4 VPWR VGND sg13g2_fill_1
X_0482_ Tile_X0Y1_IHP_BRAM_bot.Inst_IHP_BRAM_bot_ConfigMem.Inst_frame9_bit5.Q Tile_X0Y1_E1END[2]
+ Tile_X0Y1_IHP_BRAM_bot.Inst_IHP_BRAM_bot_switch_matrix.J_NS4_BEG14 Tile_X0Y1_E6END[6]
+ _0093_ Tile_X0Y1_IHP_BRAM_bot.Inst_IHP_BRAM_bot_ConfigMem.Inst_frame9_bit4.Q Tile_X0Y0_IHP_BRAM_top.Inst_IHP_BRAM_top_switch_matrix.N1END2
+ VPWR VGND sg13g2_mux4_1
X_1103_ Tile_X0Y0_FrameData[28] Tile_X0Y1_FrameStrobe[2] Tile_X0Y0_IHP_BRAM_top.Inst_IHP_BRAM_top_ConfigMem.Inst_frame2_bit28.Q
+ VPWR VGND sg13g2_dlhq_1
X_1034_ _0374_ VPWR _0376_ VGND Tile_X0Y1_IHP_BRAM_bot.Inst_IHP_BRAM_bot_ConfigMem.Inst_frame3_bit26.Q
+ _0375_ sg13g2_o21ai_1
XFILLER_99_0 VPWR VGND sg13g2_fill_1
X_1867_ Tile_X0Y0_IHP_BRAM_top.Inst_IHP_BRAM_top_switch_matrix.S2BEG4 net278 VPWR
+ VGND sg13g2_buf_1
X_1798_ Tile_X0Y0_IHP_BRAM_top.Inst_IHP_BRAM_top_switch_matrix.W6BEG7 net211 VPWR
+ VGND sg13g2_buf_1
X_0749_ VGND VPWR _0000_ Tile_X0Y0_IHP_BRAM_top.Inst_IHP_BRAM_top_ConfigMem.Inst_frame1_bit4.Q
+ _0212_ Tile_X0Y0_IHP_BRAM_top.Inst_IHP_BRAM_top_ConfigMem.Inst_frame1_bit5.Q sg13g2_a21oi_1
X_0818_ Tile_X0Y1_IHP_BRAM_bot.Inst_IHP_BRAM_bot_ConfigMem.Inst_frame5_bit4.Q A_DOUT_BRAM6
+ B_DOUT_BRAM2 Tile_X0Y1_IHP_BRAM_bot.Inst_IHP_BRAM_bot_switch_matrix.J_NS4_BEG5 _0106_
+ Tile_X0Y1_IHP_BRAM_bot.Inst_IHP_BRAM_bot_ConfigMem.Inst_frame5_bit5.Q Tile_X0Y1_IHP_BRAM_bot.Inst_IHP_BRAM_bot_switch_matrix.WW4BEG10
+ VPWR VGND sg13g2_mux4_1
XFILLER_32_76 VPWR VGND sg13g2_fill_1
X_1721_ Tile_X0Y1_FrameStrobe[7] net142 VPWR VGND sg13g2_buf_1
XFILLER_92_7 VPWR VGND sg13g2_fill_2
X_0603_ Tile_X0Y0_IHP_BRAM_top.Inst_IHP_BRAM_top_ConfigMem.Inst_frame4_bit18.Q Tile_X0Y0_EE4END[5]
+ Tile_X0Y0_EE4END[13] Tile_X0Y0_E6END[5] Tile_X0Y0_IHP_BRAM_top.Inst_IHP_BRAM_top_switch_matrix.J_NS4_BEG5
+ Tile_X0Y0_IHP_BRAM_top.Inst_IHP_BRAM_top_ConfigMem.Inst_frame4_bit19.Q net33 VPWR
+ VGND sg13g2_mux4_1
X_1583_ Tile_X0Y1_FrameData[28] Tile_X0Y1_FrameStrobe[7] Tile_X0Y1_IHP_BRAM_bot.Inst_IHP_BRAM_bot_ConfigMem.Inst_frame7_bit28.Q
+ VPWR VGND sg13g2_dlhq_1
X_0534_ VGND VPWR Tile_X0Y1_E6END[0] Tile_X0Y1_IHP_BRAM_bot.Inst_IHP_BRAM_bot_ConfigMem.Inst_frame0_bit24.Q
+ _0114_ _0113_ sg13g2_a21oi_1
X_1652_ Tile_X0Y1_FrameData[23] Tile_X0Y1_FrameStrobe[9] Tile_X0Y1_IHP_BRAM_bot.Inst_IHP_BRAM_bot_ConfigMem.Inst_frame9_bit23.Q
+ VPWR VGND sg13g2_dlhq_1
X_0465_ VPWR VGND _0078_ _0079_ Tile_X0Y0_IHP_BRAM_top.Inst_IHP_BRAM_top_ConfigMem.Inst_frame0_bit27.Q
+ _0007_ _0080_ Tile_X0Y0_IHP_BRAM_top.Inst_IHP_BRAM_top_ConfigMem.Inst_frame0_bit26.Q
+ sg13g2_a221oi_1
X_0396_ VPWR _0019_ Tile_X0Y0_IHP_BRAM_top.Inst_IHP_BRAM_top_ConfigMem.Inst_frame2_bit28.Q
+ VGND sg13g2_inv_1
X_1017_ _0357_ _0358_ Tile_X0Y1_IHP_BRAM_bot.Inst_IHP_BRAM_bot_ConfigMem.Inst_frame3_bit18.Q
+ _0360_ VPWR VGND _0359_ sg13g2_nand4_1
X_1919_ Tile_X0Y1_IHP_BRAM_bot.Inst_IHP_BRAM_bot_switch_matrix.WW4BEG0 net330 VPWR
+ VGND sg13g2_buf_1
XFILLER_32_209 VPWR VGND sg13g2_fill_2
XFILLER_43_20 VPWR VGND sg13g2_fill_1
XFILLER_4_165 VPWR VGND sg13g2_fill_1
XFILLER_4_47 VPWR VGND sg13g2_fill_2
X_1704_ Tile_X0Y0_FrameData[22] net107 VPWR VGND sg13g2_buf_1
X_0517_ Tile_X0Y0_IHP_BRAM_top.Inst_IHP_BRAM_top_ConfigMem.Inst_frame8_bit22.Q Tile_X0Y0_E1END[1]
+ Tile_X0Y0_E2MID[2] Tile_X0Y0_E2END[2] Tile_X0Y0_IHP_BRAM_top.Inst_IHP_BRAM_top_switch_matrix.J_NS2_BEG5
+ Tile_X0Y0_IHP_BRAM_top.Inst_IHP_BRAM_top_ConfigMem.Inst_frame8_bit23.Q Tile_X0Y0_IHP_BRAM_top.Inst_IHP_BRAM_top_switch_matrix.S2BEG5
+ VPWR VGND sg13g2_mux4_1
X_1566_ Tile_X0Y1_FrameData[13] Tile_X0Y1_FrameStrobe[6] Tile_X0Y1_IHP_BRAM_bot.Inst_IHP_BRAM_bot_ConfigMem.Inst_frame6_bit13.Q
+ VPWR VGND sg13g2_dlhq_1
X_1497_ Tile_X0Y1_FrameData[18] Tile_X0Y1_FrameStrobe[4] Tile_X0Y1_IHP_BRAM_bot.Inst_IHP_BRAM_bot_ConfigMem.Inst_frame4_bit18.Q
+ VPWR VGND sg13g2_dlhq_1
X_1635_ Tile_X0Y1_FrameData[8] Tile_X0Y1_FrameStrobe[8] Tile_X0Y1_IHP_BRAM_bot.Inst_IHP_BRAM_bot_ConfigMem.Inst_frame8_bit8.Q
+ VPWR VGND sg13g2_dlhq_1
X_0379_ VPWR _0002_ Tile_X0Y0_E2END[5] VGND sg13g2_inv_1
X_0448_ Tile_X0Y1_IHP_BRAM_bot.Inst_IHP_BRAM_bot_ConfigMem.Inst_frame9_bit8.Q Tile_X0Y1_E2MID[7]
+ Tile_X0Y1_E2END[7] Tile_X0Y1_E6END[7] _0065_ Tile_X0Y1_IHP_BRAM_bot.Inst_IHP_BRAM_bot_ConfigMem.Inst_frame9_bit9.Q
+ Tile_X0Y0_IHP_BRAM_top.Inst_IHP_BRAM_top_switch_matrix.N2BEGb0 VPWR VGND sg13g2_mux4_1
XFILLER_13_12 VPWR VGND sg13g2_fill_2
XFILLER_89_49 VPWR VGND sg13g2_fill_2
XFILLER_72_120 VPWR VGND sg13g2_decap_4
X_1351_ Tile_X0Y0_FrameData[4] Tile_X0Y1_FrameStrobe[9] Tile_X0Y0_IHP_BRAM_top.Inst_IHP_BRAM_top_ConfigMem.Inst_frame9_bit4.Q
+ VPWR VGND sg13g2_dlhq_1
X_1420_ Tile_X0Y1_FrameData[31] Tile_X0Y1_FrameStrobe[2] Tile_X0Y1_IHP_BRAM_bot.Inst_IHP_BRAM_bot_ConfigMem.Inst_frame2_bit31.Q
+ VPWR VGND sg13g2_dlhq_1
X_1282_ Tile_X0Y0_FrameData[9] Tile_X0Y1_FrameStrobe[7] Tile_X0Y0_IHP_BRAM_top.Inst_IHP_BRAM_top_ConfigMem.Inst_frame7_bit9.Q
+ VPWR VGND sg13g2_dlhq_1
X_1618_ Tile_X0Y1_FrameData[25] Tile_X0Y1_FrameStrobe[8] Tile_X0Y1_IHP_BRAM_bot.Inst_IHP_BRAM_bot_ConfigMem.Inst_frame8_bit25.Q
+ VPWR VGND sg13g2_dlhq_1
X_0997_ Tile_X0Y1_IHP_BRAM_bot.Inst_IHP_BRAM_bot_switch_matrix.J_NS4_BEG7 Tile_X0Y1_IHP_BRAM_bot.Inst_IHP_BRAM_bot_switch_matrix.J_NS4_BEG11
+ Tile_X0Y1_IHP_BRAM_bot.Inst_IHP_BRAM_bot_ConfigMem.Inst_frame7_bit5.Q _0341_ VPWR
+ VGND sg13g2_mux2_1
X_1549_ Tile_X0Y1_FrameData[30] Tile_X0Y1_FrameStrobe[6] Tile_X0Y1_IHP_BRAM_bot.Inst_IHP_BRAM_bot_ConfigMem.Inst_frame6_bit30.Q
+ VPWR VGND sg13g2_dlhq_1
XFILLER_91_17 VPWR VGND sg13g2_decap_4
XFILLER_108_100 VPWR VGND sg13g2_fill_2
XFILLER_105_80 VPWR VGND sg13g2_fill_2
XFILLER_81_72 VPWR VGND sg13g2_fill_1
XFILLER_65_95 VPWR VGND sg13g2_fill_2
X_0920_ Tile_X0Y1_IHP_BRAM_bot.Inst_IHP_BRAM_bot_switch_matrix.J_NS4_BEG4 Tile_X0Y1_IHP_BRAM_bot.Inst_IHP_BRAM_bot_switch_matrix.J_NS4_BEG8
+ Tile_X0Y1_IHP_BRAM_bot.Inst_IHP_BRAM_bot_ConfigMem.Inst_frame9_bit24.Q _0271_ VPWR
+ VGND sg13g2_mux2_1
X_0782_ Tile_X0Y1_IHP_BRAM_bot.Inst_IHP_BRAM_bot_ConfigMem.Inst_frame7_bit11.Q Tile_X0Y1_N1END[1]
+ A_DOUT_BRAM3 _0081_ A_DOUT_BRAM6 Tile_X0Y1_IHP_BRAM_bot.Inst_IHP_BRAM_bot_ConfigMem.Inst_frame7_bit10.Q
+ Tile_X0Y1_IHP_BRAM_bot.Inst_IHP_BRAM_bot_switch_matrix.W1BEG1 VPWR VGND sg13g2_mux4_1
X_0851_ VGND VPWR Tile_X0Y1_E2END[2] Tile_X0Y1_IHP_BRAM_bot.Inst_IHP_BRAM_bot_ConfigMem.Inst_frame4_bit12.Q
+ _0242_ _0241_ sg13g2_a21oi_1
X_1334_ Tile_X0Y0_FrameData[21] Tile_X0Y1_FrameStrobe[9] Tile_X0Y0_IHP_BRAM_top.Inst_IHP_BRAM_top_ConfigMem.Inst_frame9_bit21.Q
+ VPWR VGND sg13g2_dlhq_1
XFILLER_83_215 VPWR VGND sg13g2_fill_1
X_1265_ Tile_X0Y0_FrameData[26] Tile_X0Y1_FrameStrobe[7] Tile_X0Y0_IHP_BRAM_top.Inst_IHP_BRAM_top_ConfigMem.Inst_frame7_bit26.Q
+ VPWR VGND sg13g2_dlhq_1
X_1403_ Tile_X0Y1_FrameData[16] Tile_X0Y1_FrameStrobe[1] Tile_X0Y1_IHP_BRAM_bot.Inst_IHP_BRAM_bot_ConfigMem.Inst_frame1_bit16.Q
+ VPWR VGND sg13g2_dlhq_1
X_1196_ Tile_X0Y0_FrameData[31] Tile_X0Y1_FrameStrobe[5] Tile_X0Y0_IHP_BRAM_top.Inst_IHP_BRAM_top_ConfigMem.Inst_frame5_bit31.Q
+ VPWR VGND sg13g2_dlhq_1
Xoutput340 net340 Tile_X0Y1_WW4BEG[4] VPWR VGND sg13g2_buf_1
XFILLER_74_215 VPWR VGND sg13g2_fill_1
XFILLER_42_101 VPWR VGND sg13g2_decap_8
XFILLER_42_112 VPWR VGND sg13g2_fill_1
XFILLER_42_178 VPWR VGND sg13g2_fill_2
XFILLER_51_20 VPWR VGND sg13g2_fill_1
XFILLER_51_97 VPWR VGND sg13g2_decap_8
X_1050_ Tile_X0Y0_FrameData[17] Tile_X0Y1_FrameStrobe[0] Tile_X0Y0_IHP_BRAM_top.Inst_IHP_BRAM_top_ConfigMem.Inst_frame0_bit17.Q
+ VPWR VGND sg13g2_dlhq_1
X_1883_ Tile_X0Y1_IHP_BRAM_bot.Inst_IHP_BRAM_bot_switch_matrix.S4BEG0 net285 VPWR
+ VGND sg13g2_buf_1
X_0834_ Tile_X0Y1_IHP_BRAM_bot.Inst_IHP_BRAM_bot_ConfigMem.Inst_frame5_bit27.Q A_DOUT_BRAM5
+ Tile_X0Y1_IHP_BRAM_bot.Inst_IHP_BRAM_bot_switch_matrix.J_NS4_BEG10 Tile_X0Y1_IHP_BRAM_bot.Inst_IHP_BRAM_bot_switch_matrix.J_NS4_BEG6
+ _0102_ Tile_X0Y1_IHP_BRAM_bot.Inst_IHP_BRAM_bot_ConfigMem.Inst_frame5_bit26.Q Tile_X0Y1_IHP_BRAM_bot.Inst_IHP_BRAM_bot_switch_matrix.W6BEG5
+ VPWR VGND sg13g2_mux4_1
X_0903_ Tile_X0Y1_IHP_BRAM_bot.Inst_IHP_BRAM_bot_ConfigMem.Inst_frame2_bit20.Q Tile_X0Y1_E1END[2]
+ Tile_X0Y1_EE4END[6] Tile_X0Y1_EE4END[14] Tile_X0Y1_IHP_BRAM_bot.Inst_IHP_BRAM_bot_switch_matrix.J_NS4_BEG14
+ Tile_X0Y1_IHP_BRAM_bot.Inst_IHP_BRAM_bot_ConfigMem.Inst_frame2_bit21.Q net86 VPWR
+ VGND sg13g2_mux4_1
X_0696_ VGND VPWR _0015_ _0164_ _0168_ _0167_ sg13g2_a21oi_1
X_0765_ VGND VPWR _0226_ _0227_ _0228_ Tile_X0Y0_IHP_BRAM_top.Inst_IHP_BRAM_top_ConfigMem.Inst_frame1_bit4.Q
+ sg13g2_a21oi_1
XFILLER_44_0 VPWR VGND sg13g2_decap_8
X_1317_ Tile_X0Y0_FrameData[6] Tile_X0Y1_FrameStrobe[8] Tile_X0Y0_IHP_BRAM_top.Inst_IHP_BRAM_top_ConfigMem.Inst_frame8_bit6.Q
+ VPWR VGND sg13g2_dlhq_1
X_1248_ Tile_X0Y0_FrameData[11] Tile_X0Y1_FrameStrobe[6] Tile_X0Y0_IHP_BRAM_top.Inst_IHP_BRAM_top_ConfigMem.Inst_frame6_bit11.Q
+ VPWR VGND sg13g2_dlhq_1
XFILLER_56_215 VPWR VGND sg13g2_fill_1
X_1179_ Tile_X0Y0_FrameData[16] Tile_X0Y1_FrameStrobe[4] Tile_X0Y0_IHP_BRAM_top.Inst_IHP_BRAM_top_ConfigMem.Inst_frame4_bit16.Q
+ VPWR VGND sg13g2_dlhq_1
XFILLER_24_145 VPWR VGND sg13g2_fill_1
XANTENNA_63 VPWR VGND Tile_X0Y1_N4END[5] sg13g2_antennanp
XANTENNA_74 VPWR VGND Tile_X0Y1_N4END[5] sg13g2_antennanp
XANTENNA_41 VPWR VGND Tile_X0Y1_N4END[4] sg13g2_antennanp
XANTENNA_30 VPWR VGND Tile_X0Y1_N4END[4] sg13g2_antennanp
XANTENNA_52 VPWR VGND Tile_X0Y1_N4END[4] sg13g2_antennanp
Xoutput181 net181 Tile_X0Y0_UserCLKo VPWR VGND sg13g2_buf_1
Xoutput170 net170 Tile_X0Y0_N4BEG[14] VPWR VGND sg13g2_buf_1
Xoutput192 net192 Tile_X0Y0_W2BEG[6] VPWR VGND sg13g2_buf_1
XFILLER_62_85 VPWR VGND sg13g2_decap_4
X_0550_ Tile_X0Y0_IHP_BRAM_top.Inst_IHP_BRAM_top_ConfigMem.Inst_frame6_bit2.Q A_DOUT_BRAM9
+ B_DOUT_BRAM9 Tile_X0Y0_IHP_BRAM_top.Inst_IHP_BRAM_top_switch_matrix.J_NS2_BEG1 Tile_X0Y0_IHP_BRAM_top.Inst_IHP_BRAM_top_switch_matrix.J_NS2_BEG6
+ Tile_X0Y0_IHP_BRAM_top.Inst_IHP_BRAM_top_ConfigMem.Inst_frame6_bit3.Q Tile_X0Y0_IHP_BRAM_top.Inst_IHP_BRAM_top_switch_matrix.W2BEGb1
+ VPWR VGND sg13g2_mux4_1
XFILLER_7_47 VPWR VGND sg13g2_fill_2
X_1102_ Tile_X0Y0_FrameData[29] Tile_X0Y1_FrameStrobe[2] Tile_X0Y0_IHP_BRAM_top.Inst_IHP_BRAM_top_ConfigMem.Inst_frame2_bit29.Q
+ VPWR VGND sg13g2_dlhq_1
XFILLER_16_4 VPWR VGND sg13g2_fill_2
X_0481_ _0090_ VPWR _0093_ VGND Tile_X0Y1_IHP_BRAM_bot.Inst_IHP_BRAM_bot_ConfigMem.Inst_frame0_bit29.Q
+ _0092_ sg13g2_o21ai_1
X_1033_ Tile_X0Y1_IHP_BRAM_bot.Inst_IHP_BRAM_bot_ConfigMem.Inst_frame3_bit27.Q Tile_X0Y1_N2MID[6]
+ Tile_X0Y1_N2END[3] Tile_X0Y1_E2MID[3] Tile_X0Y1_E2END[1] Tile_X0Y1_IHP_BRAM_bot.Inst_IHP_BRAM_bot_ConfigMem.Inst_frame3_bit28.Q
+ _0375_ VPWR VGND sg13g2_mux4_1
X_1797_ Tile_X0Y0_IHP_BRAM_top.Inst_IHP_BRAM_top_switch_matrix.W6BEG6 net210 VPWR
+ VGND sg13g2_buf_1
X_1866_ Tile_X0Y0_IHP_BRAM_top.Inst_IHP_BRAM_top_switch_matrix.S2BEG3 net277 VPWR
+ VGND sg13g2_buf_1
X_0817_ Tile_X0Y1_IHP_BRAM_bot.Inst_IHP_BRAM_bot_ConfigMem.Inst_frame1_bit18.Q Tile_X0Y1_N1END[1]
+ Tile_X0Y1_N4END[1] _0081_ Tile_X0Y0_S4END[5] Tile_X0Y1_IHP_BRAM_bot.Inst_IHP_BRAM_bot_ConfigMem.Inst_frame1_bit19.Q
+ Tile_X0Y1_IHP_BRAM_bot.Inst_IHP_BRAM_bot_switch_matrix.J_NS4_BEG5 VPWR VGND sg13g2_mux4_1
XFILLER_107_59 VPWR VGND sg13g2_fill_1
X_0679_ Tile_X0Y0_IHP_BRAM_top.Inst_IHP_BRAM_top_ConfigMem.Inst_frame8_bit0.Q VPWR
+ _0153_ VGND _0151_ _0152_ sg13g2_o21ai_1
X_0748_ _0211_ _0020_ Tile_X0Y0_IHP_BRAM_top.Inst_IHP_BRAM_top_switch_matrix.N2BEGb6
+ VPWR VGND sg13g2_nand2b_1
XFILLER_83_18 VPWR VGND sg13g2_fill_1
XFILLER_16_78 VPWR VGND sg13g2_fill_2
XFILLER_32_22 VPWR VGND sg13g2_fill_1
XFILLER_87_170 VPWR VGND sg13g2_fill_2
XFILLER_35_207 VPWR VGND sg13g2_fill_1
X_1720_ Tile_X0Y1_FrameStrobe[6] net141 VPWR VGND sg13g2_buf_1
X_1651_ Tile_X0Y1_FrameData[24] Tile_X0Y1_FrameStrobe[9] Tile_X0Y1_IHP_BRAM_bot.Inst_IHP_BRAM_bot_ConfigMem.Inst_frame9_bit24.Q
+ VPWR VGND sg13g2_dlhq_1
X_0464_ Tile_X0Y0_IHP_BRAM_top.Inst_IHP_BRAM_top_ConfigMem.Inst_frame0_bit26.Q Tile_X0Y0_IHP_BRAM_top.Inst_IHP_BRAM_top_ConfigMem.Inst_frame0_bit27.Q
+ Tile_X0Y0_IHP_BRAM_top.Inst_IHP_BRAM_top_switch_matrix.N1END1 _0079_ VPWR VGND sg13g2_nor3_1
XFILLER_98_70 VPWR VGND sg13g2_fill_2
X_0602_ Tile_X0Y0_IHP_BRAM_top.Inst_IHP_BRAM_top_ConfigMem.Inst_frame4_bit16.Q Tile_X0Y0_EE4END[4]
+ Tile_X0Y0_EE4END[12] Tile_X0Y0_E6END[4] Tile_X0Y0_IHP_BRAM_top.Inst_IHP_BRAM_top_switch_matrix.J_NS4_BEG4
+ Tile_X0Y0_IHP_BRAM_top.Inst_IHP_BRAM_top_ConfigMem.Inst_frame4_bit17.Q net32 VPWR
+ VGND sg13g2_mux4_1
X_1582_ Tile_X0Y1_FrameData[29] Tile_X0Y1_FrameStrobe[7] Tile_X0Y1_IHP_BRAM_bot.Inst_IHP_BRAM_bot_ConfigMem.Inst_frame7_bit29.Q
+ VPWR VGND sg13g2_dlhq_1
X_0533_ Tile_X0Y1_IHP_BRAM_bot.Inst_IHP_BRAM_bot_ConfigMem.Inst_frame0_bit24.Q Tile_X0Y1_N1END[0]
+ _0113_ VPWR VGND sg13g2_nor2b_1
X_0395_ VPWR _0018_ Tile_X0Y0_IHP_BRAM_top.Inst_IHP_BRAM_top_ConfigMem.Inst_frame7_bit6.Q
+ VGND sg13g2_inv_1
X_1016_ VGND VPWR _0359_ _0345_ Tile_X0Y0_S2MID[3] sg13g2_or2_1
X_1849_ Tile_X0Y1_FrameData[30] net253 VPWR VGND sg13g2_buf_1
X_1918_ Tile_X0Y1_IHP_BRAM_bot.Inst_IHP_BRAM_bot_switch_matrix.W6BEG11 net320 VPWR
+ VGND sg13g2_buf_1
XFILLER_27_77 VPWR VGND sg13g2_fill_1
XFILLER_90_154 VPWR VGND sg13g2_fill_1
X_1703_ Tile_X0Y0_FrameData[21] net106 VPWR VGND sg13g2_buf_1
X_1634_ Tile_X0Y1_FrameData[9] Tile_X0Y1_FrameStrobe[8] Tile_X0Y1_IHP_BRAM_bot.Inst_IHP_BRAM_bot_ConfigMem.Inst_frame8_bit9.Q
+ VPWR VGND sg13g2_dlhq_1
XFILLER_100_215 VPWR VGND sg13g2_fill_1
X_0516_ Tile_X0Y0_IHP_BRAM_top.Inst_IHP_BRAM_top_ConfigMem.Inst_frame9_bit16.Q Tile_X0Y0_E2MID[3]
+ Tile_X0Y0_E2END[3] Tile_X0Y0_E6END[3] Tile_X0Y0_IHP_BRAM_top.Inst_IHP_BRAM_top_switch_matrix.J_NS2_BEG4
+ Tile_X0Y0_IHP_BRAM_top.Inst_IHP_BRAM_top_ConfigMem.Inst_frame9_bit17.Q Tile_X0Y0_IHP_BRAM_top.Inst_IHP_BRAM_top_switch_matrix.N2BEG4
+ VPWR VGND sg13g2_mux4_1
XFILLER_58_118 VPWR VGND sg13g2_fill_2
X_1565_ Tile_X0Y1_FrameData[14] Tile_X0Y1_FrameStrobe[6] Tile_X0Y1_IHP_BRAM_bot.Inst_IHP_BRAM_bot_ConfigMem.Inst_frame6_bit14.Q
+ VPWR VGND sg13g2_dlhq_1
X_1496_ Tile_X0Y1_FrameData[19] Tile_X0Y1_FrameStrobe[4] Tile_X0Y1_IHP_BRAM_bot.Inst_IHP_BRAM_bot_ConfigMem.Inst_frame4_bit19.Q
+ VPWR VGND sg13g2_dlhq_1
X_0447_ Tile_X0Y1_IHP_BRAM_bot.Inst_IHP_BRAM_bot_ConfigMem.Inst_frame0_bit8.Q Tile_X0Y1_N2MID[0]
+ Tile_X0Y1_N2END[0] Tile_X0Y0_IHP_BRAM_top.Inst_IHP_BRAM_top_switch_matrix.S2BEG0
+ Tile_X0Y0_S2MID[0] Tile_X0Y1_IHP_BRAM_bot.Inst_IHP_BRAM_bot_ConfigMem.Inst_frame0_bit9.Q
+ _0065_ VPWR VGND sg13g2_mux4_1
X_0378_ VPWR _0001_ Tile_X0Y0_E2END[4] VGND sg13g2_inv_1
XFILLER_57_184 VPWR VGND sg13g2_fill_1
XFILLER_38_32 VPWR VGND sg13g2_fill_1
XFILLER_38_54 VPWR VGND sg13g2_fill_1
XFILLER_38_76 VPWR VGND sg13g2_fill_1
XFILLER_38_98 VPWR VGND sg13g2_decap_8
XFILLER_54_31 VPWR VGND sg13g2_decap_8
X_1350_ Tile_X0Y0_FrameData[5] Tile_X0Y1_FrameStrobe[9] Tile_X0Y0_IHP_BRAM_top.Inst_IHP_BRAM_top_ConfigMem.Inst_frame9_bit5.Q
+ VPWR VGND sg13g2_dlhq_1
X_1281_ Tile_X0Y0_FrameData[10] Tile_X0Y1_FrameStrobe[7] Tile_X0Y0_IHP_BRAM_top.Inst_IHP_BRAM_top_ConfigMem.Inst_frame7_bit10.Q
+ VPWR VGND sg13g2_dlhq_1
XFILLER_79_72 VPWR VGND sg13g2_fill_1
X_0996_ Tile_X0Y1_IHP_BRAM_bot.Inst_IHP_BRAM_bot_ConfigMem.Inst_frame7_bit6.Q VPWR
+ _0340_ VGND Tile_X0Y1_IHP_BRAM_bot.Inst_IHP_BRAM_bot_ConfigMem.Inst_frame7_bit5.Q
+ Tile_X0Y1_IHP_BRAM_bot.Inst_IHP_BRAM_bot_switch_matrix.J_NS4_BEG15 sg13g2_o21ai_1
X_1617_ Tile_X0Y1_FrameData[26] Tile_X0Y1_FrameStrobe[8] Tile_X0Y1_IHP_BRAM_bot.Inst_IHP_BRAM_bot_ConfigMem.Inst_frame8_bit26.Q
+ VPWR VGND sg13g2_dlhq_1
X_1548_ Tile_X0Y1_FrameData[31] Tile_X0Y1_FrameStrobe[6] Tile_X0Y1_IHP_BRAM_bot.Inst_IHP_BRAM_bot_ConfigMem.Inst_frame6_bit31.Q
+ VPWR VGND sg13g2_dlhq_1
X_1479_ Tile_X0Y1_FrameData[4] Tile_X0Y1_FrameStrobe[3] Tile_X0Y1_IHP_BRAM_bot.Inst_IHP_BRAM_bot_ConfigMem.Inst_frame3_bit4.Q
+ VPWR VGND sg13g2_dlhq_1
XFILLER_24_12 VPWR VGND sg13g2_fill_1
XFILLER_60_102 VPWR VGND sg13g2_fill_2
X_0850_ Tile_X0Y1_IHP_BRAM_bot.Inst_IHP_BRAM_bot_ConfigMem.Inst_frame4_bit12.Q Tile_X0Y1_E2MID[2]
+ _0241_ VPWR VGND sg13g2_nor2b_1
X_1402_ Tile_X0Y1_FrameData[17] Tile_X0Y1_FrameStrobe[1] Tile_X0Y1_IHP_BRAM_bot.Inst_IHP_BRAM_bot_ConfigMem.Inst_frame1_bit17.Q
+ VPWR VGND sg13g2_dlhq_1
X_0781_ Tile_X0Y1_IHP_BRAM_bot.Inst_IHP_BRAM_bot_ConfigMem.Inst_frame7_bit9.Q Tile_X0Y1_N1END[0]
+ A_DOUT_BRAM2 _0111_ A_DOUT_BRAM7 Tile_X0Y1_IHP_BRAM_bot.Inst_IHP_BRAM_bot_ConfigMem.Inst_frame7_bit8.Q
+ Tile_X0Y1_IHP_BRAM_bot.Inst_IHP_BRAM_bot_switch_matrix.W1BEG0 VPWR VGND sg13g2_mux4_1
X_1333_ Tile_X0Y0_FrameData[22] Tile_X0Y1_FrameStrobe[9] Tile_X0Y0_IHP_BRAM_top.Inst_IHP_BRAM_top_ConfigMem.Inst_frame9_bit22.Q
+ VPWR VGND sg13g2_dlhq_1
X_1264_ Tile_X0Y0_FrameData[27] Tile_X0Y1_FrameStrobe[7] Tile_X0Y0_IHP_BRAM_top.Inst_IHP_BRAM_top_ConfigMem.Inst_frame7_bit27.Q
+ VPWR VGND sg13g2_dlhq_1
X_1195_ Tile_X0Y0_FrameData[0] Tile_X0Y1_FrameStrobe[4] Tile_X0Y0_IHP_BRAM_top.Inst_IHP_BRAM_top_ConfigMem.Inst_frame4_bit0.Q
+ VPWR VGND sg13g2_dlhq_1
XFILLER_51_124 VPWR VGND sg13g2_decap_4
X_0979_ Tile_X0Y1_IHP_BRAM_bot.Inst_IHP_BRAM_bot_ConfigMem.Inst_frame7_bit3.Q VPWR
+ _0324_ VGND Tile_X0Y1_E6END[6] Tile_X0Y1_IHP_BRAM_bot.Inst_IHP_BRAM_bot_ConfigMem.Inst_frame7_bit2.Q
+ sg13g2_o21ai_1
XFILLER_59_213 VPWR VGND sg13g2_fill_2
Xoutput330 net330 Tile_X0Y1_WW4BEG[0] VPWR VGND sg13g2_buf_1
Xoutput341 net341 Tile_X0Y1_WW4BEG[5] VPWR VGND sg13g2_buf_1
XFILLER_35_33 VPWR VGND sg13g2_decap_8
XFILLER_35_44 VPWR VGND sg13g2_fill_2
X_0833_ Tile_X0Y1_IHP_BRAM_bot.Inst_IHP_BRAM_bot_ConfigMem.Inst_frame5_bit25.Q A_DOUT_BRAM4
+ Tile_X0Y1_IHP_BRAM_bot.Inst_IHP_BRAM_bot_switch_matrix.J_NS4_BEG11 Tile_X0Y1_IHP_BRAM_bot.Inst_IHP_BRAM_bot_switch_matrix.J_NS4_BEG7
+ _0065_ Tile_X0Y1_IHP_BRAM_bot.Inst_IHP_BRAM_bot_ConfigMem.Inst_frame5_bit24.Q Tile_X0Y1_IHP_BRAM_bot.Inst_IHP_BRAM_bot_switch_matrix.W6BEG4
+ VPWR VGND sg13g2_mux4_1
X_0902_ Tile_X0Y1_IHP_BRAM_bot.Inst_IHP_BRAM_bot_ConfigMem.Inst_frame2_bit18.Q Tile_X0Y1_E1END[1]
+ Tile_X0Y1_EE4END[5] Tile_X0Y1_EE4END[13] Tile_X0Y1_IHP_BRAM_bot.Inst_IHP_BRAM_bot_switch_matrix.J_NS4_BEG13
+ Tile_X0Y1_IHP_BRAM_bot.Inst_IHP_BRAM_bot_ConfigMem.Inst_frame2_bit19.Q net85 VPWR
+ VGND sg13g2_mux4_1
X_1882_ Tile_X0Y0_IHP_BRAM_top.Inst_IHP_BRAM_top_switch_matrix.S4BEG3 net284 VPWR
+ VGND sg13g2_buf_1
X_0695_ Tile_X0Y0_IHP_BRAM_top.Inst_IHP_BRAM_top_ConfigMem.Inst_frame8_bit30.Q VPWR
+ _0167_ VGND _0165_ _0166_ sg13g2_o21ai_1
X_0764_ Tile_X0Y0_IHP_BRAM_top.Inst_IHP_BRAM_top_ConfigMem.Inst_frame1_bit6.Q Tile_X0Y0_S2END[2]
+ _0227_ VPWR VGND Tile_X0Y0_IHP_BRAM_top.Inst_IHP_BRAM_top_ConfigMem.Inst_frame1_bit5.Q
+ sg13g2_nand3b_1
XFILLER_37_0 VPWR VGND sg13g2_decap_8
X_1316_ Tile_X0Y0_FrameData[7] Tile_X0Y1_FrameStrobe[8] Tile_X0Y0_IHP_BRAM_top.Inst_IHP_BRAM_top_ConfigMem.Inst_frame8_bit7.Q
+ VPWR VGND sg13g2_dlhq_1
X_1178_ Tile_X0Y0_FrameData[17] Tile_X0Y1_FrameStrobe[4] Tile_X0Y0_IHP_BRAM_top.Inst_IHP_BRAM_top_ConfigMem.Inst_frame4_bit17.Q
+ VPWR VGND sg13g2_dlhq_1
X_1247_ Tile_X0Y0_FrameData[12] Tile_X0Y1_FrameStrobe[6] Tile_X0Y0_IHP_BRAM_top.Inst_IHP_BRAM_top_ConfigMem.Inst_frame6_bit12.Q
+ VPWR VGND sg13g2_dlhq_1
XANTENNA_20 VPWR VGND Tile_X0Y1_FrameStrobe[18] sg13g2_antennanp
XANTENNA_31 VPWR VGND Tile_X0Y1_N4END[4] sg13g2_antennanp
XANTENNA_64 VPWR VGND Tile_X0Y1_N4END[5] sg13g2_antennanp
XANTENNA_53 VPWR VGND Tile_X0Y1_N4END[5] sg13g2_antennanp
XFILLER_97_28 VPWR VGND sg13g2_fill_2
XANTENNA_75 VPWR VGND Tile_X0Y1_N4END[5] sg13g2_antennanp
XANTENNA_42 VPWR VGND Tile_X0Y1_N4END[4] sg13g2_antennanp
Xoutput171 net171 Tile_X0Y0_N4BEG[15] VPWR VGND sg13g2_buf_1
Xoutput160 net160 Tile_X0Y0_N2BEGb[3] VPWR VGND sg13g2_buf_1
Xoutput193 net193 Tile_X0Y0_W2BEG[7] VPWR VGND sg13g2_buf_1
Xoutput182 net182 Tile_X0Y0_W1BEG[0] VPWR VGND sg13g2_buf_1
XFILLER_46_54 VPWR VGND sg13g2_decap_4
XFILLER_46_87 VPWR VGND sg13g2_decap_4
X_0480_ VGND VPWR Tile_X0Y1_E6END[2] Tile_X0Y1_IHP_BRAM_bot.Inst_IHP_BRAM_bot_ConfigMem.Inst_frame0_bit28.Q
+ _0092_ _0091_ sg13g2_a21oi_1
X_1101_ Tile_X0Y0_FrameData[30] Tile_X0Y1_FrameStrobe[2] Tile_X0Y0_IHP_BRAM_top.Inst_IHP_BRAM_top_ConfigMem.Inst_frame2_bit30.Q
+ VPWR VGND sg13g2_dlhq_1
X_1032_ _0374_ Tile_X0Y1_IHP_BRAM_bot.Inst_IHP_BRAM_bot_ConfigMem.Inst_frame3_bit26.Q
+ _0373_ VPWR VGND sg13g2_nand2b_1
X_1934_ Tile_X0Y1_IHP_BRAM_bot.Inst_IHP_BRAM_bot_switch_matrix.WW4BEG15 net336 VPWR
+ VGND sg13g2_buf_1
XFILLER_14_190 VPWR VGND sg13g2_fill_1
X_1796_ Tile_X0Y0_IHP_BRAM_top.Inst_IHP_BRAM_top_switch_matrix.W6BEG5 net209 VPWR
+ VGND sg13g2_buf_1
X_0747_ _0210_ VPWR net92 VGND _0195_ _0201_ sg13g2_o21ai_1
X_1865_ Tile_X0Y0_IHP_BRAM_top.Inst_IHP_BRAM_top_switch_matrix.S2BEG2 net276 VPWR
+ VGND sg13g2_buf_1
X_0816_ Tile_X0Y1_IHP_BRAM_bot.Inst_IHP_BRAM_bot_ConfigMem.Inst_frame5_bit2.Q A_DOUT_BRAM5
+ B_DOUT_BRAM1 Tile_X0Y1_IHP_BRAM_bot.Inst_IHP_BRAM_bot_switch_matrix.J_NS4_BEG6 _0046_
+ Tile_X0Y1_IHP_BRAM_bot.Inst_IHP_BRAM_bot_ConfigMem.Inst_frame5_bit3.Q Tile_X0Y1_IHP_BRAM_bot.Inst_IHP_BRAM_bot_switch_matrix.WW4BEG9
+ VPWR VGND sg13g2_mux4_1
X_0678_ Tile_X0Y0_IHP_BRAM_top.Inst_IHP_BRAM_top_ConfigMem.Inst_frame9_bit31.Q VPWR
+ _0152_ VGND Tile_X0Y0_IHP_BRAM_top.Inst_IHP_BRAM_top_ConfigMem.Inst_frame9_bit30.Q
+ Tile_X0Y0_IHP_BRAM_top.Inst_IHP_BRAM_top_switch_matrix.J_NS4_BEG14 sg13g2_o21ai_1
XFILLER_79_116 VPWR VGND sg13g2_decap_4
XFILLER_92_9 VPWR VGND sg13g2_fill_1
X_0601_ Tile_X0Y0_IHP_BRAM_top.Inst_IHP_BRAM_top_ConfigMem.Inst_frame4_bit14.Q Tile_X0Y0_EE4END[3]
+ Tile_X0Y0_EE4END[11] Tile_X0Y0_E6END[3] Tile_X0Y0_IHP_BRAM_top.Inst_IHP_BRAM_top_switch_matrix.J_NS4_BEG3
+ Tile_X0Y0_IHP_BRAM_top.Inst_IHP_BRAM_top_ConfigMem.Inst_frame4_bit15.Q net31 VPWR
+ VGND sg13g2_mux4_1
X_1581_ Tile_X0Y1_FrameData[30] Tile_X0Y1_FrameStrobe[7] Tile_X0Y1_IHP_BRAM_bot.Inst_IHP_BRAM_bot_ConfigMem.Inst_frame7_bit30.Q
+ VPWR VGND sg13g2_dlhq_1
X_1650_ Tile_X0Y1_FrameData[25] Tile_X0Y1_FrameStrobe[9] Tile_X0Y1_IHP_BRAM_bot.Inst_IHP_BRAM_bot_ConfigMem.Inst_frame9_bit25.Q
+ VPWR VGND sg13g2_dlhq_1
X_0463_ _0078_ Tile_X0Y0_S1END[1] Tile_X0Y0_IHP_BRAM_top.Inst_IHP_BRAM_top_ConfigMem.Inst_frame0_bit26.Q
+ VPWR VGND sg13g2_nand2b_1
X_0394_ VPWR _0017_ Tile_X0Y0_IHP_BRAM_top.Inst_IHP_BRAM_top_ConfigMem.Inst_frame7_bit3.Q
+ VGND sg13g2_inv_1
X_0532_ Tile_X0Y1_IHP_BRAM_bot.Inst_IHP_BRAM_bot_ConfigMem.Inst_frame0_bit25.Q _0111_
+ _0112_ VPWR VGND Tile_X0Y1_IHP_BRAM_bot.Inst_IHP_BRAM_bot_ConfigMem.Inst_frame0_bit24.Q
+ sg13g2_nand3b_1
X_1015_ Tile_X0Y1_E2END[4] Tile_X0Y1_IHP_BRAM_bot.Inst_IHP_BRAM_bot_ConfigMem.Inst_frame3_bit19.Q
+ Tile_X0Y1_IHP_BRAM_bot.Inst_IHP_BRAM_bot_ConfigMem.Inst_frame3_bit20.Q _0358_ VPWR
+ VGND sg13g2_or3_1
X_1917_ Tile_X0Y1_IHP_BRAM_bot.Inst_IHP_BRAM_bot_switch_matrix.W6BEG10 net319 VPWR
+ VGND sg13g2_buf_1
XFILLER_103_202 VPWR VGND sg13g2_fill_2
X_1848_ Tile_X0Y1_FrameData[29] net251 VPWR VGND sg13g2_buf_1
X_1779_ Tile_X0Y0_IHP_BRAM_top.Inst_IHP_BRAM_top_switch_matrix.W2BEG4 net190 VPWR
+ VGND sg13g2_buf_1
XFILLER_69_160 VPWR VGND sg13g2_fill_2
XFILLER_104_0 VPWR VGND sg13g2_fill_2
XFILLER_84_95 VPWR VGND sg13g2_decap_8
X_1702_ Tile_X0Y0_FrameData[20] net105 VPWR VGND sg13g2_buf_1
X_1564_ Tile_X0Y1_FrameData[15] Tile_X0Y1_FrameStrobe[6] Tile_X0Y1_IHP_BRAM_bot.Inst_IHP_BRAM_bot_ConfigMem.Inst_frame6_bit15.Q
+ VPWR VGND sg13g2_dlhq_1
X_1633_ Tile_X0Y1_FrameData[10] Tile_X0Y1_FrameStrobe[8] Tile_X0Y1_IHP_BRAM_bot.Inst_IHP_BRAM_bot_ConfigMem.Inst_frame8_bit10.Q
+ VPWR VGND sg13g2_dlhq_1
X_0515_ Tile_X0Y0_IHP_BRAM_top.Inst_IHP_BRAM_top_ConfigMem.Inst_frame0_bit17.Q Tile_X0Y0_IHP_BRAM_top.Inst_IHP_BRAM_top_switch_matrix.N2BEGb4
+ Tile_X0Y0_S2MID[4] Tile_X0Y1_N2MID[4] Tile_X0Y0_S2END[4] Tile_X0Y0_IHP_BRAM_top.Inst_IHP_BRAM_top_ConfigMem.Inst_frame0_bit16.Q
+ Tile_X0Y0_IHP_BRAM_top.Inst_IHP_BRAM_top_switch_matrix.J_NS2_BEG4 VPWR VGND sg13g2_mux4_1
X_0446_ Tile_X0Y0_IHP_BRAM_top.Inst_IHP_BRAM_top_ConfigMem.Inst_frame8_bit12.Q Tile_X0Y0_E2MID[7]
+ Tile_X0Y0_E2END[7] Tile_X0Y0_E6END[8] Tile_X0Y0_IHP_BRAM_top.Inst_IHP_BRAM_top_switch_matrix.J_NS2_BEG0
+ Tile_X0Y0_IHP_BRAM_top.Inst_IHP_BRAM_top_ConfigMem.Inst_frame8_bit13.Q Tile_X0Y0_IHP_BRAM_top.Inst_IHP_BRAM_top_switch_matrix.S2BEG0
+ VPWR VGND sg13g2_mux4_1
X_0377_ VPWR _0000_ Tile_X0Y1_N2MID[2] VGND sg13g2_inv_1
X_1495_ Tile_X0Y1_FrameData[20] Tile_X0Y1_FrameStrobe[4] Tile_X0Y1_IHP_BRAM_bot.Inst_IHP_BRAM_bot_ConfigMem.Inst_frame4_bit20.Q
+ VPWR VGND sg13g2_dlhq_1
XFILLER_89_18 VPWR VGND sg13g2_decap_8
XFILLER_49_119 VPWR VGND sg13g2_decap_4
XFILLER_57_130 VPWR VGND sg13g2_fill_1
XFILLER_95_214 VPWR VGND sg13g2_fill_2
XFILLER_95_61 VPWR VGND sg13g2_fill_2
X_1280_ Tile_X0Y0_FrameData[11] Tile_X0Y1_FrameStrobe[7] Tile_X0Y0_IHP_BRAM_top.Inst_IHP_BRAM_top_ConfigMem.Inst_frame7_bit11.Q
+ VPWR VGND sg13g2_dlhq_1
X_0995_ _0035_ _0107_ _0339_ VPWR VGND sg13g2_nor2_1
X_1616_ Tile_X0Y1_FrameData[27] Tile_X0Y1_FrameStrobe[8] Tile_X0Y1_IHP_BRAM_bot.Inst_IHP_BRAM_bot_ConfigMem.Inst_frame8_bit27.Q
+ VPWR VGND sg13g2_dlhq_1
XFILLER_5_92 VPWR VGND sg13g2_fill_1
XFILLER_5_70 VPWR VGND sg13g2_fill_1
X_1547_ Tile_X0Y1_FrameData[0] Tile_X0Y1_FrameStrobe[5] Tile_X0Y1_IHP_BRAM_bot.Inst_IHP_BRAM_bot_ConfigMem.Inst_frame5_bit0.Q
+ VPWR VGND sg13g2_dlhq_1
X_0429_ Tile_X0Y1_N2MID[3] Tile_X0Y0_E2MID[0] Tile_X0Y0_IHP_BRAM_top.Inst_IHP_BRAM_top_ConfigMem.Inst_frame1_bit0.Q
+ _0049_ VPWR VGND sg13g2_mux2_1
X_1478_ Tile_X0Y1_FrameData[5] Tile_X0Y1_FrameStrobe[3] Tile_X0Y1_IHP_BRAM_bot.Inst_IHP_BRAM_bot_ConfigMem.Inst_frame3_bit5.Q
+ VPWR VGND sg13g2_dlhq_1
XFILLER_39_152 VPWR VGND sg13g2_decap_8
XFILLER_54_100 VPWR VGND sg13g2_fill_2
XFILLER_54_133 VPWR VGND sg13g2_fill_1
XFILLER_108_168 VPWR VGND sg13g2_fill_2
XFILLER_108_102 VPWR VGND sg13g2_fill_1
XFILLER_65_97 VPWR VGND sg13g2_fill_1
XFILLER_81_63 VPWR VGND sg13g2_decap_8
X_0780_ Tile_X0Y1_IHP_BRAM_bot.Inst_IHP_BRAM_bot_ConfigMem.Inst_frame8_bit27.Q Tile_X0Y1_E1END[3]
+ Tile_X0Y1_E2END[0] Tile_X0Y1_E2MID[0] _0107_ Tile_X0Y1_IHP_BRAM_bot.Inst_IHP_BRAM_bot_ConfigMem.Inst_frame8_bit26.Q
+ Tile_X0Y1_IHP_BRAM_bot.Inst_IHP_BRAM_bot_switch_matrix.S2BEG7 VPWR VGND sg13g2_mux4_1
X_1401_ Tile_X0Y1_FrameData[18] Tile_X0Y1_FrameStrobe[1] Tile_X0Y1_IHP_BRAM_bot.Inst_IHP_BRAM_bot_ConfigMem.Inst_frame1_bit18.Q
+ VPWR VGND sg13g2_dlhq_1
X_1332_ Tile_X0Y0_FrameData[23] Tile_X0Y1_FrameStrobe[9] Tile_X0Y0_IHP_BRAM_top.Inst_IHP_BRAM_top_ConfigMem.Inst_frame9_bit23.Q
+ VPWR VGND sg13g2_dlhq_1
X_1194_ Tile_X0Y0_FrameData[1] Tile_X0Y1_FrameStrobe[4] Tile_X0Y0_IHP_BRAM_top.Inst_IHP_BRAM_top_ConfigMem.Inst_frame4_bit1.Q
+ VPWR VGND sg13g2_dlhq_1
X_1263_ Tile_X0Y0_FrameData[28] Tile_X0Y1_FrameStrobe[7] Tile_X0Y0_IHP_BRAM_top.Inst_IHP_BRAM_top_ConfigMem.Inst_frame7_bit28.Q
+ VPWR VGND sg13g2_dlhq_1
X_0978_ VGND VPWR _0316_ _0318_ Tile_X0Y1_IHP_BRAM_bot.Inst_IHP_BRAM_bot_switch_matrix.S4BEG1
+ _0323_ sg13g2_a21oi_1
XFILLER_105_127 VPWR VGND sg13g2_decap_8
Xoutput331 net331 Tile_X0Y1_WW4BEG[10] VPWR VGND sg13g2_buf_1
Xoutput342 net342 Tile_X0Y1_WW4BEG[6] VPWR VGND sg13g2_buf_1
Xoutput320 net320 Tile_X0Y1_W6BEG[11] VPWR VGND sg13g2_buf_1
XFILLER_35_12 VPWR VGND sg13g2_decap_4
XFILLER_50_180 VPWR VGND sg13g2_fill_2
XFILLER_51_55 VPWR VGND sg13g2_fill_2
XFILLER_104_182 VPWR VGND sg13g2_fill_2
XFILLER_76_74 VPWR VGND sg13g2_decap_8
X_1881_ Tile_X0Y0_IHP_BRAM_top.Inst_IHP_BRAM_top_switch_matrix.S4BEG2 net283 VPWR
+ VGND sg13g2_buf_1
X_0763_ _0225_ VPWR _0226_ VGND Tile_X0Y0_E2END[3] Tile_X0Y0_IHP_BRAM_top.Inst_IHP_BRAM_top_ConfigMem.Inst_frame1_bit5.Q
+ sg13g2_o21ai_1
X_0832_ Tile_X0Y1_IHP_BRAM_bot.Inst_IHP_BRAM_bot_ConfigMem.Inst_frame5_bit22.Q Tile_X0Y1_N4END[3]
+ Tile_X0Y0_S4END[7] Tile_X0Y1_IHP_BRAM_bot.Inst_IHP_BRAM_bot_switch_matrix.J_NS4_BEG8
+ Tile_X0Y1_IHP_BRAM_bot.Inst_IHP_BRAM_bot_switch_matrix.J_NS4_BEG12 Tile_X0Y1_IHP_BRAM_bot.Inst_IHP_BRAM_bot_ConfigMem.Inst_frame5_bit23.Q
+ Tile_X0Y1_IHP_BRAM_bot.Inst_IHP_BRAM_bot_switch_matrix.W6BEG3 VPWR VGND sg13g2_mux4_1
X_0901_ Tile_X0Y1_IHP_BRAM_bot.Inst_IHP_BRAM_bot_ConfigMem.Inst_frame2_bit16.Q Tile_X0Y1_E1END[0]
+ Tile_X0Y1_EE4END[4] Tile_X0Y1_EE4END[12] Tile_X0Y1_IHP_BRAM_bot.Inst_IHP_BRAM_bot_switch_matrix.J_NS4_BEG12
+ Tile_X0Y1_IHP_BRAM_bot.Inst_IHP_BRAM_bot_ConfigMem.Inst_frame2_bit17.Q net84 VPWR
+ VGND sg13g2_mux4_1
X_1315_ Tile_X0Y0_FrameData[8] Tile_X0Y1_FrameStrobe[8] Tile_X0Y0_IHP_BRAM_top.Inst_IHP_BRAM_top_ConfigMem.Inst_frame8_bit8.Q
+ VPWR VGND sg13g2_dlhq_1
X_0694_ Tile_X0Y0_IHP_BRAM_top.Inst_IHP_BRAM_top_ConfigMem.Inst_frame8_bit29.Q VPWR
+ _0166_ VGND Tile_X0Y0_IHP_BRAM_top.Inst_IHP_BRAM_top_ConfigMem.Inst_frame8_bit28.Q
+ Tile_X0Y0_IHP_BRAM_top.Inst_IHP_BRAM_top_switch_matrix.J_NS4_BEG12 sg13g2_o21ai_1
X_1177_ Tile_X0Y0_FrameData[18] Tile_X0Y1_FrameStrobe[4] Tile_X0Y0_IHP_BRAM_top.Inst_IHP_BRAM_top_ConfigMem.Inst_frame4_bit18.Q
+ VPWR VGND sg13g2_dlhq_1
X_1246_ Tile_X0Y0_FrameData[13] Tile_X0Y1_FrameStrobe[6] Tile_X0Y0_IHP_BRAM_top.Inst_IHP_BRAM_top_ConfigMem.Inst_frame6_bit13.Q
+ VPWR VGND sg13g2_dlhq_1
XANTENNA_10 VPWR VGND Tile_X0Y1_FrameStrobe[11] sg13g2_antennanp
XANTENNA_65 VPWR VGND Tile_X0Y1_N4END[5] sg13g2_antennanp
XANTENNA_54 VPWR VGND Tile_X0Y1_N4END[5] sg13g2_antennanp
XANTENNA_43 VPWR VGND Tile_X0Y1_N4END[4] sg13g2_antennanp
XANTENNA_32 VPWR VGND Tile_X0Y1_N4END[4] sg13g2_antennanp
XANTENNA_21 VPWR VGND Tile_X0Y1_N2MID[1] sg13g2_antennanp
Xoutput150 net150 Tile_X0Y0_N2BEG[1] VPWR VGND sg13g2_buf_1
XANTENNA_76 VPWR VGND Tile_X0Y1_N4END[5] sg13g2_antennanp
Xoutput161 net161 Tile_X0Y0_N2BEGb[4] VPWR VGND sg13g2_buf_1
XFILLER_21_69 VPWR VGND sg13g2_fill_1
Xoutput172 net172 Tile_X0Y0_N4BEG[1] VPWR VGND sg13g2_buf_1
Xoutput194 net194 Tile_X0Y0_W2BEGb[0] VPWR VGND sg13g2_buf_1
Xoutput183 net183 Tile_X0Y0_W1BEG[1] VPWR VGND sg13g2_buf_1
XFILLER_97_117 VPWR VGND sg13g2_fill_2
X_1100_ Tile_X0Y0_FrameData[31] Tile_X0Y1_FrameStrobe[2] Tile_X0Y0_IHP_BRAM_top.Inst_IHP_BRAM_top_ConfigMem.Inst_frame2_bit31.Q
+ VPWR VGND sg13g2_dlhq_1
XFILLER_16_6 VPWR VGND sg13g2_fill_1
X_1031_ Tile_X0Y1_IHP_BRAM_bot.Inst_IHP_BRAM_bot_ConfigMem.Inst_frame3_bit27.Q Tile_X0Y1_N2END[2]
+ Tile_X0Y1_E2MID[0] Tile_X0Y1_E2MID[6] Tile_X0Y1_E2END[2] Tile_X0Y1_IHP_BRAM_bot.Inst_IHP_BRAM_bot_ConfigMem.Inst_frame3_bit28.Q
+ _0373_ VPWR VGND sg13g2_mux4_1
X_1933_ Tile_X0Y1_IHP_BRAM_bot.Inst_IHP_BRAM_bot_switch_matrix.WW4BEG14 net335 VPWR
+ VGND sg13g2_buf_1
X_1795_ Tile_X0Y0_IHP_BRAM_top.Inst_IHP_BRAM_top_switch_matrix.W6BEG4 net208 VPWR
+ VGND sg13g2_buf_1
X_0746_ Tile_X0Y0_IHP_BRAM_top.Inst_IHP_BRAM_top_ConfigMem.Inst_frame2_bit31.Q VPWR
+ _0210_ VGND _0205_ _0209_ sg13g2_o21ai_1
X_1864_ Tile_X0Y0_IHP_BRAM_top.Inst_IHP_BRAM_top_switch_matrix.S2BEG1 net275 VPWR
+ VGND sg13g2_buf_1
X_0815_ Tile_X0Y1_IHP_BRAM_bot.Inst_IHP_BRAM_bot_ConfigMem.Inst_frame1_bit20.Q Tile_X0Y1_N1END[2]
+ Tile_X0Y1_N4END[2] _0089_ Tile_X0Y0_S4END[6] Tile_X0Y1_IHP_BRAM_bot.Inst_IHP_BRAM_bot_ConfigMem.Inst_frame1_bit21.Q
+ Tile_X0Y1_IHP_BRAM_bot.Inst_IHP_BRAM_bot_switch_matrix.J_NS4_BEG6 VPWR VGND sg13g2_mux4_1
X_0677_ Tile_X0Y0_IHP_BRAM_top.Inst_IHP_BRAM_top_switch_matrix.J_NS2_BEG2 Tile_X0Y0_IHP_BRAM_top.Inst_IHP_BRAM_top_ConfigMem.Inst_frame9_bit30.Q
+ _0151_ VPWR VGND sg13g2_nor2b_1
X_1229_ Tile_X0Y0_FrameData[30] Tile_X0Y1_FrameStrobe[6] Tile_X0Y0_IHP_BRAM_top.Inst_IHP_BRAM_top_ConfigMem.Inst_frame6_bit30.Q
+ VPWR VGND sg13g2_dlhq_1
XFILLER_32_57 VPWR VGND sg13g2_fill_2
XFILLER_79_139 VPWR VGND sg13g2_fill_2
XFILLER_57_98 VPWR VGND sg13g2_decap_8
X_0600_ Tile_X0Y0_IHP_BRAM_top.Inst_IHP_BRAM_top_ConfigMem.Inst_frame4_bit12.Q Tile_X0Y0_EE4END[2]
+ Tile_X0Y0_EE4END[10] Tile_X0Y0_E6END[2] Tile_X0Y0_IHP_BRAM_top.Inst_IHP_BRAM_top_switch_matrix.J_NS4_BEG2
+ Tile_X0Y0_IHP_BRAM_top.Inst_IHP_BRAM_top_ConfigMem.Inst_frame4_bit13.Q net30 VPWR
+ VGND sg13g2_mux4_1
X_0531_ Tile_X0Y0_IHP_BRAM_top.Inst_IHP_BRAM_top_ConfigMem.Inst_frame8_bit5.Q Tile_X0Y0_E1END[0]
+ Tile_X0Y0_IHP_BRAM_top.Inst_IHP_BRAM_top_switch_matrix.J_NS4_BEG12 Tile_X0Y0_E6END[8]
+ _0110_ Tile_X0Y0_IHP_BRAM_top.Inst_IHP_BRAM_top_ConfigMem.Inst_frame8_bit4.Q _0111_
+ VPWR VGND sg13g2_mux4_1
X_1580_ Tile_X0Y1_FrameData[31] Tile_X0Y1_FrameStrobe[7] Tile_X0Y1_IHP_BRAM_bot.Inst_IHP_BRAM_bot_ConfigMem.Inst_frame7_bit31.Q
+ VPWR VGND sg13g2_dlhq_1
X_0393_ VPWR _0016_ Tile_X0Y0_IHP_BRAM_top.Inst_IHP_BRAM_top_ConfigMem.Inst_frame7_bit0.Q
+ VGND sg13g2_inv_1
XFILLER_98_72 VPWR VGND sg13g2_fill_1
X_0462_ _0077_ _0073_ net44 VPWR VGND sg13g2_nor2b_1
X_1014_ _0357_ _0344_ Tile_X0Y0_IHP_BRAM_top.Inst_IHP_BRAM_top_switch_matrix.S2BEG0
+ VPWR VGND sg13g2_nand2b_1
XFILLER_97_0 VPWR VGND sg13g2_fill_2
X_1916_ Tile_X0Y1_IHP_BRAM_bot.Inst_IHP_BRAM_bot_switch_matrix.W6BEG9 net329 VPWR
+ VGND sg13g2_buf_1
X_1847_ Tile_X0Y1_FrameData[28] net250 VPWR VGND sg13g2_buf_1
X_0729_ VGND VPWR _0000_ Tile_X0Y0_IHP_BRAM_top.Inst_IHP_BRAM_top_ConfigMem.Inst_frame2_bit28.Q
+ _0193_ Tile_X0Y0_IHP_BRAM_top.Inst_IHP_BRAM_top_ConfigMem.Inst_frame2_bit29.Q sg13g2_a21oi_1
X_1778_ Tile_X0Y0_IHP_BRAM_top.Inst_IHP_BRAM_top_switch_matrix.W2BEG3 net189 VPWR
+ VGND sg13g2_buf_1
XFILLER_27_24 VPWR VGND sg13g2_fill_2
XFILLER_4_124 VPWR VGND sg13g2_fill_2
XFILLER_75_120 VPWR VGND sg13g2_fill_1
XFILLER_90_145 VPWR VGND sg13g2_decap_8
X_1701_ Tile_X0Y0_FrameData[19] net103 VPWR VGND sg13g2_buf_1
X_1563_ Tile_X0Y1_FrameData[16] Tile_X0Y1_FrameStrobe[6] Tile_X0Y1_IHP_BRAM_bot.Inst_IHP_BRAM_bot_ConfigMem.Inst_frame6_bit16.Q
+ VPWR VGND sg13g2_dlhq_1
X_1494_ Tile_X0Y1_FrameData[21] Tile_X0Y1_FrameStrobe[4] Tile_X0Y1_IHP_BRAM_bot.Inst_IHP_BRAM_bot_ConfigMem.Inst_frame4_bit21.Q
+ VPWR VGND sg13g2_dlhq_1
X_1632_ Tile_X0Y1_FrameData[11] Tile_X0Y1_FrameStrobe[8] Tile_X0Y1_IHP_BRAM_bot.Inst_IHP_BRAM_bot_ConfigMem.Inst_frame8_bit11.Q
+ VPWR VGND sg13g2_dlhq_1
X_0514_ Tile_X0Y1_IHP_BRAM_bot.Inst_IHP_BRAM_bot_ConfigMem.Inst_frame9_bit16.Q Tile_X0Y1_E2MID[3]
+ Tile_X0Y1_E2END[3] Tile_X0Y1_E6END[3] _0105_ Tile_X0Y1_IHP_BRAM_bot.Inst_IHP_BRAM_bot_ConfigMem.Inst_frame9_bit17.Q
+ Tile_X0Y0_IHP_BRAM_top.Inst_IHP_BRAM_top_switch_matrix.N2BEGb4 VPWR VGND sg13g2_mux4_1
XFILLER_66_164 VPWR VGND sg13g2_fill_1
XFILLER_66_142 VPWR VGND sg13g2_fill_2
X_0445_ VGND VPWR _0003_ _0053_ net90 _0064_ sg13g2_a21oi_1
XFILLER_81_145 VPWR VGND sg13g2_decap_8
XFILLER_110_50 VPWR VGND sg13g2_fill_2
XFILLER_79_63 VPWR VGND sg13g2_decap_8
XFILLER_63_112 VPWR VGND sg13g2_decap_8
X_0994_ VGND VPWR _0036_ _0337_ _0338_ Tile_X0Y1_IHP_BRAM_bot.Inst_IHP_BRAM_bot_ConfigMem.Inst_frame7_bit7.Q
+ sg13g2_a21oi_1
X_1546_ Tile_X0Y1_FrameData[1] Tile_X0Y1_FrameStrobe[5] Tile_X0Y1_IHP_BRAM_bot.Inst_IHP_BRAM_bot_ConfigMem.Inst_frame5_bit1.Q
+ VPWR VGND sg13g2_dlhq_1
X_1615_ Tile_X0Y1_FrameData[28] Tile_X0Y1_FrameStrobe[8] Tile_X0Y1_IHP_BRAM_bot.Inst_IHP_BRAM_bot_ConfigMem.Inst_frame8_bit28.Q
+ VPWR VGND sg13g2_dlhq_1
X_1477_ Tile_X0Y1_FrameData[6] Tile_X0Y1_FrameStrobe[3] Tile_X0Y1_IHP_BRAM_bot.Inst_IHP_BRAM_bot_ConfigMem.Inst_frame3_bit6.Q
+ VPWR VGND sg13g2_dlhq_1
X_0428_ _0047_ VPWR _0048_ VGND Tile_X0Y0_IHP_BRAM_top.Inst_IHP_BRAM_top_ConfigMem.Inst_frame1_bit0.Q
+ Tile_X0Y0_IHP_BRAM_top.Inst_IHP_BRAM_top_switch_matrix.N2BEGb6 sg13g2_o21ai_1
XFILLER_108_158 VPWR VGND sg13g2_fill_2
XFILLER_108_147 VPWR VGND sg13g2_decap_8
XFILLER_1_18 VPWR VGND sg13g2_fill_2
XFILLER_60_104 VPWR VGND sg13g2_fill_1
XFILLER_81_97 VPWR VGND sg13g2_fill_1
XFILLER_14_80 VPWR VGND sg13g2_fill_2
X_1331_ Tile_X0Y0_FrameData[24] Tile_X0Y1_FrameStrobe[9] Tile_X0Y0_IHP_BRAM_top.Inst_IHP_BRAM_top_ConfigMem.Inst_frame9_bit24.Q
+ VPWR VGND sg13g2_dlhq_1
X_1400_ Tile_X0Y1_FrameData[19] Tile_X0Y1_FrameStrobe[1] Tile_X0Y1_IHP_BRAM_bot.Inst_IHP_BRAM_bot_ConfigMem.Inst_frame1_bit19.Q
+ VPWR VGND sg13g2_dlhq_1
X_1193_ Tile_X0Y0_FrameData[2] Tile_X0Y1_FrameStrobe[4] Tile_X0Y0_IHP_BRAM_top.Inst_IHP_BRAM_top_ConfigMem.Inst_frame4_bit2.Q
+ VPWR VGND sg13g2_dlhq_1
X_1262_ Tile_X0Y0_FrameData[29] Tile_X0Y1_FrameStrobe[7] Tile_X0Y0_IHP_BRAM_top.Inst_IHP_BRAM_top_ConfigMem.Inst_frame7_bit29.Q
+ VPWR VGND sg13g2_dlhq_1
Xoutput321 net321 Tile_X0Y1_W6BEG[1] VPWR VGND sg13g2_buf_1
Xoutput343 net343 Tile_X0Y1_WW4BEG[7] VPWR VGND sg13g2_buf_1
XFILLER_10_38 VPWR VGND sg13g2_fill_2
Xoutput332 net332 Tile_X0Y1_WW4BEG[11] VPWR VGND sg13g2_buf_1
Xoutput310 net310 Tile_X0Y1_W2BEGb[0] VPWR VGND sg13g2_buf_1
X_0977_ VGND VPWR _0032_ _0321_ _0323_ _0322_ sg13g2_a21oi_1
XFILLER_59_215 VPWR VGND sg13g2_fill_1
XFILLER_19_69 VPWR VGND sg13g2_fill_2
X_1529_ Tile_X0Y1_FrameData[18] Tile_X0Y1_FrameStrobe[5] Tile_X0Y1_IHP_BRAM_bot.Inst_IHP_BRAM_bot_ConfigMem.Inst_frame5_bit18.Q
+ VPWR VGND sg13g2_dlhq_1
XFILLER_51_78 VPWR VGND sg13g2_fill_2
X_1880_ Tile_X0Y0_IHP_BRAM_top.Inst_IHP_BRAM_top_switch_matrix.S4BEG1 net297 VPWR
+ VGND sg13g2_buf_1
XFILLER_33_126 VPWR VGND sg13g2_fill_2
X_0900_ Tile_X0Y1_IHP_BRAM_bot.Inst_IHP_BRAM_bot_ConfigMem.Inst_frame2_bit14.Q Tile_X0Y1_EE4END[3]
+ Tile_X0Y1_EE4END[11] Tile_X0Y1_E6END[11] Tile_X0Y1_IHP_BRAM_bot.Inst_IHP_BRAM_bot_switch_matrix.J_NS4_BEG11
+ Tile_X0Y1_IHP_BRAM_bot.Inst_IHP_BRAM_bot_ConfigMem.Inst_frame2_bit15.Q net83 VPWR
+ VGND sg13g2_mux4_1
X_0693_ Tile_X0Y0_IHP_BRAM_top.Inst_IHP_BRAM_top_switch_matrix.J_NS2_BEG4 Tile_X0Y0_IHP_BRAM_top.Inst_IHP_BRAM_top_ConfigMem.Inst_frame8_bit28.Q
+ _0165_ VPWR VGND sg13g2_nor2b_1
X_0762_ VGND VPWR _0002_ Tile_X0Y0_IHP_BRAM_top.Inst_IHP_BRAM_top_ConfigMem.Inst_frame1_bit5.Q
+ _0225_ Tile_X0Y0_IHP_BRAM_top.Inst_IHP_BRAM_top_ConfigMem.Inst_frame1_bit6.Q sg13g2_a21oi_1
X_0831_ Tile_X0Y1_IHP_BRAM_bot.Inst_IHP_BRAM_bot_ConfigMem.Inst_frame5_bit20.Q Tile_X0Y1_N4END[2]
+ Tile_X0Y0_S4END[6] Tile_X0Y1_IHP_BRAM_bot.Inst_IHP_BRAM_bot_switch_matrix.J_NS4_BEG9
+ Tile_X0Y1_IHP_BRAM_bot.Inst_IHP_BRAM_bot_switch_matrix.J_NS4_BEG13 Tile_X0Y1_IHP_BRAM_bot.Inst_IHP_BRAM_bot_ConfigMem.Inst_frame5_bit21.Q
+ Tile_X0Y1_IHP_BRAM_bot.Inst_IHP_BRAM_bot_switch_matrix.W6BEG2 VPWR VGND sg13g2_mux4_1
XFILLER_110_175 VPWR VGND sg13g2_fill_1
X_1314_ Tile_X0Y0_FrameData[9] Tile_X0Y1_FrameStrobe[8] Tile_X0Y0_IHP_BRAM_top.Inst_IHP_BRAM_top_ConfigMem.Inst_frame8_bit9.Q
+ VPWR VGND sg13g2_dlhq_1
X_1176_ Tile_X0Y0_FrameData[19] Tile_X0Y1_FrameStrobe[4] Tile_X0Y0_IHP_BRAM_top.Inst_IHP_BRAM_top_ConfigMem.Inst_frame4_bit19.Q
+ VPWR VGND sg13g2_dlhq_1
X_1245_ Tile_X0Y0_FrameData[14] Tile_X0Y1_FrameStrobe[6] Tile_X0Y0_IHP_BRAM_top.Inst_IHP_BRAM_top_ConfigMem.Inst_frame6_bit14.Q
+ VPWR VGND sg13g2_dlhq_1
XANTENNA_11 VPWR VGND Tile_X0Y1_FrameStrobe[12] sg13g2_antennanp
XANTENNA_55 VPWR VGND Tile_X0Y1_N4END[5] sg13g2_antennanp
XANTENNA_66 VPWR VGND Tile_X0Y1_N4END[5] sg13g2_antennanp
XANTENNA_77 VPWR VGND Tile_X0Y1_N4END[5] sg13g2_antennanp
XANTENNA_44 VPWR VGND Tile_X0Y1_N4END[4] sg13g2_antennanp
XANTENNA_33 VPWR VGND Tile_X0Y1_N4END[4] sg13g2_antennanp
XANTENNA_22 VPWR VGND Tile_X0Y1_N2MID[1] sg13g2_antennanp
Xoutput140 net140 Tile_X0Y0_FrameStrobe_O[5] VPWR VGND sg13g2_buf_1
Xoutput151 net151 Tile_X0Y0_N2BEG[2] VPWR VGND sg13g2_buf_1
Xoutput162 net162 Tile_X0Y0_N2BEGb[5] VPWR VGND sg13g2_buf_1
Xoutput173 net173 Tile_X0Y0_N4BEG[2] VPWR VGND sg13g2_buf_1
Xoutput195 net195 Tile_X0Y0_W2BEGb[1] VPWR VGND sg13g2_buf_1
Xoutput184 net184 Tile_X0Y0_W1BEG[2] VPWR VGND sg13g2_buf_1
X_1030_ VPWR VGND _0371_ _0040_ _0370_ Tile_X0Y1_IHP_BRAM_bot.Inst_IHP_BRAM_bot_ConfigMem.Inst_frame3_bit26.Q
+ _0372_ _0368_ sg13g2_a221oi_1
X_1932_ Tile_X0Y1_IHP_BRAM_bot.Inst_IHP_BRAM_bot_switch_matrix.WW4BEG13 net334 VPWR
+ VGND sg13g2_buf_1
X_1863_ Tile_X0Y0_IHP_BRAM_top.Inst_IHP_BRAM_top_switch_matrix.S2BEG0 net274 VPWR
+ VGND sg13g2_buf_1
X_0814_ Tile_X0Y1_IHP_BRAM_bot.Inst_IHP_BRAM_bot_ConfigMem.Inst_frame5_bit0.Q A_DOUT_BRAM4
+ B_DOUT_BRAM0 Tile_X0Y1_IHP_BRAM_bot.Inst_IHP_BRAM_bot_switch_matrix.J_NS4_BEG7 _0107_
+ Tile_X0Y1_IHP_BRAM_bot.Inst_IHP_BRAM_bot_ConfigMem.Inst_frame5_bit1.Q Tile_X0Y1_IHP_BRAM_bot.Inst_IHP_BRAM_bot_switch_matrix.WW4BEG8
+ VPWR VGND sg13g2_mux4_1
XFILLER_107_18 VPWR VGND sg13g2_fill_2
X_0676_ Tile_X0Y0_IHP_BRAM_top.Inst_IHP_BRAM_top_switch_matrix.J_NS4_BEG6 Tile_X0Y0_IHP_BRAM_top.Inst_IHP_BRAM_top_switch_matrix.J_NS4_BEG10
+ Tile_X0Y0_IHP_BRAM_top.Inst_IHP_BRAM_top_ConfigMem.Inst_frame9_bit30.Q _0150_ VPWR
+ VGND sg13g2_mux2_1
X_1794_ Tile_X0Y0_IHP_BRAM_top.Inst_IHP_BRAM_top_switch_matrix.W6BEG3 net207 VPWR
+ VGND sg13g2_buf_1
X_0745_ VGND VPWR _0207_ _0208_ _0209_ Tile_X0Y0_IHP_BRAM_top.Inst_IHP_BRAM_top_ConfigMem.Inst_frame2_bit28.Q
+ sg13g2_a21oi_1
XFILLER_42_0 VPWR VGND sg13g2_fill_1
X_1228_ Tile_X0Y0_FrameData[31] Tile_X0Y1_FrameStrobe[6] Tile_X0Y0_IHP_BRAM_top.Inst_IHP_BRAM_top_ConfigMem.Inst_frame6_bit31.Q
+ VPWR VGND sg13g2_dlhq_1
X_1159_ Tile_X0Y0_FrameData[4] Tile_X0Y1_FrameStrobe[3] Tile_X0Y0_IHP_BRAM_top.Inst_IHP_BRAM_top_ConfigMem.Inst_frame3_bit4.Q
+ VPWR VGND sg13g2_dlhq_1
XFILLER_12_129 VPWR VGND sg13g2_fill_2
XFILLER_87_140 VPWR VGND sg13g2_fill_2
X_0530_ VPWR VGND _0108_ _0109_ Tile_X0Y0_IHP_BRAM_top.Inst_IHP_BRAM_top_ConfigMem.Inst_frame0_bit25.Q
+ _0010_ _0110_ Tile_X0Y0_IHP_BRAM_top.Inst_IHP_BRAM_top_ConfigMem.Inst_frame0_bit24.Q
+ sg13g2_a221oi_1
X_0392_ VPWR _0015_ Tile_X0Y0_IHP_BRAM_top.Inst_IHP_BRAM_top_ConfigMem.Inst_frame8_bit29.Q
+ VGND sg13g2_inv_1
XFILLER_14_4 VPWR VGND sg13g2_fill_2
X_0461_ CONFIGURED_top VPWR _0077_ VGND Tile_X0Y1_IHP_BRAM_bot.Inst_IHP_BRAM_bot_ConfigMem.Inst_frame3_bit25.Q
+ _0076_ sg13g2_o21ai_1
X_1013_ VGND VPWR _0352_ _0355_ _0356_ Tile_X0Y1_IHP_BRAM_bot.Inst_IHP_BRAM_bot_ConfigMem.Inst_frame3_bit21.Q
+ sg13g2_a21oi_1
X_1846_ Tile_X0Y1_FrameData[27] net249 VPWR VGND sg13g2_buf_1
X_1777_ Tile_X0Y0_IHP_BRAM_top.Inst_IHP_BRAM_top_switch_matrix.W2BEG2 net188 VPWR
+ VGND sg13g2_buf_1
X_1915_ Tile_X0Y1_IHP_BRAM_bot.Inst_IHP_BRAM_bot_switch_matrix.W6BEG8 net328 VPWR
+ VGND sg13g2_buf_1
X_0728_ _0192_ _0019_ Tile_X0Y0_IHP_BRAM_top.Inst_IHP_BRAM_top_switch_matrix.N2BEGb6
+ VPWR VGND sg13g2_nand2b_1
X_0659_ VPWR VGND Tile_X0Y0_IHP_BRAM_top.Inst_IHP_BRAM_top_ConfigMem.Inst_frame2_bit26.Q
+ _0134_ _0135_ Tile_X0Y0_IHP_BRAM_top.Inst_IHP_BRAM_top_ConfigMem.Inst_frame2_bit27.Q
+ net56 _0045_ sg13g2_a221oi_1
XFILLER_68_43 VPWR VGND sg13g2_fill_2
X_1700_ Tile_X0Y0_FrameData[18] net102 VPWR VGND sg13g2_buf_1
X_1631_ Tile_X0Y1_FrameData[12] Tile_X0Y1_FrameStrobe[8] Tile_X0Y1_IHP_BRAM_bot.Inst_IHP_BRAM_bot_ConfigMem.Inst_frame8_bit12.Q
+ VPWR VGND sg13g2_dlhq_1
X_0444_ CONFIGURED_top VPWR _0064_ VGND _0062_ _0063_ sg13g2_o21ai_1
X_1562_ Tile_X0Y1_FrameData[17] Tile_X0Y1_FrameStrobe[6] Tile_X0Y1_IHP_BRAM_bot.Inst_IHP_BRAM_bot_ConfigMem.Inst_frame6_bit17.Q
+ VPWR VGND sg13g2_dlhq_1
X_1493_ Tile_X0Y1_FrameData[22] Tile_X0Y1_FrameStrobe[4] Tile_X0Y1_IHP_BRAM_bot.Inst_IHP_BRAM_bot_ConfigMem.Inst_frame4_bit22.Q
+ VPWR VGND sg13g2_dlhq_1
X_0513_ Tile_X0Y1_IHP_BRAM_bot.Inst_IHP_BRAM_bot_ConfigMem.Inst_frame0_bit16.Q Tile_X0Y1_N2MID[4]
+ Tile_X0Y1_N2END[4] Tile_X0Y0_IHP_BRAM_top.Inst_IHP_BRAM_top_switch_matrix.S2BEG4
+ Tile_X0Y0_S2MID[4] Tile_X0Y1_IHP_BRAM_bot.Inst_IHP_BRAM_bot_ConfigMem.Inst_frame0_bit17.Q
+ _0105_ VPWR VGND sg13g2_mux4_1
X_1829_ Tile_X0Y1_FrameData[10] net231 VPWR VGND sg13g2_buf_1
XFILLER_72_124 VPWR VGND sg13g2_fill_2
XFILLER_72_102 VPWR VGND sg13g2_fill_1
XFILLER_54_12 VPWR VGND sg13g2_fill_2
XFILLER_54_56 VPWR VGND sg13g2_decap_4
XFILLER_54_78 VPWR VGND sg13g2_decap_4
XFILLER_70_77 VPWR VGND sg13g2_decap_4
XFILLER_95_74 VPWR VGND sg13g2_decap_4
X_0993_ Tile_X0Y1_E1END[3] Tile_X0Y1_EE4END[15] Tile_X0Y1_IHP_BRAM_bot.Inst_IHP_BRAM_bot_ConfigMem.Inst_frame7_bit5.Q
+ _0337_ VPWR VGND sg13g2_mux2_1
X_1614_ Tile_X0Y1_FrameData[29] Tile_X0Y1_FrameStrobe[8] Tile_X0Y1_IHP_BRAM_bot.Inst_IHP_BRAM_bot_ConfigMem.Inst_frame8_bit29.Q
+ VPWR VGND sg13g2_dlhq_1
X_0427_ VGND VPWR _0000_ Tile_X0Y0_IHP_BRAM_top.Inst_IHP_BRAM_top_ConfigMem.Inst_frame1_bit0.Q
+ _0047_ Tile_X0Y0_IHP_BRAM_top.Inst_IHP_BRAM_top_ConfigMem.Inst_frame1_bit1.Q sg13g2_a21oi_1
X_1545_ Tile_X0Y1_FrameData[2] Tile_X0Y1_FrameStrobe[5] Tile_X0Y1_IHP_BRAM_bot.Inst_IHP_BRAM_bot_ConfigMem.Inst_frame5_bit2.Q
+ VPWR VGND sg13g2_dlhq_1
X_1476_ Tile_X0Y1_FrameData[7] Tile_X0Y1_FrameStrobe[3] Tile_X0Y1_IHP_BRAM_bot.Inst_IHP_BRAM_bot_ConfigMem.Inst_frame3_bit7.Q
+ VPWR VGND sg13g2_dlhq_1
XFILLER_39_176 VPWR VGND sg13g2_decap_8
XFILLER_65_22 VPWR VGND sg13g2_fill_1
XFILLER_49_67 VPWR VGND sg13g2_decap_4
XFILLER_49_89 VPWR VGND sg13g2_decap_4
XFILLER_107_170 VPWR VGND sg13g2_decap_8
X_1330_ Tile_X0Y0_FrameData[25] Tile_X0Y1_FrameStrobe[9] Tile_X0Y0_IHP_BRAM_top.Inst_IHP_BRAM_top_ConfigMem.Inst_frame9_bit25.Q
+ VPWR VGND sg13g2_dlhq_1
X_1261_ Tile_X0Y0_FrameData[30] Tile_X0Y1_FrameStrobe[7] Tile_X0Y0_IHP_BRAM_top.Inst_IHP_BRAM_top_ConfigMem.Inst_frame7_bit30.Q
+ VPWR VGND sg13g2_dlhq_1
X_1192_ Tile_X0Y0_FrameData[3] Tile_X0Y1_FrameStrobe[4] Tile_X0Y0_IHP_BRAM_top.Inst_IHP_BRAM_top_ConfigMem.Inst_frame4_bit3.Q
+ VPWR VGND sg13g2_dlhq_1
X_0976_ Tile_X0Y1_IHP_BRAM_bot.Inst_IHP_BRAM_bot_ConfigMem.Inst_frame7_bit1.Q VPWR
+ _0322_ VGND _0319_ _0320_ sg13g2_o21ai_1
Xoutput344 net344 Tile_X0Y1_WW4BEG[8] VPWR VGND sg13g2_buf_1
Xoutput333 net333 Tile_X0Y1_WW4BEG[12] VPWR VGND sg13g2_buf_1
Xoutput322 net322 Tile_X0Y1_W6BEG[2] VPWR VGND sg13g2_buf_1
Xoutput300 net300 Tile_X0Y1_W1BEG[2] VPWR VGND sg13g2_buf_1
Xoutput311 net311 Tile_X0Y1_W2BEGb[1] VPWR VGND sg13g2_buf_1
X_1528_ Tile_X0Y1_FrameData[19] Tile_X0Y1_FrameStrobe[5] Tile_X0Y1_IHP_BRAM_bot.Inst_IHP_BRAM_bot_ConfigMem.Inst_frame5_bit19.Q
+ VPWR VGND sg13g2_dlhq_1
X_1459_ Tile_X0Y1_FrameData[24] Tile_X0Y1_FrameStrobe[3] Tile_X0Y1_IHP_BRAM_bot.Inst_IHP_BRAM_bot_ConfigMem.Inst_frame3_bit24.Q
+ VPWR VGND sg13g2_dlhq_1
XFILLER_104_184 VPWR VGND sg13g2_fill_1
X_0830_ Tile_X0Y1_IHP_BRAM_bot.Inst_IHP_BRAM_bot_ConfigMem.Inst_frame5_bit18.Q Tile_X0Y1_N4END[1]
+ Tile_X0Y0_S4END[5] Tile_X0Y1_IHP_BRAM_bot.Inst_IHP_BRAM_bot_switch_matrix.J_NS4_BEG10
+ Tile_X0Y1_IHP_BRAM_bot.Inst_IHP_BRAM_bot_switch_matrix.J_NS4_BEG14 Tile_X0Y1_IHP_BRAM_bot.Inst_IHP_BRAM_bot_ConfigMem.Inst_frame5_bit19.Q
+ Tile_X0Y1_IHP_BRAM_bot.Inst_IHP_BRAM_bot_switch_matrix.W6BEG1 VPWR VGND sg13g2_mux4_1
X_0692_ Tile_X0Y0_IHP_BRAM_top.Inst_IHP_BRAM_top_switch_matrix.J_NS4_BEG4 Tile_X0Y0_IHP_BRAM_top.Inst_IHP_BRAM_top_switch_matrix.J_NS4_BEG8
+ Tile_X0Y0_IHP_BRAM_top.Inst_IHP_BRAM_top_ConfigMem.Inst_frame8_bit28.Q _0164_ VPWR
+ VGND sg13g2_mux2_1
X_0761_ VGND VPWR _0222_ _0223_ _0224_ _0020_ sg13g2_a21oi_1
X_1313_ Tile_X0Y0_FrameData[10] Tile_X0Y1_FrameStrobe[8] Tile_X0Y0_IHP_BRAM_top.Inst_IHP_BRAM_top_ConfigMem.Inst_frame8_bit10.Q
+ VPWR VGND sg13g2_dlhq_1
X_1244_ Tile_X0Y0_FrameData[15] Tile_X0Y1_FrameStrobe[6] Tile_X0Y0_IHP_BRAM_top.Inst_IHP_BRAM_top_ConfigMem.Inst_frame6_bit15.Q
+ VPWR VGND sg13g2_dlhq_1
X_1175_ Tile_X0Y0_FrameData[20] Tile_X0Y1_FrameStrobe[4] Tile_X0Y0_IHP_BRAM_top.Inst_IHP_BRAM_top_ConfigMem.Inst_frame4_bit20.Q
+ VPWR VGND sg13g2_dlhq_1
XANTENNA_12 VPWR VGND Tile_X0Y1_FrameStrobe[13] sg13g2_antennanp
XANTENNA_78 VPWR VGND Tile_X0Y1_FrameStrobe[19] sg13g2_antennanp
XANTENNA_23 VPWR VGND Tile_X0Y1_N2MID[1] sg13g2_antennanp
XANTENNA_56 VPWR VGND Tile_X0Y1_N4END[5] sg13g2_antennanp
XANTENNA_67 VPWR VGND Tile_X0Y1_N4END[5] sg13g2_antennanp
XANTENNA_45 VPWR VGND Tile_X0Y1_N4END[4] sg13g2_antennanp
XANTENNA_34 VPWR VGND Tile_X0Y1_N4END[4] sg13g2_antennanp
X_0959_ _0305_ VPWR _0306_ VGND _0029_ _0233_ sg13g2_o21ai_1
Xoutput141 net141 Tile_X0Y0_FrameStrobe_O[6] VPWR VGND sg13g2_buf_1
Xoutput152 net152 Tile_X0Y0_N2BEG[3] VPWR VGND sg13g2_buf_1
Xoutput130 net130 Tile_X0Y0_FrameStrobe_O[14] VPWR VGND sg13g2_buf_1
Xoutput174 net174 Tile_X0Y0_N4BEG[3] VPWR VGND sg13g2_buf_1
Xoutput163 net163 Tile_X0Y0_N2BEGb[6] VPWR VGND sg13g2_buf_1
Xoutput196 net196 Tile_X0Y0_W2BEGb[2] VPWR VGND sg13g2_buf_1
Xoutput185 net185 Tile_X0Y0_W1BEG[3] VPWR VGND sg13g2_buf_1
XFILLER_70_211 VPWR VGND sg13g2_fill_1
XFILLER_62_89 VPWR VGND sg13g2_fill_1
XFILLER_62_78 VPWR VGND sg13g2_decap_8
X_1793_ Tile_X0Y0_IHP_BRAM_top.Inst_IHP_BRAM_top_switch_matrix.W6BEG2 net206 VPWR
+ VGND sg13g2_buf_1
X_0813_ Tile_X0Y1_IHP_BRAM_bot.Inst_IHP_BRAM_bot_ConfigMem.Inst_frame1_bit22.Q Tile_X0Y1_N1END[3]
+ Tile_X0Y1_N4END[3] _0097_ Tile_X0Y0_S4END[7] Tile_X0Y1_IHP_BRAM_bot.Inst_IHP_BRAM_bot_ConfigMem.Inst_frame1_bit23.Q
+ Tile_X0Y1_IHP_BRAM_bot.Inst_IHP_BRAM_bot_switch_matrix.J_NS4_BEG7 VPWR VGND sg13g2_mux4_1
X_1862_ Tile_X0Y1_IHP_BRAM_bot.Inst_IHP_BRAM_bot_switch_matrix.S2BEG7 net273 VPWR
+ VGND sg13g2_buf_1
X_1931_ Tile_X0Y1_IHP_BRAM_bot.Inst_IHP_BRAM_bot_switch_matrix.WW4BEG12 net333 VPWR
+ VGND sg13g2_buf_1
X_0675_ _0147_ _0149_ Tile_X0Y0_IHP_BRAM_top.Inst_IHP_BRAM_top_switch_matrix.N4BEG1
+ VPWR VGND sg13g2_nor2_1
X_0744_ Tile_X0Y0_IHP_BRAM_top.Inst_IHP_BRAM_top_ConfigMem.Inst_frame2_bit30.Q Tile_X0Y0_S2END[2]
+ _0208_ VPWR VGND Tile_X0Y0_IHP_BRAM_top.Inst_IHP_BRAM_top_ConfigMem.Inst_frame2_bit29.Q
+ sg13g2_nand3b_1
XFILLER_35_0 VPWR VGND sg13g2_decap_8
X_1158_ Tile_X0Y0_FrameData[5] Tile_X0Y1_FrameStrobe[3] Tile_X0Y0_IHP_BRAM_top.Inst_IHP_BRAM_top_ConfigMem.Inst_frame3_bit5.Q
+ VPWR VGND sg13g2_dlhq_1
X_1227_ Tile_X0Y0_FrameData[0] Tile_X0Y1_FrameStrobe[5] Tile_X0Y0_IHP_BRAM_top.Inst_IHP_BRAM_top_ConfigMem.Inst_frame5_bit0.Q
+ VPWR VGND sg13g2_dlhq_1
X_1089_ Tile_X0Y0_FrameData[10] Tile_X0Y1_FrameStrobe[1] Tile_X0Y0_IHP_BRAM_top.Inst_IHP_BRAM_top_ConfigMem.Inst_frame1_bit10.Q
+ VPWR VGND sg13g2_dlhq_1
XFILLER_7_167 VPWR VGND sg13g2_fill_1
X_0460_ _0075_ _0074_ Tile_X0Y1_IHP_BRAM_bot.Inst_IHP_BRAM_bot_ConfigMem.Inst_frame3_bit24.Q
+ _0076_ VPWR VGND sg13g2_mux2_1
X_0391_ VPWR _0014_ Tile_X0Y0_IHP_BRAM_top.Inst_IHP_BRAM_top_ConfigMem.Inst_frame8_bit2.Q
+ VGND sg13g2_inv_1
X_1012_ VPWR VGND _0344_ _0347_ _0354_ _0348_ _0355_ _0350_ sg13g2_a221oi_1
X_1914_ Tile_X0Y1_IHP_BRAM_bot.Inst_IHP_BRAM_bot_switch_matrix.W6BEG7 net327 VPWR
+ VGND sg13g2_buf_1
X_1776_ Tile_X0Y0_IHP_BRAM_top.Inst_IHP_BRAM_top_switch_matrix.W2BEG1 net187 VPWR
+ VGND sg13g2_buf_1
X_0727_ Tile_X0Y1_IHP_BRAM_bot.Inst_IHP_BRAM_bot_ConfigMem.Inst_frame0_bit6.Q Tile_X0Y1_N1END[3]
+ Tile_X0Y1_N4END[3] _0097_ Tile_X0Y0_S4END[7] Tile_X0Y1_IHP_BRAM_bot.Inst_IHP_BRAM_bot_ConfigMem.Inst_frame0_bit7.Q
+ Tile_X0Y1_IHP_BRAM_bot.Inst_IHP_BRAM_bot_switch_matrix.J_NS4_BEG15 VPWR VGND sg13g2_mux4_1
X_1845_ Tile_X0Y1_FrameData[26] net248 VPWR VGND sg13g2_buf_1
X_0589_ Tile_X0Y0_IHP_BRAM_top.Inst_IHP_BRAM_top_ConfigMem.Inst_frame5_bit22.Q Tile_X0Y1_N4END[7]
+ Tile_X0Y0_S4END[3] Tile_X0Y0_IHP_BRAM_top.Inst_IHP_BRAM_top_switch_matrix.J_NS4_BEG8
+ Tile_X0Y0_IHP_BRAM_top.Inst_IHP_BRAM_top_switch_matrix.J_NS4_BEG12 Tile_X0Y0_IHP_BRAM_top.Inst_IHP_BRAM_top_ConfigMem.Inst_frame5_bit23.Q
+ Tile_X0Y0_IHP_BRAM_top.Inst_IHP_BRAM_top_switch_matrix.W6BEG3 VPWR VGND sg13g2_mux4_1
X_0658_ _0135_ Tile_X0Y0_E2END[4] Tile_X0Y0_IHP_BRAM_top.Inst_IHP_BRAM_top_ConfigMem.Inst_frame2_bit27.Q
+ VPWR VGND sg13g2_nand2b_1
XFILLER_43_58 VPWR VGND sg13g2_decap_4
XFILLER_4_126 VPWR VGND sg13g2_fill_1
XFILLER_84_32 VPWR VGND sg13g2_decap_4
XFILLER_31_214 VPWR VGND sg13g2_fill_2
X_1630_ Tile_X0Y1_FrameData[13] Tile_X0Y1_FrameStrobe[8] Tile_X0Y1_IHP_BRAM_bot.Inst_IHP_BRAM_bot_ConfigMem.Inst_frame8_bit13.Q
+ VPWR VGND sg13g2_dlhq_1
X_0512_ Tile_X0Y0_IHP_BRAM_top.Inst_IHP_BRAM_top_ConfigMem.Inst_frame8_bit21.Q Tile_X0Y0_E1END[0]
+ Tile_X0Y0_E2END[3] Tile_X0Y0_E2MID[3] Tile_X0Y0_IHP_BRAM_top.Inst_IHP_BRAM_top_switch_matrix.J_NS2_BEG4
+ Tile_X0Y0_IHP_BRAM_top.Inst_IHP_BRAM_top_ConfigMem.Inst_frame8_bit20.Q Tile_X0Y0_IHP_BRAM_top.Inst_IHP_BRAM_top_switch_matrix.S2BEG4
+ VPWR VGND sg13g2_mux4_1
X_0443_ _0063_ Tile_X0Y0_IHP_BRAM_top.Inst_IHP_BRAM_top_ConfigMem.Inst_frame1_bit3.Q
+ _0058_ VPWR VGND sg13g2_nand2_1
X_1561_ Tile_X0Y1_FrameData[18] Tile_X0Y1_FrameStrobe[6] Tile_X0Y1_IHP_BRAM_bot.Inst_IHP_BRAM_bot_ConfigMem.Inst_frame6_bit18.Q
+ VPWR VGND sg13g2_dlhq_1
X_1492_ Tile_X0Y1_FrameData[23] Tile_X0Y1_FrameStrobe[4] Tile_X0Y1_IHP_BRAM_bot.Inst_IHP_BRAM_bot_ConfigMem.Inst_frame4_bit23.Q
+ VPWR VGND sg13g2_dlhq_1
X_1759_ Tile_X0Y1_N4END[13] net176 VPWR VGND sg13g2_buf_1
XFILLER_1_129 VPWR VGND sg13g2_fill_1
X_1828_ Tile_X0Y1_FrameData[9] net261 VPWR VGND sg13g2_buf_1
XFILLER_72_169 VPWR VGND sg13g2_fill_2
XFILLER_70_56 VPWR VGND sg13g2_decap_4
XFILLER_70_12 VPWR VGND sg13g2_fill_2
XFILLER_102_0 VPWR VGND sg13g2_fill_1
XFILLER_79_76 VPWR VGND sg13g2_fill_2
X_0992_ _0335_ VPWR _0336_ VGND _0035_ _0230_ sg13g2_o21ai_1
XFILLER_74_4 VPWR VGND sg13g2_fill_1
X_1544_ Tile_X0Y1_FrameData[3] Tile_X0Y1_FrameStrobe[5] Tile_X0Y1_IHP_BRAM_bot.Inst_IHP_BRAM_bot_ConfigMem.Inst_frame5_bit3.Q
+ VPWR VGND sg13g2_dlhq_1
X_1613_ Tile_X0Y1_FrameData[30] Tile_X0Y1_FrameStrobe[8] Tile_X0Y1_IHP_BRAM_bot.Inst_IHP_BRAM_bot_ConfigMem.Inst_frame8_bit30.Q
+ VPWR VGND sg13g2_dlhq_1
X_0426_ Tile_X0Y0_IHP_BRAM_top.Inst_IHP_BRAM_top_ConfigMem.Inst_frame0_bit21.Q Tile_X0Y0_IHP_BRAM_top.Inst_IHP_BRAM_top_switch_matrix.N2BEGb6
+ Tile_X0Y0_S2MID[6] Tile_X0Y1_N2MID[6] Tile_X0Y0_S2END[6] Tile_X0Y0_IHP_BRAM_top.Inst_IHP_BRAM_top_ConfigMem.Inst_frame0_bit20.Q
+ Tile_X0Y0_IHP_BRAM_top.Inst_IHP_BRAM_top_switch_matrix.J_NS2_BEG6 VPWR VGND sg13g2_mux4_1
X_1475_ Tile_X0Y1_FrameData[8] Tile_X0Y1_FrameStrobe[3] Tile_X0Y1_IHP_BRAM_bot.Inst_IHP_BRAM_bot_ConfigMem.Inst_frame3_bit8.Q
+ VPWR VGND sg13g2_dlhq_1
XFILLER_45_147 VPWR VGND sg13g2_decap_4
XFILLER_14_82 VPWR VGND sg13g2_fill_1
X_1191_ Tile_X0Y0_FrameData[4] Tile_X0Y1_FrameStrobe[4] Tile_X0Y0_IHP_BRAM_top.Inst_IHP_BRAM_top_ConfigMem.Inst_frame4_bit4.Q
+ VPWR VGND sg13g2_dlhq_1
X_1260_ Tile_X0Y0_FrameData[31] Tile_X0Y1_FrameStrobe[7] Tile_X0Y0_IHP_BRAM_top.Inst_IHP_BRAM_top_ConfigMem.Inst_frame7_bit31.Q
+ VPWR VGND sg13g2_dlhq_1
XFILLER_39_7 VPWR VGND sg13g2_fill_2
XFILLER_36_136 VPWR VGND sg13g2_decap_8
XFILLER_51_128 VPWR VGND sg13g2_fill_2
XFILLER_65_0 VPWR VGND sg13g2_fill_1
X_0975_ Tile_X0Y1_IHP_BRAM_bot.Inst_IHP_BRAM_bot_switch_matrix.J_NS4_BEG5 Tile_X0Y1_IHP_BRAM_bot.Inst_IHP_BRAM_bot_switch_matrix.J_NS4_BEG9
+ Tile_X0Y1_IHP_BRAM_bot.Inst_IHP_BRAM_bot_ConfigMem.Inst_frame8_bit31.Q _0321_ VPWR
+ VGND sg13g2_mux2_1
Xoutput323 net323 Tile_X0Y1_W6BEG[3] VPWR VGND sg13g2_buf_1
Xoutput334 net334 Tile_X0Y1_WW4BEG[13] VPWR VGND sg13g2_buf_1
Xoutput345 net345 Tile_X0Y1_WW4BEG[9] VPWR VGND sg13g2_buf_1
Xoutput312 net312 Tile_X0Y1_W2BEGb[2] VPWR VGND sg13g2_buf_1
Xoutput301 net301 Tile_X0Y1_W1BEG[3] VPWR VGND sg13g2_buf_1
X_1527_ Tile_X0Y1_FrameData[20] Tile_X0Y1_FrameStrobe[5] Tile_X0Y1_IHP_BRAM_bot.Inst_IHP_BRAM_bot_ConfigMem.Inst_frame5_bit20.Q
+ VPWR VGND sg13g2_dlhq_1
X_1389_ Tile_X0Y1_FrameData[30] Tile_X0Y1_FrameStrobe[1] Tile_X0Y1_IHP_BRAM_bot.Inst_IHP_BRAM_bot_ConfigMem.Inst_frame1_bit30.Q
+ VPWR VGND sg13g2_dlhq_1
X_0409_ VPWR _0032_ Tile_X0Y1_IHP_BRAM_bot.Inst_IHP_BRAM_bot_ConfigMem.Inst_frame7_bit0.Q
+ VGND sg13g2_inv_1
X_1458_ Tile_X0Y1_FrameData[25] Tile_X0Y1_FrameStrobe[3] Tile_X0Y1_IHP_BRAM_bot.Inst_IHP_BRAM_bot_ConfigMem.Inst_frame3_bit25.Q
+ VPWR VGND sg13g2_dlhq_1
XFILLER_104_163 VPWR VGND sg13g2_fill_2
XFILLER_92_76 VPWR VGND sg13g2_fill_2
XFILLER_76_88 VPWR VGND sg13g2_fill_1
XFILLER_33_128 VPWR VGND sg13g2_fill_1
X_0760_ VGND VPWR Tile_X0Y0_S2MID[0] Tile_X0Y0_IHP_BRAM_top.Inst_IHP_BRAM_top_ConfigMem.Inst_frame1_bit5.Q
+ _0223_ _0221_ sg13g2_a21oi_1
X_0691_ _0161_ _0163_ Tile_X0Y0_IHP_BRAM_top.Inst_IHP_BRAM_top_switch_matrix.N4BEG3
+ VPWR VGND sg13g2_nor2_1
X_1174_ Tile_X0Y0_FrameData[21] Tile_X0Y1_FrameStrobe[4] Tile_X0Y0_IHP_BRAM_top.Inst_IHP_BRAM_top_ConfigMem.Inst_frame4_bit21.Q
+ VPWR VGND sg13g2_dlhq_1
X_1312_ Tile_X0Y0_FrameData[11] Tile_X0Y1_FrameStrobe[8] Tile_X0Y0_IHP_BRAM_top.Inst_IHP_BRAM_top_ConfigMem.Inst_frame8_bit11.Q
+ VPWR VGND sg13g2_dlhq_1
X_1243_ Tile_X0Y0_FrameData[16] Tile_X0Y1_FrameStrobe[6] Tile_X0Y0_IHP_BRAM_top.Inst_IHP_BRAM_top_ConfigMem.Inst_frame6_bit16.Q
+ VPWR VGND sg13g2_dlhq_1
XFILLER_2_74 VPWR VGND sg13g2_fill_2
XANTENNA_13 VPWR VGND Tile_X0Y1_FrameStrobe[14] sg13g2_antennanp
XFILLER_24_106 VPWR VGND sg13g2_decap_4
XFILLER_32_161 VPWR VGND sg13g2_decap_4
XFILLER_32_183 VPWR VGND sg13g2_fill_1
XANTENNA_57 VPWR VGND Tile_X0Y1_N4END[5] sg13g2_antennanp
XANTENNA_68 VPWR VGND Tile_X0Y1_N4END[5] sg13g2_antennanp
XANTENNA_46 VPWR VGND Tile_X0Y1_N4END[4] sg13g2_antennanp
XANTENNA_35 VPWR VGND Tile_X0Y1_N4END[4] sg13g2_antennanp
X_0958_ VPWR _0305_ _0304_ VGND sg13g2_inv_1
XFILLER_21_39 VPWR VGND sg13g2_fill_1
XANTENNA_24 VPWR VGND Tile_X0Y1_N2MID[7] sg13g2_antennanp
XANTENNA_79 VPWR VGND Tile_X0Y1_N4END[9] sg13g2_antennanp
X_0889_ Tile_X0Y1_IHP_BRAM_bot.Inst_IHP_BRAM_bot_ConfigMem.Inst_frame2_bit5.Q _0104_
+ _0258_ VPWR VGND Tile_X0Y1_IHP_BRAM_bot.Inst_IHP_BRAM_bot_ConfigMem.Inst_frame2_bit4.Q
+ sg13g2_nand3b_1
Xoutput142 net142 Tile_X0Y0_FrameStrobe_O[7] VPWR VGND sg13g2_buf_1
Xoutput153 net153 Tile_X0Y0_N2BEG[4] VPWR VGND sg13g2_buf_1
Xoutput131 net131 Tile_X0Y0_FrameStrobe_O[15] VPWR VGND sg13g2_buf_1
XFILLER_101_122 VPWR VGND sg13g2_fill_1
Xoutput175 net175 Tile_X0Y0_N4BEG[4] VPWR VGND sg13g2_buf_1
Xoutput164 net164 Tile_X0Y0_N2BEGb[7] VPWR VGND sg13g2_buf_1
Xoutput120 net120 Tile_X0Y0_FrameData_O[5] VPWR VGND sg13g2_buf_1
Xoutput197 net197 Tile_X0Y0_W2BEGb[3] VPWR VGND sg13g2_buf_1
Xoutput186 net186 Tile_X0Y0_W2BEG[0] VPWR VGND sg13g2_buf_1
XFILLER_15_117 VPWR VGND sg13g2_fill_2
XFILLER_102_75 VPWR VGND sg13g2_fill_2
X_1930_ Tile_X0Y1_IHP_BRAM_bot.Inst_IHP_BRAM_bot_switch_matrix.WW4BEG11 net332 VPWR
+ VGND sg13g2_buf_1
X_1792_ Tile_X0Y0_IHP_BRAM_top.Inst_IHP_BRAM_top_switch_matrix.W6BEG1 net205 VPWR
+ VGND sg13g2_buf_1
X_0743_ _0206_ VPWR _0207_ VGND Tile_X0Y0_E2END[3] Tile_X0Y0_IHP_BRAM_top.Inst_IHP_BRAM_top_ConfigMem.Inst_frame2_bit29.Q
+ sg13g2_o21ai_1
X_0812_ Tile_X0Y1_IHP_BRAM_bot.Inst_IHP_BRAM_bot_ConfigMem.Inst_frame6_bit30.Q A_DOUT_BRAM7
+ B_DOUT_BRAM3 Tile_X0Y1_IHP_BRAM_bot.Inst_IHP_BRAM_bot_switch_matrix.J_NS4_BEG8 _0065_
+ Tile_X0Y1_IHP_BRAM_bot.Inst_IHP_BRAM_bot_ConfigMem.Inst_frame6_bit31.Q Tile_X0Y1_IHP_BRAM_bot.Inst_IHP_BRAM_bot_switch_matrix.WW4BEG7
+ VPWR VGND sg13g2_mux4_1
X_1861_ Tile_X0Y1_IHP_BRAM_bot.Inst_IHP_BRAM_bot_switch_matrix.S2BEG6 net272 VPWR
+ VGND sg13g2_buf_1
X_0674_ Tile_X0Y0_IHP_BRAM_top.Inst_IHP_BRAM_top_ConfigMem.Inst_frame9_bit29.Q _0148_
+ _0149_ VPWR VGND sg13g2_nor2_1
XFILLER_28_0 VPWR VGND sg13g2_fill_1
X_1157_ Tile_X0Y0_FrameData[6] Tile_X0Y1_FrameStrobe[3] Tile_X0Y0_IHP_BRAM_top.Inst_IHP_BRAM_top_ConfigMem.Inst_frame3_bit6.Q
+ VPWR VGND sg13g2_dlhq_1
X_1226_ Tile_X0Y0_FrameData[1] Tile_X0Y1_FrameStrobe[5] Tile_X0Y0_IHP_BRAM_top.Inst_IHP_BRAM_top_ConfigMem.Inst_frame5_bit1.Q
+ VPWR VGND sg13g2_dlhq_1
X_1088_ Tile_X0Y0_FrameData[11] Tile_X0Y1_FrameStrobe[1] Tile_X0Y0_IHP_BRAM_top.Inst_IHP_BRAM_top_ConfigMem.Inst_frame1_bit11.Q
+ VPWR VGND sg13g2_dlhq_1
XFILLER_87_120 VPWR VGND sg13g2_fill_2
X_0390_ VPWR _0013_ Tile_X0Y0_IHP_BRAM_top.Inst_IHP_BRAM_top_ConfigMem.Inst_frame9_bit31.Q
+ VGND sg13g2_inv_1
XFILLER_93_134 VPWR VGND sg13g2_fill_1
X_1011_ VGND VPWR Tile_X0Y1_N2END[3] _0037_ _0354_ _0353_ sg13g2_a21oi_1
X_1913_ Tile_X0Y1_IHP_BRAM_bot.Inst_IHP_BRAM_bot_switch_matrix.W6BEG6 net326 VPWR
+ VGND sg13g2_buf_1
X_1775_ Tile_X0Y0_IHP_BRAM_top.Inst_IHP_BRAM_top_switch_matrix.W2BEG0 net186 VPWR
+ VGND sg13g2_buf_1
X_0726_ Tile_X0Y1_IHP_BRAM_bot.Inst_IHP_BRAM_bot_ConfigMem.Inst_frame0_bit4.Q Tile_X0Y1_N1END[2]
+ Tile_X0Y1_N4END[2] _0089_ Tile_X0Y0_S4END[6] Tile_X0Y1_IHP_BRAM_bot.Inst_IHP_BRAM_bot_ConfigMem.Inst_frame0_bit5.Q
+ Tile_X0Y1_IHP_BRAM_bot.Inst_IHP_BRAM_bot_switch_matrix.J_NS4_BEG14 VPWR VGND sg13g2_mux4_1
X_1844_ Tile_X0Y1_FrameData[25] net247 VPWR VGND sg13g2_buf_1
X_0588_ Tile_X0Y0_IHP_BRAM_top.Inst_IHP_BRAM_top_ConfigMem.Inst_frame5_bit20.Q Tile_X0Y1_N4END[6]
+ Tile_X0Y0_S4END[2] Tile_X0Y0_IHP_BRAM_top.Inst_IHP_BRAM_top_switch_matrix.J_NS4_BEG9
+ Tile_X0Y0_IHP_BRAM_top.Inst_IHP_BRAM_top_switch_matrix.J_NS4_BEG13 Tile_X0Y0_IHP_BRAM_top.Inst_IHP_BRAM_top_ConfigMem.Inst_frame5_bit21.Q
+ Tile_X0Y0_IHP_BRAM_top.Inst_IHP_BRAM_top_switch_matrix.W6BEG2 VPWR VGND sg13g2_mux4_1
X_0657_ Tile_X0Y0_E2MID[4] Tile_X0Y0_IHP_BRAM_top.Inst_IHP_BRAM_top_ConfigMem.Inst_frame2_bit26.Q
+ Tile_X0Y0_IHP_BRAM_top.Inst_IHP_BRAM_top_ConfigMem.Inst_frame2_bit27.Q _0134_ VPWR
+ VGND sg13g2_nor3_1
X_1209_ Tile_X0Y0_FrameData[18] Tile_X0Y1_FrameStrobe[5] Tile_X0Y0_IHP_BRAM_top.Inst_IHP_BRAM_top_ConfigMem.Inst_frame5_bit18.Q
+ VPWR VGND sg13g2_dlhq_1
XFILLER_84_189 VPWR VGND sg13g2_fill_1
XFILLER_40_215 VPWR VGND sg13g2_fill_1
X_0511_ Tile_X0Y0_IHP_BRAM_top.Inst_IHP_BRAM_top_ConfigMem.Inst_frame9_bit15.Q Tile_X0Y0_E2MID[4]
+ Tile_X0Y0_E6END[4] Tile_X0Y0_E2END[4] Tile_X0Y0_IHP_BRAM_top.Inst_IHP_BRAM_top_switch_matrix.J_NS2_BEG3
+ Tile_X0Y0_IHP_BRAM_top.Inst_IHP_BRAM_top_ConfigMem.Inst_frame9_bit14.Q Tile_X0Y0_IHP_BRAM_top.Inst_IHP_BRAM_top_switch_matrix.N2BEG3
+ VPWR VGND sg13g2_mux4_1
X_1560_ Tile_X0Y1_FrameData[19] Tile_X0Y1_FrameStrobe[6] Tile_X0Y1_IHP_BRAM_bot.Inst_IHP_BRAM_bot_ConfigMem.Inst_frame6_bit19.Q
+ VPWR VGND sg13g2_dlhq_1
X_0442_ VGND VPWR _0059_ _0061_ _0062_ Tile_X0Y0_IHP_BRAM_top.Inst_IHP_BRAM_top_ConfigMem.Inst_frame1_bit0.Q
+ sg13g2_a21oi_1
X_1491_ Tile_X0Y1_FrameData[24] Tile_X0Y1_FrameStrobe[4] Tile_X0Y1_IHP_BRAM_bot.Inst_IHP_BRAM_bot_ConfigMem.Inst_frame4_bit24.Q
+ VPWR VGND sg13g2_dlhq_1
XFILLER_81_115 VPWR VGND sg13g2_fill_2
XFILLER_95_0 VPWR VGND sg13g2_fill_1
X_1827_ Tile_X0Y1_FrameData[8] net260 VPWR VGND sg13g2_buf_1
X_0709_ Tile_X0Y0_IHP_BRAM_top.Inst_IHP_BRAM_top_switch_matrix.J_NS2_BEG6 Tile_X0Y0_IHP_BRAM_top.Inst_IHP_BRAM_top_ConfigMem.Inst_frame7_bit2.Q
+ _0179_ VPWR VGND sg13g2_nor2b_1
X_1689_ Tile_X0Y0_FrameData[7] net122 VPWR VGND sg13g2_buf_1
XFILLER_89_215 VPWR VGND sg13g2_fill_1
X_1758_ Tile_X0Y1_N4END[12] net175 VPWR VGND sg13g2_buf_1
XFILLER_72_137 VPWR VGND sg13g2_decap_8
XFILLER_57_112 VPWR VGND sg13g2_decap_8
XFILLER_13_215 VPWR VGND sg13g2_fill_1
XFILLER_0_130 VPWR VGND sg13g2_fill_2
XFILLER_48_134 VPWR VGND sg13g2_decap_8
XFILLER_63_137 VPWR VGND sg13g2_fill_2
XFILLER_71_181 VPWR VGND sg13g2_decap_4
X_0991_ VPWR _0335_ _0334_ VGND sg13g2_inv_1
X_1543_ Tile_X0Y1_FrameData[4] Tile_X0Y1_FrameStrobe[5] Tile_X0Y1_IHP_BRAM_bot.Inst_IHP_BRAM_bot_ConfigMem.Inst_frame5_bit4.Q
+ VPWR VGND sg13g2_dlhq_1
X_1474_ Tile_X0Y1_FrameData[9] Tile_X0Y1_FrameStrobe[3] Tile_X0Y1_IHP_BRAM_bot.Inst_IHP_BRAM_bot_ConfigMem.Inst_frame3_bit9.Q
+ VPWR VGND sg13g2_dlhq_1
X_1612_ Tile_X0Y1_FrameData[31] Tile_X0Y1_FrameStrobe[8] Tile_X0Y1_IHP_BRAM_bot.Inst_IHP_BRAM_bot_ConfigMem.Inst_frame8_bit31.Q
+ VPWR VGND sg13g2_dlhq_1
X_0425_ Tile_X0Y1_IHP_BRAM_bot.Inst_IHP_BRAM_bot_ConfigMem.Inst_frame9_bit20.Q Tile_X0Y1_E2MID[1]
+ Tile_X0Y1_E2END[1] Tile_X0Y1_E6END[1] _0046_ Tile_X0Y1_IHP_BRAM_bot.Inst_IHP_BRAM_bot_ConfigMem.Inst_frame9_bit21.Q
+ Tile_X0Y0_IHP_BRAM_top.Inst_IHP_BRAM_top_switch_matrix.N2BEGb6 VPWR VGND sg13g2_mux4_1
XFILLER_54_126 VPWR VGND sg13g2_decap_8
XFILLER_49_14 VPWR VGND sg13g2_fill_2
XFILLER_49_47 VPWR VGND sg13g2_fill_2
XFILLER_105_86 VPWR VGND sg13g2_fill_2
XFILLER_14_61 VPWR VGND sg13g2_fill_2
XFILLER_53_170 VPWR VGND sg13g2_fill_1
XFILLER_5_211 VPWR VGND sg13g2_fill_1
XFILLER_91_210 VPWR VGND sg13g2_fill_2
X_1190_ Tile_X0Y0_FrameData[5] Tile_X0Y1_FrameStrobe[4] Tile_X0Y0_IHP_BRAM_top.Inst_IHP_BRAM_top_ConfigMem.Inst_frame4_bit5.Q
+ VPWR VGND sg13g2_dlhq_1
X_0974_ Tile_X0Y1_IHP_BRAM_bot.Inst_IHP_BRAM_bot_ConfigMem.Inst_frame7_bit0.Q VPWR
+ _0320_ VGND Tile_X0Y1_IHP_BRAM_bot.Inst_IHP_BRAM_bot_ConfigMem.Inst_frame8_bit31.Q
+ Tile_X0Y1_IHP_BRAM_bot.Inst_IHP_BRAM_bot_switch_matrix.J_NS4_BEG13 sg13g2_o21ai_1
Xoutput335 net335 Tile_X0Y1_WW4BEG[14] VPWR VGND sg13g2_buf_1
Xoutput324 net324 Tile_X0Y1_W6BEG[4] VPWR VGND sg13g2_buf_1
Xoutput313 net313 Tile_X0Y1_W2BEGb[3] VPWR VGND sg13g2_buf_1
Xoutput302 net302 Tile_X0Y1_W2BEG[0] VPWR VGND sg13g2_buf_1
X_1526_ Tile_X0Y1_FrameData[21] Tile_X0Y1_FrameStrobe[5] Tile_X0Y1_IHP_BRAM_bot.Inst_IHP_BRAM_bot_ConfigMem.Inst_frame5_bit21.Q
+ VPWR VGND sg13g2_dlhq_1
X_1457_ Tile_X0Y1_FrameData[26] Tile_X0Y1_FrameStrobe[3] Tile_X0Y1_IHP_BRAM_bot.Inst_IHP_BRAM_bot_ConfigMem.Inst_frame3_bit26.Q
+ VPWR VGND sg13g2_dlhq_1
X_1388_ Tile_X0Y1_FrameData[31] Tile_X0Y1_FrameStrobe[1] Tile_X0Y1_IHP_BRAM_bot.Inst_IHP_BRAM_bot_ConfigMem.Inst_frame1_bit31.Q
+ VPWR VGND sg13g2_dlhq_1
X_0408_ VPWR _0031_ Tile_X0Y1_IHP_BRAM_bot.Inst_IHP_BRAM_bot_ConfigMem.Inst_frame8_bit31.Q
+ VGND sg13g2_inv_1
XFILLER_2_214 VPWR VGND sg13g2_fill_2
XFILLER_92_55 VPWR VGND sg13g2_fill_1
X_0690_ Tile_X0Y0_IHP_BRAM_top.Inst_IHP_BRAM_top_ConfigMem.Inst_frame8_bit3.Q _0162_
+ _0163_ VPWR VGND sg13g2_nor2_1
X_1311_ Tile_X0Y0_FrameData[12] Tile_X0Y1_FrameStrobe[8] Tile_X0Y0_IHP_BRAM_top.Inst_IHP_BRAM_top_ConfigMem.Inst_frame8_bit12.Q
+ VPWR VGND sg13g2_dlhq_1
X_1173_ Tile_X0Y0_FrameData[22] Tile_X0Y1_FrameStrobe[4] Tile_X0Y0_IHP_BRAM_top.Inst_IHP_BRAM_top_ConfigMem.Inst_frame4_bit22.Q
+ VPWR VGND sg13g2_dlhq_1
X_1242_ Tile_X0Y0_FrameData[17] Tile_X0Y1_FrameStrobe[6] Tile_X0Y0_IHP_BRAM_top.Inst_IHP_BRAM_top_ConfigMem.Inst_frame6_bit17.Q
+ VPWR VGND sg13g2_dlhq_1
XANTENNA_14 VPWR VGND Tile_X0Y1_FrameStrobe[15] sg13g2_antennanp
XANTENNA_25 VPWR VGND Tile_X0Y1_N2MID[7] sg13g2_antennanp
XANTENNA_36 VPWR VGND Tile_X0Y1_N4END[4] sg13g2_antennanp
XANTENNA_47 VPWR VGND Tile_X0Y1_N4END[4] sg13g2_antennanp
XFILLER_32_140 VPWR VGND sg13g2_fill_2
Xoutput143 net143 Tile_X0Y0_FrameStrobe_O[8] VPWR VGND sg13g2_buf_1
Xoutput132 net132 Tile_X0Y0_FrameStrobe_O[16] VPWR VGND sg13g2_buf_1
Xoutput110 net110 Tile_X0Y0_FrameData_O[25] VPWR VGND sg13g2_buf_1
XANTENNA_58 VPWR VGND Tile_X0Y1_N4END[5] sg13g2_antennanp
XANTENNA_69 VPWR VGND Tile_X0Y1_N4END[5] sg13g2_antennanp
Xoutput121 net121 Tile_X0Y0_FrameData_O[6] VPWR VGND sg13g2_buf_1
X_0957_ Tile_X0Y1_IHP_BRAM_bot.Inst_IHP_BRAM_bot_ConfigMem.Inst_frame8_bit29.Q VPWR
+ _0304_ VGND Tile_X0Y1_E6END[4] Tile_X0Y1_IHP_BRAM_bot.Inst_IHP_BRAM_bot_ConfigMem.Inst_frame8_bit28.Q
+ sg13g2_o21ai_1
X_0888_ _0255_ VPWR net49 VGND Tile_X0Y1_IHP_BRAM_bot.Inst_IHP_BRAM_bot_ConfigMem.Inst_frame2_bit3.Q
+ _0257_ sg13g2_o21ai_1
Xoutput154 net154 Tile_X0Y0_N2BEG[5] VPWR VGND sg13g2_buf_1
Xoutput176 net176 Tile_X0Y0_N4BEG[5] VPWR VGND sg13g2_buf_1
Xoutput165 net165 Tile_X0Y0_N4BEG[0] VPWR VGND sg13g2_buf_1
Xoutput198 net198 Tile_X0Y0_W2BEGb[4] VPWR VGND sg13g2_buf_1
Xoutput187 net187 Tile_X0Y0_W2BEG[1] VPWR VGND sg13g2_buf_1
X_1509_ Tile_X0Y1_FrameData[6] Tile_X0Y1_FrameStrobe[4] Tile_X0Y1_IHP_BRAM_bot.Inst_IHP_BRAM_bot_ConfigMem.Inst_frame4_bit6.Q
+ VPWR VGND sg13g2_dlhq_1
XFILLER_87_66 VPWR VGND sg13g2_decap_4
XFILLER_46_210 VPWR VGND sg13g2_fill_2
X_1860_ Tile_X0Y1_IHP_BRAM_bot.Inst_IHP_BRAM_bot_switch_matrix.S2BEG5 net271 VPWR
+ VGND sg13g2_buf_1
X_0673_ Tile_X0Y0_IHP_BRAM_top.Inst_IHP_BRAM_top_ConfigMem.Inst_frame9_bit28.Q Tile_X0Y0_E1END[1]
+ Tile_X0Y0_E6END[9] Tile_X0Y0_EE4END[1] Tile_X0Y0_IHP_BRAM_top.Inst_IHP_BRAM_top_switch_matrix.J_NS4_BEG1
+ Tile_X0Y0_IHP_BRAM_top.Inst_IHP_BRAM_top_ConfigMem.Inst_frame9_bit27.Q _0148_ VPWR
+ VGND sg13g2_mux4_1
X_1791_ Tile_X0Y0_IHP_BRAM_top.Inst_IHP_BRAM_top_switch_matrix.W6BEG0 net202 VPWR
+ VGND sg13g2_buf_1
X_0742_ VGND VPWR _0002_ Tile_X0Y0_IHP_BRAM_top.Inst_IHP_BRAM_top_ConfigMem.Inst_frame2_bit29.Q
+ _0206_ Tile_X0Y0_IHP_BRAM_top.Inst_IHP_BRAM_top_ConfigMem.Inst_frame2_bit30.Q sg13g2_a21oi_1
X_0811_ Tile_X0Y1_IHP_BRAM_bot.Inst_IHP_BRAM_bot_ConfigMem.Inst_frame1_bit24.Q Tile_X0Y1_N1END[0]
+ Tile_X0Y1_N4END[0] _0111_ Tile_X0Y0_S4END[4] Tile_X0Y1_IHP_BRAM_bot.Inst_IHP_BRAM_bot_ConfigMem.Inst_frame1_bit25.Q
+ Tile_X0Y1_IHP_BRAM_bot.Inst_IHP_BRAM_bot_switch_matrix.J_NS4_BEG8 VPWR VGND sg13g2_mux4_1
XFILLER_96_110 VPWR VGND sg13g2_fill_2
X_1087_ Tile_X0Y0_FrameData[12] Tile_X0Y1_FrameStrobe[1] Tile_X0Y0_IHP_BRAM_top.Inst_IHP_BRAM_top_ConfigMem.Inst_frame1_bit12.Q
+ VPWR VGND sg13g2_dlhq_1
X_1156_ Tile_X0Y0_FrameData[7] Tile_X0Y1_FrameStrobe[3] Tile_X0Y0_IHP_BRAM_top.Inst_IHP_BRAM_top_ConfigMem.Inst_frame3_bit7.Q
+ VPWR VGND sg13g2_dlhq_1
X_1225_ Tile_X0Y0_FrameData[2] Tile_X0Y1_FrameStrobe[5] Tile_X0Y0_IHP_BRAM_top.Inst_IHP_BRAM_top_ConfigMem.Inst_frame5_bit2.Q
+ VPWR VGND sg13g2_dlhq_1
XFILLER_57_58 VPWR VGND sg13g2_fill_2
XFILLER_98_76 VPWR VGND sg13g2_fill_2
XFILLER_78_143 VPWR VGND sg13g2_fill_1
X_1010_ Tile_X0Y1_E2MID[0] Tile_X0Y1_IHP_BRAM_bot.Inst_IHP_BRAM_bot_ConfigMem.Inst_frame3_bit18.Q
+ _0353_ VPWR VGND sg13g2_and2_1
X_1912_ Tile_X0Y1_IHP_BRAM_bot.Inst_IHP_BRAM_bot_switch_matrix.W6BEG5 net325 VPWR
+ VGND sg13g2_buf_1
X_1843_ Tile_X0Y1_FrameData[24] net246 VPWR VGND sg13g2_buf_1
X_1774_ Tile_X0Y0_IHP_BRAM_top.Inst_IHP_BRAM_top_switch_matrix.W1BEG3 net185 VPWR
+ VGND sg13g2_buf_1
X_0656_ VPWR VGND Tile_X0Y0_IHP_BRAM_top.Inst_IHP_BRAM_top_ConfigMem.Inst_frame2_bit24.Q
+ _0132_ _0133_ Tile_X0Y0_IHP_BRAM_top.Inst_IHP_BRAM_top_ConfigMem.Inst_frame2_bit25.Q
+ net55 _0044_ sg13g2_a221oi_1
XFILLER_6_191 VPWR VGND sg13g2_fill_1
XFILLER_40_0 VPWR VGND sg13g2_fill_1
X_0725_ Tile_X0Y1_IHP_BRAM_bot.Inst_IHP_BRAM_bot_ConfigMem.Inst_frame0_bit2.Q Tile_X0Y1_N1END[1]
+ Tile_X0Y1_N4END[1] _0081_ Tile_X0Y0_S4END[5] Tile_X0Y1_IHP_BRAM_bot.Inst_IHP_BRAM_bot_ConfigMem.Inst_frame0_bit3.Q
+ Tile_X0Y1_IHP_BRAM_bot.Inst_IHP_BRAM_bot_switch_matrix.J_NS4_BEG13 VPWR VGND sg13g2_mux4_1
X_1208_ Tile_X0Y0_FrameData[19] Tile_X0Y1_FrameStrobe[5] Tile_X0Y0_IHP_BRAM_top.Inst_IHP_BRAM_top_ConfigMem.Inst_frame5_bit19.Q
+ VPWR VGND sg13g2_dlhq_1
X_0587_ Tile_X0Y0_IHP_BRAM_top.Inst_IHP_BRAM_top_ConfigMem.Inst_frame5_bit18.Q Tile_X0Y1_N4END[5]
+ Tile_X0Y0_S4END[1] Tile_X0Y0_IHP_BRAM_top.Inst_IHP_BRAM_top_switch_matrix.J_NS4_BEG10
+ Tile_X0Y0_IHP_BRAM_top.Inst_IHP_BRAM_top_switch_matrix.J_NS4_BEG14 Tile_X0Y0_IHP_BRAM_top.Inst_IHP_BRAM_top_ConfigMem.Inst_frame5_bit19.Q
+ Tile_X0Y0_IHP_BRAM_top.Inst_IHP_BRAM_top_switch_matrix.W6BEG1 VPWR VGND sg13g2_mux4_1
XFILLER_84_102 VPWR VGND sg13g2_decap_4
X_1139_ Tile_X0Y0_FrameData[24] Tile_X0Y1_FrameStrobe[3] Tile_X0Y0_IHP_BRAM_top.Inst_IHP_BRAM_top_ConfigMem.Inst_frame3_bit24.Q
+ VPWR VGND sg13g2_dlhq_1
XFILLER_25_213 VPWR VGND sg13g2_fill_2
XFILLER_43_38 VPWR VGND sg13g2_fill_2
XFILLER_33_60 VPWR VGND sg13g2_fill_1
X_0510_ Tile_X0Y0_IHP_BRAM_top.Inst_IHP_BRAM_top_ConfigMem.Inst_frame0_bit15.Q Tile_X0Y0_IHP_BRAM_top.Inst_IHP_BRAM_top_switch_matrix.N2BEGb3
+ Tile_X0Y0_S2MID[3] Tile_X0Y1_N2MID[3] Tile_X0Y0_S2END[3] Tile_X0Y0_IHP_BRAM_top.Inst_IHP_BRAM_top_ConfigMem.Inst_frame0_bit14.Q
+ Tile_X0Y0_IHP_BRAM_top.Inst_IHP_BRAM_top_switch_matrix.J_NS2_BEG3 VPWR VGND sg13g2_mux4_1
X_1490_ Tile_X0Y1_FrameData[25] Tile_X0Y1_FrameStrobe[4] Tile_X0Y1_IHP_BRAM_bot.Inst_IHP_BRAM_bot_ConfigMem.Inst_frame4_bit25.Q
+ VPWR VGND sg13g2_dlhq_1
X_0441_ _0060_ VPWR _0061_ VGND Tile_X0Y0_IHP_BRAM_top.Inst_IHP_BRAM_top_ConfigMem.Inst_frame1_bit1.Q
+ Tile_X0Y0_E2END[3] sg13g2_o21ai_1
XFILLER_81_138 VPWR VGND sg13g2_decap_8
XFILLER_88_0 VPWR VGND sg13g2_decap_8
X_1826_ Tile_X0Y1_FrameData[7] net259 VPWR VGND sg13g2_buf_1
X_0639_ Tile_X0Y0_IHP_BRAM_top.Inst_IHP_BRAM_top_ConfigMem.Inst_frame2_bit6.Q Tile_X0Y0_EE4END[2]
+ Tile_X0Y0_EE4END[10] Tile_X0Y0_E6END[10] Tile_X0Y0_IHP_BRAM_top.Inst_IHP_BRAM_top_switch_matrix.J_NS4_BEG10
+ Tile_X0Y0_IHP_BRAM_top.Inst_IHP_BRAM_top_ConfigMem.Inst_frame2_bit7.Q net59 VPWR
+ VGND sg13g2_mux4_1
X_0708_ Tile_X0Y0_IHP_BRAM_top.Inst_IHP_BRAM_top_switch_matrix.J_NS4_BEG6 Tile_X0Y0_IHP_BRAM_top.Inst_IHP_BRAM_top_switch_matrix.J_NS4_BEG10
+ Tile_X0Y0_IHP_BRAM_top.Inst_IHP_BRAM_top_ConfigMem.Inst_frame7_bit2.Q _0178_ VPWR
+ VGND sg13g2_mux2_1
X_1688_ Tile_X0Y0_FrameData[6] net121 VPWR VGND sg13g2_buf_1
X_1757_ Tile_X0Y1_N4END[11] net174 VPWR VGND sg13g2_buf_1
XFILLER_63_105 VPWR VGND sg13g2_decap_8
X_0990_ Tile_X0Y1_IHP_BRAM_bot.Inst_IHP_BRAM_bot_ConfigMem.Inst_frame7_bit6.Q VPWR
+ _0334_ VGND Tile_X0Y1_E6END[7] Tile_X0Y1_IHP_BRAM_bot.Inst_IHP_BRAM_bot_ConfigMem.Inst_frame7_bit5.Q
+ sg13g2_o21ai_1
X_1611_ Tile_X0Y1_FrameData[0] Tile_X0Y1_FrameStrobe[7] Tile_X0Y1_IHP_BRAM_bot.Inst_IHP_BRAM_bot_ConfigMem.Inst_frame7_bit0.Q
+ VPWR VGND sg13g2_dlhq_1
XFILLER_5_42 VPWR VGND sg13g2_fill_2
XFILLER_5_20 VPWR VGND sg13g2_fill_1
X_1473_ Tile_X0Y1_FrameData[10] Tile_X0Y1_FrameStrobe[3] Tile_X0Y1_IHP_BRAM_bot.Inst_IHP_BRAM_bot_ConfigMem.Inst_frame3_bit10.Q
+ VPWR VGND sg13g2_dlhq_1
X_1542_ Tile_X0Y1_FrameData[5] Tile_X0Y1_FrameStrobe[5] Tile_X0Y1_IHP_BRAM_bot.Inst_IHP_BRAM_bot_ConfigMem.Inst_frame5_bit5.Q
+ VPWR VGND sg13g2_dlhq_1
X_0424_ Tile_X0Y1_IHP_BRAM_bot.Inst_IHP_BRAM_bot_ConfigMem.Inst_frame0_bit20.Q Tile_X0Y1_N2MID[6]
+ Tile_X0Y1_N2END[6] Tile_X0Y0_IHP_BRAM_top.Inst_IHP_BRAM_top_switch_matrix.S2BEG6
+ Tile_X0Y0_S2MID[6] Tile_X0Y1_IHP_BRAM_bot.Inst_IHP_BRAM_bot_ConfigMem.Inst_frame0_bit21.Q
+ _0046_ VPWR VGND sg13g2_mux4_1
X_1809_ Tile_X0Y0_IHP_BRAM_top.Inst_IHP_BRAM_top_switch_matrix.WW4BEG6 net226 VPWR
+ VGND sg13g2_buf_1
XFILLER_38_190 VPWR VGND sg13g2_fill_1
XFILLER_45_116 VPWR VGND sg13g2_fill_1
XFILLER_39_9 VPWR VGND sg13g2_fill_1
Xoutput325 net325 Tile_X0Y1_W6BEG[5] VPWR VGND sg13g2_buf_1
Xoutput314 net314 Tile_X0Y1_W2BEGb[4] VPWR VGND sg13g2_buf_1
Xoutput303 net303 Tile_X0Y1_W2BEG[1] VPWR VGND sg13g2_buf_1
X_0973_ _0031_ _0106_ _0319_ VPWR VGND sg13g2_nor2_1
Xoutput336 net336 Tile_X0Y1_WW4BEG[15] VPWR VGND sg13g2_buf_1
X_1387_ Tile_X0Y1_FrameData[0] Tile_X0Y1_FrameStrobe[0] Tile_X0Y1_IHP_BRAM_bot.Inst_IHP_BRAM_bot_ConfigMem.Inst_frame0_bit0.Q
+ VPWR VGND sg13g2_dlhq_1
X_1525_ Tile_X0Y1_FrameData[22] Tile_X0Y1_FrameStrobe[5] Tile_X0Y1_IHP_BRAM_bot.Inst_IHP_BRAM_bot_ConfigMem.Inst_frame5_bit22.Q
+ VPWR VGND sg13g2_dlhq_1
X_0407_ VPWR _0030_ Tile_X0Y1_IHP_BRAM_bot.Inst_IHP_BRAM_bot_ConfigMem.Inst_frame8_bit29.Q
+ VGND sg13g2_inv_1
X_1456_ Tile_X0Y1_FrameData[27] Tile_X0Y1_FrameStrobe[3] Tile_X0Y1_IHP_BRAM_bot.Inst_IHP_BRAM_bot_ConfigMem.Inst_frame3_bit27.Q
+ VPWR VGND sg13g2_dlhq_1
XFILLER_42_108 VPWR VGND sg13g2_decap_4
XFILLER_73_211 VPWR VGND sg13g2_fill_1
XFILLER_26_193 VPWR VGND sg13g2_fill_2
XFILLER_41_82 VPWR VGND sg13g2_fill_2
X_1310_ Tile_X0Y0_FrameData[13] Tile_X0Y1_FrameStrobe[8] Tile_X0Y0_IHP_BRAM_top.Inst_IHP_BRAM_top_ConfigMem.Inst_frame8_bit13.Q
+ VPWR VGND sg13g2_dlhq_1
X_1241_ Tile_X0Y0_FrameData[18] Tile_X0Y1_FrameStrobe[6] Tile_X0Y0_IHP_BRAM_top.Inst_IHP_BRAM_top_ConfigMem.Inst_frame6_bit18.Q
+ VPWR VGND sg13g2_dlhq_1
XFILLER_44_7 VPWR VGND sg13g2_decap_8
X_1172_ Tile_X0Y0_FrameData[23] Tile_X0Y1_FrameStrobe[4] Tile_X0Y0_IHP_BRAM_top.Inst_IHP_BRAM_top_ConfigMem.Inst_frame4_bit23.Q
+ VPWR VGND sg13g2_dlhq_1
XANTENNA_15 VPWR VGND Tile_X0Y1_FrameStrobe[16] sg13g2_antennanp
XANTENNA_59 VPWR VGND Tile_X0Y1_N4END[5] sg13g2_antennanp
XANTENNA_48 VPWR VGND Tile_X0Y1_N4END[4] sg13g2_antennanp
XANTENNA_37 VPWR VGND Tile_X0Y1_N4END[4] sg13g2_antennanp
XANTENNA_26 VPWR VGND Tile_X0Y1_N2MID[7] sg13g2_antennanp
X_0956_ VGND VPWR _0296_ _0298_ Tile_X0Y0_IHP_BRAM_top.N4BEG_outbuf_11.A _0303_ sg13g2_a21oi_1
Xoutput155 net155 Tile_X0Y0_N2BEG[6] VPWR VGND sg13g2_buf_1
Xoutput133 net133 Tile_X0Y0_FrameStrobe_O[17] VPWR VGND sg13g2_buf_1
Xoutput144 net144 Tile_X0Y0_FrameStrobe_O[9] VPWR VGND sg13g2_buf_1
Xoutput111 net111 Tile_X0Y0_FrameData_O[26] VPWR VGND sg13g2_buf_1
Xoutput166 net166 Tile_X0Y0_N4BEG[10] VPWR VGND sg13g2_buf_1
XFILLER_99_152 VPWR VGND sg13g2_decap_8
Xoutput177 net177 Tile_X0Y0_N4BEG[6] VPWR VGND sg13g2_buf_1
Xoutput100 net100 Tile_X0Y0_FrameData_O[16] VPWR VGND sg13g2_buf_1
Xoutput122 net122 Tile_X0Y0_FrameData_O[7] VPWR VGND sg13g2_buf_1
X_0887_ VGND VPWR Tile_X0Y1_E2END[2] Tile_X0Y1_IHP_BRAM_bot.Inst_IHP_BRAM_bot_ConfigMem.Inst_frame2_bit2.Q
+ _0257_ _0256_ sg13g2_a21oi_1
Xoutput199 net199 Tile_X0Y0_W2BEGb[5] VPWR VGND sg13g2_buf_1
Xoutput188 net188 Tile_X0Y0_W2BEG[2] VPWR VGND sg13g2_buf_1
X_1508_ Tile_X0Y1_FrameData[7] Tile_X0Y1_FrameStrobe[4] Tile_X0Y1_IHP_BRAM_bot.Inst_IHP_BRAM_bot_ConfigMem.Inst_frame4_bit7.Q
+ VPWR VGND sg13g2_dlhq_1
X_1439_ Tile_X0Y1_FrameData[12] Tile_X0Y1_FrameStrobe[2] Tile_X0Y1_IHP_BRAM_bot.Inst_IHP_BRAM_bot_ConfigMem.Inst_frame2_bit12.Q
+ VPWR VGND sg13g2_dlhq_1
XFILLER_102_77 VPWR VGND sg13g2_fill_1
X_1790_ Tile_X0Y0_IHP_BRAM_top.Inst_IHP_BRAM_top_switch_matrix.W2BEGb7 net201 VPWR
+ VGND sg13g2_buf_1
X_0810_ Tile_X0Y1_IHP_BRAM_bot.Inst_IHP_BRAM_bot_ConfigMem.Inst_frame6_bit28.Q A_DOUT_BRAM6
+ B_DOUT_BRAM2 Tile_X0Y1_IHP_BRAM_bot.Inst_IHP_BRAM_bot_switch_matrix.J_NS4_BEG9 _0102_
+ Tile_X0Y1_IHP_BRAM_bot.Inst_IHP_BRAM_bot_ConfigMem.Inst_frame6_bit29.Q Tile_X0Y1_IHP_BRAM_bot.Inst_IHP_BRAM_bot_switch_matrix.WW4BEG6
+ VPWR VGND sg13g2_mux4_1
X_0672_ VGND VPWR _0012_ _0143_ _0147_ _0146_ sg13g2_a21oi_1
X_0741_ VGND VPWR _0203_ _0204_ _0205_ _0019_ sg13g2_a21oi_1
X_1224_ Tile_X0Y0_FrameData[3] Tile_X0Y1_FrameStrobe[5] Tile_X0Y0_IHP_BRAM_top.Inst_IHP_BRAM_top_ConfigMem.Inst_frame5_bit3.Q
+ VPWR VGND sg13g2_dlhq_1
XFILLER_37_211 VPWR VGND sg13g2_fill_1
X_1086_ Tile_X0Y0_FrameData[13] Tile_X0Y1_FrameStrobe[1] Tile_X0Y0_IHP_BRAM_top.Inst_IHP_BRAM_top_ConfigMem.Inst_frame1_bit13.Q
+ VPWR VGND sg13g2_dlhq_1
X_1155_ Tile_X0Y0_FrameData[8] Tile_X0Y1_FrameStrobe[3] Tile_X0Y0_IHP_BRAM_top.Inst_IHP_BRAM_top_ConfigMem.Inst_frame3_bit8.Q
+ VPWR VGND sg13g2_dlhq_1
XFILLER_32_18 VPWR VGND sg13g2_decap_4
X_0939_ VGND VPWR _0026_ _0287_ _0288_ Tile_X0Y1_IHP_BRAM_bot.Inst_IHP_BRAM_bot_ConfigMem.Inst_frame8_bit0.Q
+ sg13g2_a21oi_1
XFILLER_87_122 VPWR VGND sg13g2_fill_1
XFILLER_87_166 VPWR VGND sg13g2_decap_4
XFILLER_73_58 VPWR VGND sg13g2_decap_8
XFILLER_22_40 VPWR VGND sg13g2_fill_1
XFILLER_78_111 VPWR VGND sg13g2_decap_8
XFILLER_0_0 VPWR VGND sg13g2_fill_2
X_1911_ Tile_X0Y1_IHP_BRAM_bot.Inst_IHP_BRAM_bot_switch_matrix.W6BEG4 net324 VPWR
+ VGND sg13g2_buf_1
X_1842_ Tile_X0Y1_FrameData[23] net245 VPWR VGND sg13g2_buf_1
X_1773_ Tile_X0Y0_IHP_BRAM_top.Inst_IHP_BRAM_top_switch_matrix.W1BEG2 net184 VPWR
+ VGND sg13g2_buf_1
X_0586_ Tile_X0Y0_IHP_BRAM_top.Inst_IHP_BRAM_top_ConfigMem.Inst_frame5_bit16.Q Tile_X0Y1_N4END[4]
+ Tile_X0Y0_S4END[0] Tile_X0Y0_IHP_BRAM_top.Inst_IHP_BRAM_top_switch_matrix.J_NS4_BEG11
+ Tile_X0Y0_IHP_BRAM_top.Inst_IHP_BRAM_top_switch_matrix.J_NS4_BEG15 Tile_X0Y0_IHP_BRAM_top.Inst_IHP_BRAM_top_ConfigMem.Inst_frame5_bit17.Q
+ Tile_X0Y0_IHP_BRAM_top.Inst_IHP_BRAM_top_switch_matrix.W6BEG0 VPWR VGND sg13g2_mux4_1
X_0655_ _0133_ Tile_X0Y0_E2END[3] Tile_X0Y0_IHP_BRAM_top.Inst_IHP_BRAM_top_ConfigMem.Inst_frame2_bit25.Q
+ VPWR VGND sg13g2_nand2b_1
X_0724_ Tile_X0Y1_IHP_BRAM_bot.Inst_IHP_BRAM_bot_ConfigMem.Inst_frame0_bit0.Q Tile_X0Y1_N1END[0]
+ Tile_X0Y1_N4END[0] _0111_ Tile_X0Y0_S4END[4] Tile_X0Y1_IHP_BRAM_bot.Inst_IHP_BRAM_bot_ConfigMem.Inst_frame0_bit1.Q
+ Tile_X0Y1_IHP_BRAM_bot.Inst_IHP_BRAM_bot_switch_matrix.J_NS4_BEG12 VPWR VGND sg13g2_mux4_1
XFILLER_33_0 VPWR VGND sg13g2_decap_4
X_1207_ Tile_X0Y0_FrameData[20] Tile_X0Y1_FrameStrobe[5] Tile_X0Y0_IHP_BRAM_top.Inst_IHP_BRAM_top_ConfigMem.Inst_frame5_bit20.Q
+ VPWR VGND sg13g2_dlhq_1
X_1069_ Tile_X0Y0_FrameData[30] Tile_X0Y1_FrameStrobe[1] Tile_X0Y0_IHP_BRAM_top.Inst_IHP_BRAM_top_ConfigMem.Inst_frame1_bit30.Q
+ VPWR VGND sg13g2_dlhq_1
X_1138_ Tile_X0Y0_FrameData[25] Tile_X0Y1_FrameStrobe[3] Tile_X0Y0_IHP_BRAM_top.Inst_IHP_BRAM_top_ConfigMem.Inst_frame3_bit25.Q
+ VPWR VGND sg13g2_dlhq_1
X_0440_ VGND VPWR Tile_X0Y0_IHP_BRAM_top.Inst_IHP_BRAM_top_ConfigMem.Inst_frame1_bit1.Q
+ _0002_ _0060_ Tile_X0Y0_IHP_BRAM_top.Inst_IHP_BRAM_top_ConfigMem.Inst_frame1_bit2.Q
+ sg13g2_a21oi_1
XFILLER_74_191 VPWR VGND sg13g2_decap_4
XFILLER_74_90 VPWR VGND sg13g2_decap_8
X_0707_ _0175_ _0177_ Tile_X0Y0_IHP_BRAM_top.Inst_IHP_BRAM_top_switch_matrix.S4BEG1
+ VPWR VGND sg13g2_nor2_1
X_1756_ Tile_X0Y1_N4END[10] net173 VPWR VGND sg13g2_buf_1
X_1825_ Tile_X0Y1_FrameData[6] net258 VPWR VGND sg13g2_buf_1
X_0638_ Tile_X0Y0_IHP_BRAM_top.Inst_IHP_BRAM_top_ConfigMem.Inst_frame2_bit4.Q Tile_X0Y0_EE4END[1]
+ Tile_X0Y0_EE4END[9] Tile_X0Y0_E6END[9] Tile_X0Y0_IHP_BRAM_top.Inst_IHP_BRAM_top_switch_matrix.J_NS4_BEG9
+ Tile_X0Y0_IHP_BRAM_top.Inst_IHP_BRAM_top_ConfigMem.Inst_frame2_bit5.Q net72 VPWR
+ VGND sg13g2_mux4_1
X_1687_ Tile_X0Y0_FrameData[5] net120 VPWR VGND sg13g2_buf_1
X_0569_ Tile_X0Y0_IHP_BRAM_top.Inst_IHP_BRAM_top_ConfigMem.Inst_frame6_bit30.Q A_DOUT_BRAM15
+ B_DOUT_BRAM11 Tile_X0Y0_IHP_BRAM_top.Inst_IHP_BRAM_top_switch_matrix.J_NS4_BEG8
+ Tile_X0Y0_IHP_BRAM_top.Inst_IHP_BRAM_top_switch_matrix.J_NS2_BEG0 Tile_X0Y0_IHP_BRAM_top.Inst_IHP_BRAM_top_ConfigMem.Inst_frame6_bit31.Q
+ Tile_X0Y0_IHP_BRAM_top.Inst_IHP_BRAM_top_switch_matrix.WW4BEG7 VPWR VGND sg13g2_mux4_1
XFILLER_54_38 VPWR VGND sg13g2_fill_1
XFILLER_95_209 VPWR VGND sg13g2_fill_1
XFILLER_0_165 VPWR VGND sg13g2_fill_1
XFILLER_48_158 VPWR VGND sg13g2_fill_1
XFILLER_63_139 VPWR VGND sg13g2_fill_1
X_1610_ Tile_X0Y1_FrameData[1] Tile_X0Y1_FrameStrobe[7] Tile_X0Y1_IHP_BRAM_bot.Inst_IHP_BRAM_bot_ConfigMem.Inst_frame7_bit1.Q
+ VPWR VGND sg13g2_dlhq_1
X_0423_ Tile_X0Y0_IHP_BRAM_top.Inst_IHP_BRAM_top_ConfigMem.Inst_frame8_bit24.Q Tile_X0Y0_E1END[2]
+ Tile_X0Y0_E2MID[1] Tile_X0Y0_E2END[1] Tile_X0Y0_IHP_BRAM_top.Inst_IHP_BRAM_top_switch_matrix.J_NS2_BEG6
+ Tile_X0Y0_IHP_BRAM_top.Inst_IHP_BRAM_top_ConfigMem.Inst_frame8_bit25.Q Tile_X0Y0_IHP_BRAM_top.Inst_IHP_BRAM_top_switch_matrix.S2BEG6
+ VPWR VGND sg13g2_mux4_1
X_1541_ Tile_X0Y1_FrameData[6] Tile_X0Y1_FrameStrobe[5] Tile_X0Y1_IHP_BRAM_bot.Inst_IHP_BRAM_bot_ConfigMem.Inst_frame5_bit6.Q
+ VPWR VGND sg13g2_dlhq_1
X_1472_ Tile_X0Y1_FrameData[11] Tile_X0Y1_FrameStrobe[3] Tile_X0Y1_IHP_BRAM_bot.Inst_IHP_BRAM_bot_ConfigMem.Inst_frame3_bit11.Q
+ VPWR VGND sg13g2_dlhq_1
X_1739_ Tile_X0Y0_IHP_BRAM_top.Inst_IHP_BRAM_top_switch_matrix.N2BEG1 net150 VPWR
+ VGND sg13g2_buf_1
X_1808_ Tile_X0Y0_IHP_BRAM_top.Inst_IHP_BRAM_top_switch_matrix.WW4BEG5 net225 VPWR
+ VGND sg13g2_buf_1
XFILLER_105_88 VPWR VGND sg13g2_fill_1
XFILLER_49_49 VPWR VGND sg13g2_fill_1
XFILLER_53_150 VPWR VGND sg13g2_decap_4
XFILLER_107_163 VPWR VGND sg13g2_decap_8
XFILLER_100_0 VPWR VGND sg13g2_fill_2
XFILLER_36_106 VPWR VGND sg13g2_fill_2
X_0972_ VGND VPWR _0032_ _0317_ _0318_ Tile_X0Y1_IHP_BRAM_bot.Inst_IHP_BRAM_bot_ConfigMem.Inst_frame7_bit1.Q
+ sg13g2_a21oi_1
X_1524_ Tile_X0Y1_FrameData[23] Tile_X0Y1_FrameStrobe[5] Tile_X0Y1_IHP_BRAM_bot.Inst_IHP_BRAM_bot_ConfigMem.Inst_frame5_bit23.Q
+ VPWR VGND sg13g2_dlhq_1
Xoutput315 net315 Tile_X0Y1_W2BEGb[5] VPWR VGND sg13g2_buf_1
Xoutput326 net326 Tile_X0Y1_W6BEG[6] VPWR VGND sg13g2_buf_1
Xoutput337 net337 Tile_X0Y1_WW4BEG[1] VPWR VGND sg13g2_buf_1
Xoutput304 net304 Tile_X0Y1_W2BEG[2] VPWR VGND sg13g2_buf_1
X_1386_ Tile_X0Y1_FrameData[1] Tile_X0Y1_FrameStrobe[0] Tile_X0Y1_IHP_BRAM_bot.Inst_IHP_BRAM_bot_ConfigMem.Inst_frame0_bit1.Q
+ VPWR VGND sg13g2_dlhq_1
X_0406_ VPWR _0029_ Tile_X0Y1_IHP_BRAM_bot.Inst_IHP_BRAM_bot_ConfigMem.Inst_frame8_bit28.Q
+ VGND sg13g2_inv_1
X_1455_ Tile_X0Y1_FrameData[28] Tile_X0Y1_FrameStrobe[3] Tile_X0Y1_IHP_BRAM_bot.Inst_IHP_BRAM_bot_ConfigMem.Inst_frame3_bit28.Q
+ VPWR VGND sg13g2_dlhq_1
XFILLER_35_183 VPWR VGND sg13g2_fill_1
XFILLER_25_40 VPWR VGND sg13g2_fill_1
XFILLER_41_120 VPWR VGND sg13g2_decap_8
X_1171_ Tile_X0Y0_FrameData[24] Tile_X0Y1_FrameStrobe[4] Tile_X0Y0_IHP_BRAM_top.Inst_IHP_BRAM_top_ConfigMem.Inst_frame4_bit24.Q
+ VPWR VGND sg13g2_dlhq_1
X_1240_ Tile_X0Y0_FrameData[19] Tile_X0Y1_FrameStrobe[6] Tile_X0Y0_IHP_BRAM_top.Inst_IHP_BRAM_top_ConfigMem.Inst_frame6_bit19.Q
+ VPWR VGND sg13g2_dlhq_1
XFILLER_37_7 VPWR VGND sg13g2_fill_1
XANTENNA_16 VPWR VGND Tile_X0Y1_FrameStrobe[17] sg13g2_antennanp
XANTENNA_27 VPWR VGND Tile_X0Y1_N2MID[7] sg13g2_antennanp
XANTENNA_49 VPWR VGND Tile_X0Y1_N4END[4] sg13g2_antennanp
XANTENNA_38 VPWR VGND Tile_X0Y1_N4END[4] sg13g2_antennanp
X_0886_ Tile_X0Y1_IHP_BRAM_bot.Inst_IHP_BRAM_bot_ConfigMem.Inst_frame2_bit2.Q Tile_X0Y1_E2MID[2]
+ _0256_ VPWR VGND sg13g2_nor2b_1
XFILLER_32_142 VPWR VGND sg13g2_fill_1
X_0955_ VGND VPWR _0028_ _0301_ _0303_ _0302_ sg13g2_a21oi_1
Xoutput112 net112 Tile_X0Y0_FrameData_O[27] VPWR VGND sg13g2_buf_1
Xoutput134 net134 Tile_X0Y0_FrameStrobe_O[18] VPWR VGND sg13g2_buf_1
Xoutput167 net167 Tile_X0Y0_N4BEG[11] VPWR VGND sg13g2_buf_1
Xoutput101 net101 Tile_X0Y0_FrameData_O[17] VPWR VGND sg13g2_buf_1
Xoutput178 net178 Tile_X0Y0_N4BEG[7] VPWR VGND sg13g2_buf_1
Xoutput145 net145 Tile_X0Y0_N1BEG[0] VPWR VGND sg13g2_buf_1
Xoutput156 net156 Tile_X0Y0_N2BEG[7] VPWR VGND sg13g2_buf_1
Xoutput123 net123 Tile_X0Y0_FrameData_O[8] VPWR VGND sg13g2_buf_1
Xoutput189 net189 Tile_X0Y0_W2BEG[3] VPWR VGND sg13g2_buf_1
X_1507_ Tile_X0Y1_FrameData[8] Tile_X0Y1_FrameStrobe[4] Tile_X0Y1_IHP_BRAM_bot.Inst_IHP_BRAM_bot_ConfigMem.Inst_frame4_bit8.Q
+ VPWR VGND sg13g2_dlhq_1
X_1438_ Tile_X0Y1_FrameData[13] Tile_X0Y1_FrameStrobe[2] Tile_X0Y1_IHP_BRAM_bot.Inst_IHP_BRAM_bot_ConfigMem.Inst_frame2_bit13.Q
+ VPWR VGND sg13g2_dlhq_1
X_1369_ Tile_X0Y1_FrameData[18] Tile_X0Y1_FrameStrobe[0] Tile_X0Y1_IHP_BRAM_bot.Inst_IHP_BRAM_bot_ConfigMem.Inst_frame0_bit18.Q
+ VPWR VGND sg13g2_dlhq_1
XFILLER_11_53 VPWR VGND sg13g2_fill_2
XFILLER_36_83 VPWR VGND sg13g2_decap_4
X_0740_ VGND VPWR Tile_X0Y0_S2MID[0] Tile_X0Y0_IHP_BRAM_top.Inst_IHP_BRAM_top_ConfigMem.Inst_frame2_bit29.Q
+ _0204_ _0202_ sg13g2_a21oi_1
X_0671_ Tile_X0Y0_IHP_BRAM_top.Inst_IHP_BRAM_top_ConfigMem.Inst_frame9_bit29.Q VPWR
+ _0146_ VGND _0144_ _0145_ sg13g2_o21ai_1
X_1223_ Tile_X0Y0_FrameData[4] Tile_X0Y1_FrameStrobe[5] Tile_X0Y0_IHP_BRAM_top.Inst_IHP_BRAM_top_ConfigMem.Inst_frame5_bit4.Q
+ VPWR VGND sg13g2_dlhq_1
XFILLER_77_90 VPWR VGND sg13g2_fill_2
X_1154_ Tile_X0Y0_FrameData[9] Tile_X0Y1_FrameStrobe[3] Tile_X0Y0_IHP_BRAM_top.Inst_IHP_BRAM_top_ConfigMem.Inst_frame3_bit9.Q
+ VPWR VGND sg13g2_dlhq_1
X_1085_ Tile_X0Y0_FrameData[14] Tile_X0Y1_FrameStrobe[1] Tile_X0Y0_IHP_BRAM_top.Inst_IHP_BRAM_top_ConfigMem.Inst_frame1_bit14.Q
+ VPWR VGND sg13g2_dlhq_1
X_0869_ Tile_X0Y1_IHP_BRAM_bot.Inst_IHP_BRAM_bot_ConfigMem.Inst_frame3_bit2.Q Tile_X0Y1_EE4END[0]
+ Tile_X0Y1_EE4END[8] Tile_X0Y1_E6END[0] _0233_ Tile_X0Y1_IHP_BRAM_bot.Inst_IHP_BRAM_bot_ConfigMem.Inst_frame3_bit3.Q
+ net11 VPWR VGND sg13g2_mux4_1
X_0938_ Tile_X0Y1_E1END[2] Tile_X0Y1_EE4END[2] Tile_X0Y1_IHP_BRAM_bot.Inst_IHP_BRAM_bot_ConfigMem.Inst_frame9_bit30.Q
+ _0287_ VPWR VGND sg13g2_mux2_1
XFILLER_43_215 VPWR VGND sg13g2_fill_1
XFILLER_11_101 VPWR VGND sg13g2_fill_1
XFILLER_22_96 VPWR VGND sg13g2_decap_8
XFILLER_97_6 VPWR VGND sg13g2_fill_1
X_1910_ Tile_X0Y1_IHP_BRAM_bot.Inst_IHP_BRAM_bot_switch_matrix.W6BEG3 net323 VPWR
+ VGND sg13g2_buf_1
X_0723_ _0189_ _0191_ Tile_X0Y0_IHP_BRAM_top.Inst_IHP_BRAM_top_switch_matrix.S4BEG3
+ VPWR VGND sg13g2_nor2_1
X_1841_ Tile_X0Y1_FrameData[22] net244 VPWR VGND sg13g2_buf_1
X_1772_ Tile_X0Y0_IHP_BRAM_top.Inst_IHP_BRAM_top_switch_matrix.W1BEG1 net183 VPWR
+ VGND sg13g2_buf_1
X_0585_ Tile_X0Y0_IHP_BRAM_top.Inst_IHP_BRAM_top_ConfigMem.Inst_frame5_bit14.Q A_DOUT_BRAM11
+ B_DOUT_BRAM15 Tile_X0Y0_IHP_BRAM_top.Inst_IHP_BRAM_top_switch_matrix.J_NS4_BEG0
+ Tile_X0Y0_IHP_BRAM_top.Inst_IHP_BRAM_top_switch_matrix.J_NS2_BEG0 Tile_X0Y0_IHP_BRAM_top.Inst_IHP_BRAM_top_ConfigMem.Inst_frame5_bit15.Q
+ Tile_X0Y0_IHP_BRAM_top.Inst_IHP_BRAM_top_switch_matrix.WW4BEG15 VPWR VGND sg13g2_mux4_1
XFILLER_69_123 VPWR VGND sg13g2_fill_2
X_0654_ Tile_X0Y0_E2MID[3] Tile_X0Y0_IHP_BRAM_top.Inst_IHP_BRAM_top_ConfigMem.Inst_frame2_bit24.Q
+ Tile_X0Y0_IHP_BRAM_top.Inst_IHP_BRAM_top_ConfigMem.Inst_frame2_bit25.Q _0132_ VPWR
+ VGND sg13g2_nor3_1
XFILLER_26_0 VPWR VGND sg13g2_fill_1
X_1206_ Tile_X0Y0_FrameData[21] Tile_X0Y1_FrameStrobe[5] Tile_X0Y0_IHP_BRAM_top.Inst_IHP_BRAM_top_ConfigMem.Inst_frame5_bit21.Q
+ VPWR VGND sg13g2_dlhq_1
X_1137_ Tile_X0Y0_FrameData[26] Tile_X0Y1_FrameStrobe[3] Tile_X0Y0_IHP_BRAM_top.Inst_IHP_BRAM_top_ConfigMem.Inst_frame3_bit26.Q
+ VPWR VGND sg13g2_dlhq_1
XFILLER_25_215 VPWR VGND sg13g2_fill_1
X_1068_ Tile_X0Y0_FrameData[31] Tile_X0Y1_FrameStrobe[1] Tile_X0Y0_IHP_BRAM_top.Inst_IHP_BRAM_top_ConfigMem.Inst_frame1_bit31.Q
+ VPWR VGND sg13g2_dlhq_1
XFILLER_43_18 VPWR VGND sg13g2_fill_2
XFILLER_84_36 VPWR VGND sg13g2_fill_1
XFILLER_84_25 VPWR VGND sg13g2_decap_8
XFILLER_3_196 VPWR VGND sg13g2_fill_2
X_0706_ Tile_X0Y0_IHP_BRAM_top.Inst_IHP_BRAM_top_ConfigMem.Inst_frame7_bit1.Q _0176_
+ _0177_ VPWR VGND sg13g2_nor2_1
X_1686_ Tile_X0Y0_FrameData[4] net119 VPWR VGND sg13g2_buf_1
X_1755_ Tile_X0Y1_N4END[9] net172 VPWR VGND sg13g2_buf_1
X_1824_ Tile_X0Y1_FrameData[5] net257 VPWR VGND sg13g2_buf_1
X_0568_ Tile_X0Y0_IHP_BRAM_top.Inst_IHP_BRAM_top_ConfigMem.Inst_frame1_bit24.Q Tile_X0Y0_IHP_BRAM_top.Inst_IHP_BRAM_top_switch_matrix.N1END0
+ Tile_X0Y1_N4END[4] Tile_X0Y0_S1END[0] Tile_X0Y0_S4END[0] Tile_X0Y0_IHP_BRAM_top.Inst_IHP_BRAM_top_ConfigMem.Inst_frame1_bit25.Q
+ Tile_X0Y0_IHP_BRAM_top.Inst_IHP_BRAM_top_switch_matrix.J_NS4_BEG8 VPWR VGND sg13g2_mux4_1
X_0637_ Tile_X0Y0_IHP_BRAM_top.Inst_IHP_BRAM_top_ConfigMem.Inst_frame2_bit2.Q Tile_X0Y0_EE4END[0]
+ Tile_X0Y0_EE4END[8] Tile_X0Y0_E6END[8] Tile_X0Y0_IHP_BRAM_top.Inst_IHP_BRAM_top_switch_matrix.J_NS4_BEG8
+ Tile_X0Y0_IHP_BRAM_top.Inst_IHP_BRAM_top_ConfigMem.Inst_frame2_bit3.Q net71 VPWR
+ VGND sg13g2_mux4_1
XFILLER_57_148 VPWR VGND sg13g2_fill_2
X_0499_ Tile_X0Y1_IHP_BRAM_bot.Inst_IHP_BRAM_bot_ConfigMem.Inst_frame9_bit10.Q Tile_X0Y1_E2MID[6]
+ Tile_X0Y1_E2END[6] Tile_X0Y1_E6END[6] _0102_ Tile_X0Y1_IHP_BRAM_bot.Inst_IHP_BRAM_bot_ConfigMem.Inst_frame9_bit11.Q
+ Tile_X0Y0_IHP_BRAM_top.Inst_IHP_BRAM_top_switch_matrix.N2BEGb1 VPWR VGND sg13g2_mux4_1
XFILLER_57_126 VPWR VGND sg13g2_decap_4
XFILLER_95_57 VPWR VGND sg13g2_decap_4
XFILLER_48_104 VPWR VGND sg13g2_fill_2
X_1540_ Tile_X0Y1_FrameData[7] Tile_X0Y1_FrameStrobe[5] Tile_X0Y1_IHP_BRAM_bot.Inst_IHP_BRAM_bot_ConfigMem.Inst_frame5_bit7.Q
+ VPWR VGND sg13g2_dlhq_1
XFILLER_5_44 VPWR VGND sg13g2_fill_1
XFILLER_69_80 VPWR VGND sg13g2_decap_8
X_0422_ VPWR _0045_ Tile_X0Y0_IHP_BRAM_top.Inst_IHP_BRAM_top_switch_matrix.J_NS2_BEG4
+ VGND sg13g2_inv_1
X_1471_ Tile_X0Y1_FrameData[12] Tile_X0Y1_FrameStrobe[3] Tile_X0Y1_IHP_BRAM_bot.Inst_IHP_BRAM_bot_ConfigMem.Inst_frame3_bit12.Q
+ VPWR VGND sg13g2_dlhq_1
XFILLER_39_115 VPWR VGND sg13g2_fill_2
XFILLER_62_184 VPWR VGND sg13g2_fill_1
X_1807_ Tile_X0Y0_IHP_BRAM_top.Inst_IHP_BRAM_top_switch_matrix.WW4BEG4 net224 VPWR
+ VGND sg13g2_buf_1
X_1738_ Tile_X0Y0_IHP_BRAM_top.Inst_IHP_BRAM_top_switch_matrix.N2BEG0 net149 VPWR
+ VGND sg13g2_buf_1
X_1669_ Tile_X0Y1_FrameData[6] Tile_X0Y1_FrameStrobe[9] Tile_X0Y1_IHP_BRAM_bot.Inst_IHP_BRAM_bot_ConfigMem.Inst_frame9_bit6.Q
+ VPWR VGND sg13g2_dlhq_1
XFILLER_14_31 VPWR VGND sg13g2_fill_1
XFILLER_107_142 VPWR VGND sg13g2_decap_8
XFILLER_39_61 VPWR VGND sg13g2_fill_1
XFILLER_36_129 VPWR VGND sg13g2_decap_8
XFILLER_55_93 VPWR VGND sg13g2_decap_8
X_0971_ Tile_X0Y1_E1END[1] Tile_X0Y1_EE4END[13] Tile_X0Y1_IHP_BRAM_bot.Inst_IHP_BRAM_bot_ConfigMem.Inst_frame8_bit31.Q
+ _0317_ VPWR VGND sg13g2_mux2_1
Xoutput316 net316 Tile_X0Y1_W2BEGb[6] VPWR VGND sg13g2_buf_1
X_1523_ Tile_X0Y1_FrameData[24] Tile_X0Y1_FrameStrobe[5] Tile_X0Y1_IHP_BRAM_bot.Inst_IHP_BRAM_bot_ConfigMem.Inst_frame5_bit24.Q
+ VPWR VGND sg13g2_dlhq_1
Xoutput338 net338 Tile_X0Y1_WW4BEG[2] VPWR VGND sg13g2_buf_1
Xoutput327 net327 Tile_X0Y1_W6BEG[7] VPWR VGND sg13g2_buf_1
Xoutput305 net305 Tile_X0Y1_W2BEG[3] VPWR VGND sg13g2_buf_1
X_1454_ Tile_X0Y1_FrameData[29] Tile_X0Y1_FrameStrobe[3] Tile_X0Y1_IHP_BRAM_bot.Inst_IHP_BRAM_bot_ConfigMem.Inst_frame3_bit29.Q
+ VPWR VGND sg13g2_dlhq_1
X_0405_ VPWR _0028_ Tile_X0Y1_IHP_BRAM_bot.Inst_IHP_BRAM_bot_ConfigMem.Inst_frame8_bit2.Q
+ VGND sg13g2_inv_1
X_1385_ Tile_X0Y1_FrameData[2] Tile_X0Y1_FrameStrobe[0] Tile_X0Y1_IHP_BRAM_bot.Inst_IHP_BRAM_bot_ConfigMem.Inst_frame0_bit2.Q
+ VPWR VGND sg13g2_dlhq_1
XFILLER_51_18 VPWR VGND sg13g2_fill_2
XFILLER_26_173 VPWR VGND sg13g2_fill_2
XFILLER_41_132 VPWR VGND sg13g2_fill_2
X_1170_ Tile_X0Y0_FrameData[25] Tile_X0Y1_FrameStrobe[4] Tile_X0Y0_IHP_BRAM_top.Inst_IHP_BRAM_top_ConfigMem.Inst_frame4_bit25.Q
+ VPWR VGND sg13g2_dlhq_1
XFILLER_32_165 VPWR VGND sg13g2_fill_1
XANTENNA_17 VPWR VGND Tile_X0Y1_FrameStrobe[17] sg13g2_antennanp
XANTENNA_28 VPWR VGND Tile_X0Y1_N4END[4] sg13g2_antennanp
XANTENNA_39 VPWR VGND Tile_X0Y1_N4END[4] sg13g2_antennanp
X_0885_ Tile_X0Y1_IHP_BRAM_bot.Inst_IHP_BRAM_bot_ConfigMem.Inst_frame2_bit3.Q _0103_
+ _0255_ VPWR VGND Tile_X0Y1_IHP_BRAM_bot.Inst_IHP_BRAM_bot_ConfigMem.Inst_frame2_bit2.Q
+ sg13g2_nand3b_1
X_0954_ Tile_X0Y1_IHP_BRAM_bot.Inst_IHP_BRAM_bot_ConfigMem.Inst_frame8_bit3.Q VPWR
+ _0302_ VGND _0299_ _0300_ sg13g2_o21ai_1
Xoutput135 net135 Tile_X0Y0_FrameStrobe_O[19] VPWR VGND sg13g2_buf_1
Xoutput146 net146 Tile_X0Y0_N1BEG[1] VPWR VGND sg13g2_buf_1
Xoutput157 net157 Tile_X0Y0_N2BEGb[0] VPWR VGND sg13g2_buf_1
Xoutput113 net113 Tile_X0Y0_FrameData_O[28] VPWR VGND sg13g2_buf_1
Xoutput102 net102 Tile_X0Y0_FrameData_O[18] VPWR VGND sg13g2_buf_1
XFILLER_101_115 VPWR VGND sg13g2_decap_8
Xoutput168 net168 Tile_X0Y0_N4BEG[12] VPWR VGND sg13g2_buf_1
Xoutput179 net179 Tile_X0Y0_N4BEG[8] VPWR VGND sg13g2_buf_1
Xoutput124 net124 Tile_X0Y0_FrameData_O[9] VPWR VGND sg13g2_buf_1
X_1506_ Tile_X0Y1_FrameData[9] Tile_X0Y1_FrameStrobe[4] Tile_X0Y1_IHP_BRAM_bot.Inst_IHP_BRAM_bot_ConfigMem.Inst_frame4_bit9.Q
+ VPWR VGND sg13g2_dlhq_1
X_1437_ Tile_X0Y1_FrameData[14] Tile_X0Y1_FrameStrobe[2] Tile_X0Y1_IHP_BRAM_bot.Inst_IHP_BRAM_bot_ConfigMem.Inst_frame2_bit14.Q
+ VPWR VGND sg13g2_dlhq_1
XFILLER_56_0 VPWR VGND sg13g2_fill_1
X_1299_ Tile_X0Y0_FrameData[24] Tile_X0Y1_FrameStrobe[8] Tile_X0Y0_IHP_BRAM_top.Inst_IHP_BRAM_top_ConfigMem.Inst_frame8_bit24.Q
+ VPWR VGND sg13g2_dlhq_1
XFILLER_46_18 VPWR VGND sg13g2_fill_2
X_1368_ Tile_X0Y1_FrameData[19] Tile_X0Y1_FrameStrobe[0] Tile_X0Y1_IHP_BRAM_bot.Inst_IHP_BRAM_bot_ConfigMem.Inst_frame0_bit19.Q
+ VPWR VGND sg13g2_dlhq_1
XFILLER_23_110 VPWR VGND sg13g2_decap_8
XFILLER_14_143 VPWR VGND sg13g2_fill_2
X_0670_ Tile_X0Y0_IHP_BRAM_top.Inst_IHP_BRAM_top_ConfigMem.Inst_frame9_bit28.Q VPWR
+ _0145_ VGND Tile_X0Y0_IHP_BRAM_top.Inst_IHP_BRAM_top_ConfigMem.Inst_frame9_bit27.Q
+ Tile_X0Y0_IHP_BRAM_top.Inst_IHP_BRAM_top_switch_matrix.J_NS4_BEG13 sg13g2_o21ai_1
X_1222_ Tile_X0Y0_FrameData[5] Tile_X0Y1_FrameStrobe[5] Tile_X0Y0_IHP_BRAM_top.Inst_IHP_BRAM_top_ConfigMem.Inst_frame5_bit5.Q
+ VPWR VGND sg13g2_dlhq_1
X_1153_ Tile_X0Y0_FrameData[10] Tile_X0Y1_FrameStrobe[3] Tile_X0Y0_IHP_BRAM_top.Inst_IHP_BRAM_top_ConfigMem.Inst_frame3_bit10.Q
+ VPWR VGND sg13g2_dlhq_1
X_1084_ Tile_X0Y0_FrameData[15] Tile_X0Y1_FrameStrobe[1] Tile_X0Y0_IHP_BRAM_top.Inst_IHP_BRAM_top_ConfigMem.Inst_frame1_bit15.Q
+ VPWR VGND sg13g2_dlhq_1
XFILLER_9_180 VPWR VGND sg13g2_fill_2
X_0799_ Tile_X0Y1_IHP_BRAM_bot.Inst_IHP_BRAM_bot_ConfigMem.Inst_frame6_bit12.Q A_DOUT_BRAM6
+ B_DOUT_BRAM6 _0102_ _0046_ Tile_X0Y1_IHP_BRAM_bot.Inst_IHP_BRAM_bot_ConfigMem.Inst_frame6_bit13.Q
+ Tile_X0Y1_IHP_BRAM_bot.Inst_IHP_BRAM_bot_switch_matrix.W2BEGb6 VPWR VGND sg13g2_mux4_1
X_0868_ Tile_X0Y1_IHP_BRAM_bot.Inst_IHP_BRAM_bot_ConfigMem.Inst_frame3_bit0.Q Tile_X0Y1_EE4END[7]
+ Tile_X0Y1_EE4END[15] Tile_X0Y1_E6END[7] Tile_X0Y1_IHP_BRAM_bot.Inst_IHP_BRAM_bot_switch_matrix.J_NS4_BEG7
+ Tile_X0Y1_IHP_BRAM_bot.Inst_IHP_BRAM_bot_ConfigMem.Inst_frame3_bit1.Q net41 VPWR
+ VGND sg13g2_mux4_1
X_0937_ _0285_ VPWR _0286_ VGND _0025_ _0231_ sg13g2_o21ai_1
XFILLER_87_113 VPWR VGND sg13g2_decap_8
XFILLER_98_57 VPWR VGND sg13g2_fill_2
XFILLER_0_2 VPWR VGND sg13g2_fill_1
X_1840_ Tile_X0Y1_FrameData[21] net243 VPWR VGND sg13g2_buf_1
X_0722_ Tile_X0Y0_IHP_BRAM_top.Inst_IHP_BRAM_top_ConfigMem.Inst_frame7_bit7.Q _0190_
+ _0191_ VPWR VGND sg13g2_nor2_1
X_0653_ VPWR VGND Tile_X0Y0_IHP_BRAM_top.Inst_IHP_BRAM_top_ConfigMem.Inst_frame2_bit22.Q
+ _0130_ _0131_ Tile_X0Y0_IHP_BRAM_top.Inst_IHP_BRAM_top_ConfigMem.Inst_frame2_bit23.Q
+ net54 _0043_ sg13g2_a221oi_1
X_1771_ Tile_X0Y0_IHP_BRAM_top.Inst_IHP_BRAM_top_switch_matrix.W1BEG0 net182 VPWR
+ VGND sg13g2_buf_1
X_0584_ Tile_X0Y0_IHP_BRAM_top.Inst_IHP_BRAM_top_ConfigMem.Inst_frame1_bit8.Q Tile_X0Y0_IHP_BRAM_top.Inst_IHP_BRAM_top_switch_matrix.N1END0
+ Tile_X0Y1_N4END[4] Tile_X0Y0_S1END[0] Tile_X0Y0_S4END[0] Tile_X0Y0_IHP_BRAM_top.Inst_IHP_BRAM_top_ConfigMem.Inst_frame1_bit9.Q
+ Tile_X0Y0_IHP_BRAM_top.Inst_IHP_BRAM_top_switch_matrix.J_NS4_BEG0 VPWR VGND sg13g2_mux4_1
X_1067_ Tile_X0Y0_FrameData[0] Tile_X0Y1_FrameStrobe[0] Tile_X0Y0_IHP_BRAM_top.Inst_IHP_BRAM_top_ConfigMem.Inst_frame0_bit0.Q
+ VPWR VGND sg13g2_dlhq_1
X_1136_ Tile_X0Y0_FrameData[27] Tile_X0Y1_FrameStrobe[3] Tile_X0Y0_IHP_BRAM_top.Inst_IHP_BRAM_top_ConfigMem.Inst_frame3_bit27.Q
+ VPWR VGND sg13g2_dlhq_1
X_1205_ Tile_X0Y0_FrameData[22] Tile_X0Y1_FrameStrobe[5] Tile_X0Y0_IHP_BRAM_top.Inst_IHP_BRAM_top_ConfigMem.Inst_frame5_bit22.Q
+ VPWR VGND sg13g2_dlhq_1
XFILLER_19_0 VPWR VGND sg13g2_fill_1
XFILLER_102_210 VPWR VGND sg13g2_fill_2
XFILLER_75_116 VPWR VGND sg13g2_decap_4
XFILLER_66_105 VPWR VGND sg13g2_fill_2
XFILLER_58_60 VPWR VGND sg13g2_decap_8
X_1823_ Tile_X0Y1_FrameData[4] net256 VPWR VGND sg13g2_buf_1
X_0705_ Tile_X0Y0_IHP_BRAM_top.Inst_IHP_BRAM_top_ConfigMem.Inst_frame7_bit0.Q Tile_X0Y0_E1END[1]
+ Tile_X0Y0_E6END[5] Tile_X0Y0_EE4END[13] Tile_X0Y0_IHP_BRAM_top.Inst_IHP_BRAM_top_switch_matrix.J_NS4_BEG1
+ Tile_X0Y0_IHP_BRAM_top.Inst_IHP_BRAM_top_ConfigMem.Inst_frame8_bit31.Q _0176_ VPWR
+ VGND sg13g2_mux4_1
X_1685_ Tile_X0Y0_FrameData[3] net118 VPWR VGND sg13g2_buf_1
X_0636_ Tile_X0Y0_IHP_BRAM_top.Inst_IHP_BRAM_top_ConfigMem.Inst_frame2_bit0.Q Tile_X0Y0_E1END[3]
+ Tile_X0Y0_EE4END[7] Tile_X0Y0_EE4END[15] Tile_X0Y0_IHP_BRAM_top.Inst_IHP_BRAM_top_switch_matrix.J_NS4_BEG15
+ Tile_X0Y0_IHP_BRAM_top.Inst_IHP_BRAM_top_ConfigMem.Inst_frame2_bit1.Q net81 VPWR
+ VGND sg13g2_mux4_1
X_1754_ Tile_X0Y1_N4END[8] net165 VPWR VGND sg13g2_buf_1
X_0567_ Tile_X0Y0_IHP_BRAM_top.Inst_IHP_BRAM_top_ConfigMem.Inst_frame6_bit28.Q A_DOUT_BRAM14
+ B_DOUT_BRAM10 Tile_X0Y0_IHP_BRAM_top.Inst_IHP_BRAM_top_switch_matrix.J_NS4_BEG9
+ Tile_X0Y0_IHP_BRAM_top.Inst_IHP_BRAM_top_switch_matrix.J_NS2_BEG1 Tile_X0Y0_IHP_BRAM_top.Inst_IHP_BRAM_top_ConfigMem.Inst_frame6_bit29.Q
+ Tile_X0Y0_IHP_BRAM_top.Inst_IHP_BRAM_top_switch_matrix.WW4BEG6 VPWR VGND sg13g2_mux4_1
X_0498_ Tile_X0Y1_IHP_BRAM_bot.Inst_IHP_BRAM_bot_ConfigMem.Inst_frame0_bit10.Q Tile_X0Y1_N2MID[1]
+ Tile_X0Y1_N2END[1] Tile_X0Y0_IHP_BRAM_top.Inst_IHP_BRAM_top_switch_matrix.S2BEG1
+ Tile_X0Y0_S2MID[1] Tile_X0Y1_IHP_BRAM_bot.Inst_IHP_BRAM_bot_ConfigMem.Inst_frame0_bit11.Q
+ _0102_ VPWR VGND sg13g2_mux4_1
XFILLER_57_105 VPWR VGND sg13g2_decap_8
X_1119_ Tile_X0Y0_FrameData[12] Tile_X0Y1_FrameStrobe[2] Tile_X0Y0_IHP_BRAM_top.Inst_IHP_BRAM_top_ConfigMem.Inst_frame2_bit12.Q
+ VPWR VGND sg13g2_dlhq_1
XFILLER_65_171 VPWR VGND sg13g2_fill_1
XFILLER_63_119 VPWR VGND sg13g2_fill_1
XFILLER_28_41 VPWR VGND sg13g2_decap_8
XFILLER_48_127 VPWR VGND sg13g2_decap_8
XFILLER_71_185 VPWR VGND sg13g2_fill_1
X_1470_ Tile_X0Y1_FrameData[13] Tile_X0Y1_FrameStrobe[3] Tile_X0Y1_IHP_BRAM_bot.Inst_IHP_BRAM_bot_ConfigMem.Inst_frame3_bit13.Q
+ VPWR VGND sg13g2_dlhq_1
X_0421_ VPWR _0044_ Tile_X0Y0_IHP_BRAM_top.Inst_IHP_BRAM_top_switch_matrix.J_NS2_BEG3
+ VGND sg13g2_inv_1
XFILLER_54_119 VPWR VGND sg13g2_decap_8
XFILLER_86_0 VPWR VGND sg13g2_decap_4
X_1806_ Tile_X0Y0_IHP_BRAM_top.Inst_IHP_BRAM_top_switch_matrix.WW4BEG3 net223 VPWR
+ VGND sg13g2_buf_1
X_1737_ Tile_X0Y0_IHP_BRAM_top.Inst_IHP_BRAM_top_switch_matrix.N1BEG3 net148 VPWR
+ VGND sg13g2_buf_1
X_0619_ VPWR VGND Tile_X0Y0_IHP_BRAM_top.Inst_IHP_BRAM_top_ConfigMem.Inst_frame3_bit10.Q
+ _0118_ _0119_ Tile_X0Y0_IHP_BRAM_top.Inst_IHP_BRAM_top_ConfigMem.Inst_frame3_bit11.Q
+ net7 _0042_ sg13g2_a221oi_1
X_1599_ Tile_X0Y1_FrameData[12] Tile_X0Y1_FrameStrobe[7] Tile_X0Y1_IHP_BRAM_bot.Inst_IHP_BRAM_bot_ConfigMem.Inst_frame7_bit12.Q
+ VPWR VGND sg13g2_dlhq_1
X_1668_ Tile_X0Y1_FrameData[7] Tile_X0Y1_FrameStrobe[9] Tile_X0Y1_IHP_BRAM_bot.Inst_IHP_BRAM_bot_ConfigMem.Inst_frame9_bit7.Q
+ VPWR VGND sg13g2_dlhq_1
XFILLER_100_2 VPWR VGND sg13g2_fill_1
XFILLER_107_198 VPWR VGND sg13g2_fill_2
XFILLER_55_72 VPWR VGND sg13g2_decap_8
X_0970_ _0315_ VPWR _0316_ VGND _0031_ _0232_ sg13g2_o21ai_1
X_1522_ Tile_X0Y1_FrameData[25] Tile_X0Y1_FrameStrobe[5] Tile_X0Y1_IHP_BRAM_bot.Inst_IHP_BRAM_bot_ConfigMem.Inst_frame5_bit25.Q
+ VPWR VGND sg13g2_dlhq_1
Xoutput317 net317 Tile_X0Y1_W2BEGb[7] VPWR VGND sg13g2_buf_1
X_1453_ Tile_X0Y1_FrameData[30] Tile_X0Y1_FrameStrobe[3] Tile_X0Y1_IHP_BRAM_bot.Inst_IHP_BRAM_bot_ConfigMem.Inst_frame3_bit30.Q
+ VPWR VGND sg13g2_dlhq_1
Xoutput328 net328 Tile_X0Y1_W6BEG[8] VPWR VGND sg13g2_buf_1
Xoutput306 net306 Tile_X0Y1_W2BEG[4] VPWR VGND sg13g2_buf_1
Xoutput339 net339 Tile_X0Y1_WW4BEG[3] VPWR VGND sg13g2_buf_1
X_0404_ VPWR _0027_ Tile_X0Y1_IHP_BRAM_bot.Inst_IHP_BRAM_bot_ConfigMem.Inst_frame8_bit1.Q
+ VGND sg13g2_inv_1
XFILLER_82_214 VPWR VGND sg13g2_fill_2
XFILLER_67_211 VPWR VGND sg13g2_fill_1
X_1384_ Tile_X0Y1_FrameData[3] Tile_X0Y1_FrameStrobe[0] Tile_X0Y1_IHP_BRAM_bot.Inst_IHP_BRAM_bot_ConfigMem.Inst_frame0_bit3.Q
+ VPWR VGND sg13g2_dlhq_1
XFILLER_50_122 VPWR VGND sg13g2_fill_1
XFILLER_104_124 VPWR VGND sg13g2_decap_4
XFILLER_92_48 VPWR VGND sg13g2_decap_8
XFILLER_66_82 VPWR VGND sg13g2_fill_2
XFILLER_66_71 VPWR VGND sg13g2_decap_8
XFILLER_2_46 VPWR VGND sg13g2_fill_2
XANTENNA_18 VPWR VGND Tile_X0Y1_FrameStrobe[18] sg13g2_antennanp
XANTENNA_29 VPWR VGND Tile_X0Y1_N4END[4] sg13g2_antennanp
XFILLER_82_81 VPWR VGND sg13g2_decap_8
XFILLER_82_70 VPWR VGND sg13g2_fill_1
XFILLER_32_133 VPWR VGND sg13g2_decap_8
Xoutput125 net125 Tile_X0Y0_FrameStrobe_O[0] VPWR VGND sg13g2_buf_1
Xoutput114 net114 Tile_X0Y0_FrameData_O[29] VPWR VGND sg13g2_buf_1
Xoutput103 net103 Tile_X0Y0_FrameData_O[19] VPWR VGND sg13g2_buf_1
X_0884_ _0252_ VPWR net48 VGND Tile_X0Y1_IHP_BRAM_bot.Inst_IHP_BRAM_bot_ConfigMem.Inst_frame2_bit1.Q
+ _0254_ sg13g2_o21ai_1
X_0953_ Tile_X0Y1_IHP_BRAM_bot.Inst_IHP_BRAM_bot_switch_matrix.J_NS4_BEG7 Tile_X0Y1_IHP_BRAM_bot.Inst_IHP_BRAM_bot_switch_matrix.J_NS4_BEG11
+ Tile_X0Y1_IHP_BRAM_bot.Inst_IHP_BRAM_bot_ConfigMem.Inst_frame8_bit1.Q _0301_ VPWR
+ VGND sg13g2_mux2_1
Xoutput136 net136 Tile_X0Y0_FrameStrobe_O[1] VPWR VGND sg13g2_buf_1
Xoutput169 net169 Tile_X0Y0_N4BEG[13] VPWR VGND sg13g2_buf_1
Xoutput158 net158 Tile_X0Y0_N2BEGb[1] VPWR VGND sg13g2_buf_1
XFILLER_101_149 VPWR VGND sg13g2_decap_8
Xoutput147 net147 Tile_X0Y0_N1BEG[2] VPWR VGND sg13g2_buf_1
X_1505_ Tile_X0Y1_FrameData[10] Tile_X0Y1_FrameStrobe[4] Tile_X0Y1_IHP_BRAM_bot.Inst_IHP_BRAM_bot_ConfigMem.Inst_frame4_bit10.Q
+ VPWR VGND sg13g2_dlhq_1
X_1436_ Tile_X0Y1_FrameData[15] Tile_X0Y1_FrameStrobe[2] Tile_X0Y1_IHP_BRAM_bot.Inst_IHP_BRAM_bot_ConfigMem.Inst_frame2_bit15.Q
+ VPWR VGND sg13g2_dlhq_1
XFILLER_49_0 VPWR VGND sg13g2_decap_8
X_1367_ Tile_X0Y1_FrameData[20] Tile_X0Y1_FrameStrobe[0] Tile_X0Y1_IHP_BRAM_bot.Inst_IHP_BRAM_bot_ConfigMem.Inst_frame0_bit20.Q
+ VPWR VGND sg13g2_dlhq_1
X_1298_ Tile_X0Y0_FrameData[25] Tile_X0Y1_FrameStrobe[8] Tile_X0Y0_IHP_BRAM_top.Inst_IHP_BRAM_top_ConfigMem.Inst_frame8_bit25.Q
+ VPWR VGND sg13g2_dlhq_1
XFILLER_62_18 VPWR VGND sg13g2_fill_1
XFILLER_55_214 VPWR VGND sg13g2_fill_2
XFILLER_87_59 VPWR VGND sg13g2_decap_8
XFILLER_14_100 VPWR VGND sg13g2_fill_2
XFILLER_14_188 VPWR VGND sg13g2_fill_2
XFILLER_77_70 VPWR VGND sg13g2_fill_2
X_1221_ Tile_X0Y0_FrameData[6] Tile_X0Y1_FrameStrobe[5] Tile_X0Y0_IHP_BRAM_top.Inst_IHP_BRAM_top_ConfigMem.Inst_frame5_bit6.Q
+ VPWR VGND sg13g2_dlhq_1
X_1083_ Tile_X0Y0_FrameData[16] Tile_X0Y1_FrameStrobe[1] Tile_X0Y0_IHP_BRAM_top.Inst_IHP_BRAM_top_ConfigMem.Inst_frame1_bit16.Q
+ VPWR VGND sg13g2_dlhq_1
X_1152_ Tile_X0Y0_FrameData[11] Tile_X0Y1_FrameStrobe[3] Tile_X0Y0_IHP_BRAM_top.Inst_IHP_BRAM_top_ConfigMem.Inst_frame3_bit11.Q
+ VPWR VGND sg13g2_dlhq_1
XFILLER_20_147 VPWR VGND sg13g2_fill_2
X_0936_ VPWR _0285_ _0284_ VGND sg13g2_inv_1
X_0798_ Tile_X0Y1_IHP_BRAM_bot.Inst_IHP_BRAM_bot_ConfigMem.Inst_frame6_bit10.Q A_DOUT_BRAM5
+ B_DOUT_BRAM5 _0103_ _0106_ Tile_X0Y1_IHP_BRAM_bot.Inst_IHP_BRAM_bot_ConfigMem.Inst_frame6_bit11.Q
+ Tile_X0Y1_IHP_BRAM_bot.Inst_IHP_BRAM_bot_switch_matrix.W2BEGb5 VPWR VGND sg13g2_mux4_1
X_0867_ Tile_X0Y1_IHP_BRAM_bot.Inst_IHP_BRAM_bot_ConfigMem.Inst_frame4_bit30.Q Tile_X0Y1_EE4END[6]
+ Tile_X0Y1_EE4END[14] Tile_X0Y1_E6END[6] Tile_X0Y1_IHP_BRAM_bot.Inst_IHP_BRAM_bot_switch_matrix.J_NS4_BEG6
+ Tile_X0Y1_IHP_BRAM_bot.Inst_IHP_BRAM_bot_ConfigMem.Inst_frame4_bit31.Q net40 VPWR
+ VGND sg13g2_mux4_1
X_1419_ Tile_X0Y1_FrameData[0] Tile_X0Y1_FrameStrobe[1] Tile_X0Y1_IHP_BRAM_bot.Inst_IHP_BRAM_bot_ConfigMem.Inst_frame1_bit0.Q
+ VPWR VGND sg13g2_dlhq_1
XFILLER_93_128 VPWR VGND sg13g2_fill_2
XFILLER_34_206 VPWR VGND sg13g2_fill_2
XFILLER_47_40 VPWR VGND sg13g2_decap_8
X_1770_ clknet_1_1__leaf_Tile_X0Y1_UserCLK net181 VPWR VGND sg13g2_buf_1
XFILLER_8_12 VPWR VGND sg13g2_fill_2
X_0583_ Tile_X0Y0_IHP_BRAM_top.Inst_IHP_BRAM_top_ConfigMem.Inst_frame5_bit12.Q A_DOUT_BRAM10
+ B_DOUT_BRAM14 Tile_X0Y0_IHP_BRAM_top.Inst_IHP_BRAM_top_switch_matrix.J_NS4_BEG1
+ Tile_X0Y0_IHP_BRAM_top.Inst_IHP_BRAM_top_switch_matrix.J_NS2_BEG1 Tile_X0Y0_IHP_BRAM_top.Inst_IHP_BRAM_top_ConfigMem.Inst_frame5_bit13.Q
+ Tile_X0Y0_IHP_BRAM_top.Inst_IHP_BRAM_top_switch_matrix.WW4BEG14 VPWR VGND sg13g2_mux4_1
X_0721_ Tile_X0Y0_IHP_BRAM_top.Inst_IHP_BRAM_top_ConfigMem.Inst_frame7_bit6.Q Tile_X0Y0_E1END[3]
+ Tile_X0Y0_E6END[7] Tile_X0Y0_EE4END[15] Tile_X0Y0_IHP_BRAM_top.Inst_IHP_BRAM_top_switch_matrix.J_NS4_BEG3
+ Tile_X0Y0_IHP_BRAM_top.Inst_IHP_BRAM_top_ConfigMem.Inst_frame7_bit5.Q _0190_ VPWR
+ VGND sg13g2_mux4_1
X_0652_ _0131_ Tile_X0Y0_E2END[2] Tile_X0Y0_IHP_BRAM_top.Inst_IHP_BRAM_top_ConfigMem.Inst_frame2_bit23.Q
+ VPWR VGND sg13g2_nand2b_1
X_1204_ Tile_X0Y0_FrameData[23] Tile_X0Y1_FrameStrobe[5] Tile_X0Y0_IHP_BRAM_top.Inst_IHP_BRAM_top_ConfigMem.Inst_frame5_bit23.Q
+ VPWR VGND sg13g2_dlhq_1
XFILLER_69_114 VPWR VGND sg13g2_fill_1
X_1135_ Tile_X0Y0_FrameData[28] Tile_X0Y1_FrameStrobe[3] Tile_X0Y0_IHP_BRAM_top.Inst_IHP_BRAM_top_ConfigMem.Inst_frame3_bit28.Q
+ VPWR VGND sg13g2_dlhq_1
X_1066_ Tile_X0Y0_FrameData[1] Tile_X0Y1_FrameStrobe[0] Tile_X0Y0_IHP_BRAM_top.Inst_IHP_BRAM_top_ConfigMem.Inst_frame0_bit1.Q
+ VPWR VGND sg13g2_dlhq_1
X_0919_ Tile_X0Y1_IHP_BRAM_bot.Inst_IHP_BRAM_bot_ConfigMem.Inst_frame9_bit25.Q VPWR
+ _0270_ VGND Tile_X0Y1_IHP_BRAM_bot.Inst_IHP_BRAM_bot_ConfigMem.Inst_frame9_bit24.Q
+ Tile_X0Y1_IHP_BRAM_bot.Inst_IHP_BRAM_bot_switch_matrix.J_NS4_BEG12 sg13g2_o21ai_1
X_1899_ Tile_X0Y1_IHP_BRAM_bot.Inst_IHP_BRAM_bot_switch_matrix.W2BEGb0 net310 VPWR
+ VGND sg13g2_buf_1
XFILLER_33_86 VPWR VGND sg13g2_fill_2
X_1753_ Tile_X0Y0_IHP_BRAM_top.Inst_IHP_BRAM_top_switch_matrix.N2BEGb7 net164 VPWR
+ VGND sg13g2_buf_1
X_1822_ Tile_X0Y1_FrameData[3] net255 VPWR VGND sg13g2_buf_1
X_0566_ Tile_X0Y0_IHP_BRAM_top.Inst_IHP_BRAM_top_ConfigMem.Inst_frame1_bit26.Q Tile_X0Y0_IHP_BRAM_top.Inst_IHP_BRAM_top_switch_matrix.N1END1
+ Tile_X0Y1_N4END[5] Tile_X0Y0_S1END[1] Tile_X0Y0_S4END[1] Tile_X0Y0_IHP_BRAM_top.Inst_IHP_BRAM_top_ConfigMem.Inst_frame1_bit27.Q
+ Tile_X0Y0_IHP_BRAM_top.Inst_IHP_BRAM_top_switch_matrix.J_NS4_BEG9 VPWR VGND sg13g2_mux4_1
X_0704_ VGND VPWR _0016_ _0171_ _0175_ _0174_ sg13g2_a21oi_1
X_0635_ Tile_X0Y0_IHP_BRAM_top.Inst_IHP_BRAM_top_ConfigMem.Inst_frame3_bit30.Q Tile_X0Y0_E1END[2]
+ Tile_X0Y0_EE4END[6] Tile_X0Y0_EE4END[14] Tile_X0Y0_IHP_BRAM_top.Inst_IHP_BRAM_top_switch_matrix.J_NS4_BEG14
+ Tile_X0Y0_IHP_BRAM_top.Inst_IHP_BRAM_top_ConfigMem.Inst_frame3_bit31.Q net80 VPWR
+ VGND sg13g2_mux4_1
X_1684_ Tile_X0Y0_FrameData[2] net115 VPWR VGND sg13g2_buf_1
XFILLER_31_0 VPWR VGND sg13g2_fill_1
X_0497_ Tile_X0Y0_IHP_BRAM_top.Inst_IHP_BRAM_top_ConfigMem.Inst_frame8_bit14.Q Tile_X0Y0_E2MID[6]
+ Tile_X0Y0_E2END[6] Tile_X0Y0_E6END[9] Tile_X0Y0_IHP_BRAM_top.Inst_IHP_BRAM_top_switch_matrix.J_NS2_BEG1
+ Tile_X0Y0_IHP_BRAM_top.Inst_IHP_BRAM_top_ConfigMem.Inst_frame8_bit15.Q Tile_X0Y0_IHP_BRAM_top.Inst_IHP_BRAM_top_switch_matrix.S2BEG1
+ VPWR VGND sg13g2_mux4_1
X_1049_ Tile_X0Y0_FrameData[18] Tile_X0Y1_FrameStrobe[0] Tile_X0Y0_IHP_BRAM_top.Inst_IHP_BRAM_top_ConfigMem.Inst_frame0_bit18.Q
+ VPWR VGND sg13g2_dlhq_1
X_1118_ Tile_X0Y0_FrameData[13] Tile_X0Y1_FrameStrobe[2] Tile_X0Y0_IHP_BRAM_top.Inst_IHP_BRAM_top_ConfigMem.Inst_frame2_bit13.Q
+ VPWR VGND sg13g2_dlhq_1
XFILLER_71_120 VPWR VGND sg13g2_decap_8
XFILLER_44_41 VPWR VGND sg13g2_fill_2
XFILLER_100_91 VPWR VGND sg13g2_decap_8
XFILLER_8_213 VPWR VGND sg13g2_fill_2
X_0420_ VPWR _0043_ Tile_X0Y0_IHP_BRAM_top.Inst_IHP_BRAM_top_switch_matrix.J_NS2_BEG2
+ VGND sg13g2_inv_1
XFILLER_39_117 VPWR VGND sg13g2_fill_1
X_1736_ Tile_X0Y0_IHP_BRAM_top.Inst_IHP_BRAM_top_switch_matrix.N1BEG2 net147 VPWR
+ VGND sg13g2_buf_1
X_1805_ Tile_X0Y0_IHP_BRAM_top.Inst_IHP_BRAM_top_switch_matrix.WW4BEG2 net222 VPWR
+ VGND sg13g2_buf_1
X_0618_ _0119_ Tile_X0Y0_E2END[1] Tile_X0Y0_IHP_BRAM_top.Inst_IHP_BRAM_top_ConfigMem.Inst_frame3_bit11.Q
+ VPWR VGND sg13g2_nand2b_1
X_0549_ Tile_X0Y0_IHP_BRAM_top.Inst_IHP_BRAM_top_ConfigMem.Inst_frame6_bit0.Q A_DOUT_BRAM8
+ B_DOUT_BRAM8 Tile_X0Y0_IHP_BRAM_top.Inst_IHP_BRAM_top_switch_matrix.J_NS2_BEG0 Tile_X0Y0_IHP_BRAM_top.Inst_IHP_BRAM_top_switch_matrix.J_NS2_BEG7
+ Tile_X0Y0_IHP_BRAM_top.Inst_IHP_BRAM_top_ConfigMem.Inst_frame6_bit1.Q Tile_X0Y0_IHP_BRAM_top.Inst_IHP_BRAM_top_switch_matrix.W2BEGb0
+ VPWR VGND sg13g2_mux4_1
X_1598_ Tile_X0Y1_FrameData[13] Tile_X0Y1_FrameStrobe[7] Tile_X0Y1_IHP_BRAM_bot.Inst_IHP_BRAM_bot_ConfigMem.Inst_frame7_bit13.Q
+ VPWR VGND sg13g2_dlhq_1
X_1667_ Tile_X0Y1_FrameData[8] Tile_X0Y1_FrameStrobe[9] Tile_X0Y1_IHP_BRAM_bot.Inst_IHP_BRAM_bot_ConfigMem.Inst_frame9_bit8.Q
+ VPWR VGND sg13g2_dlhq_1
XFILLER_38_172 VPWR VGND sg13g2_fill_1
XFILLER_107_177 VPWR VGND sg13g2_fill_2
XFILLER_30_21 VPWR VGND sg13g2_fill_1
XFILLER_55_51 VPWR VGND sg13g2_decap_4
Xoutput307 net307 Tile_X0Y1_W2BEG[5] VPWR VGND sg13g2_buf_1
Xoutput318 net318 Tile_X0Y1_W6BEG[0] VPWR VGND sg13g2_buf_1
Xoutput329 net329 Tile_X0Y1_W6BEG[9] VPWR VGND sg13g2_buf_1
X_1521_ Tile_X0Y1_FrameData[26] Tile_X0Y1_FrameStrobe[5] Tile_X0Y1_IHP_BRAM_bot.Inst_IHP_BRAM_bot_ConfigMem.Inst_frame5_bit26.Q
+ VPWR VGND sg13g2_dlhq_1
X_1452_ Tile_X0Y1_FrameData[31] Tile_X0Y1_FrameStrobe[3] Tile_X0Y1_IHP_BRAM_bot.Inst_IHP_BRAM_bot_ConfigMem.Inst_frame3_bit31.Q
+ VPWR VGND sg13g2_dlhq_1
X_1383_ Tile_X0Y1_FrameData[4] Tile_X0Y1_FrameStrobe[0] Tile_X0Y1_IHP_BRAM_bot.Inst_IHP_BRAM_bot_ConfigMem.Inst_frame0_bit4.Q
+ VPWR VGND sg13g2_dlhq_1
X_0403_ VPWR _0026_ Tile_X0Y1_IHP_BRAM_bot.Inst_IHP_BRAM_bot_ConfigMem.Inst_frame9_bit31.Q
+ VGND sg13g2_inv_1
X_1719_ Tile_X0Y1_FrameStrobe[5] net140 VPWR VGND sg13g2_buf_1
XFILLER_104_147 VPWR VGND sg13g2_fill_1
XFILLER_26_175 VPWR VGND sg13g2_fill_1
XFILLER_41_101 VPWR VGND sg13g2_fill_2
XFILLER_41_134 VPWR VGND sg13g2_fill_1
XANTENNA_19 VPWR VGND Tile_X0Y1_FrameStrobe[18] sg13g2_antennanp
X_0952_ Tile_X0Y1_IHP_BRAM_bot.Inst_IHP_BRAM_bot_ConfigMem.Inst_frame8_bit2.Q VPWR
+ _0300_ VGND Tile_X0Y1_IHP_BRAM_bot.Inst_IHP_BRAM_bot_ConfigMem.Inst_frame8_bit1.Q
+ Tile_X0Y1_IHP_BRAM_bot.Inst_IHP_BRAM_bot_switch_matrix.J_NS4_BEG15 sg13g2_o21ai_1
Xoutput137 net137 Tile_X0Y0_FrameStrobe_O[2] VPWR VGND sg13g2_buf_1
Xoutput148 net148 Tile_X0Y0_N1BEG[3] VPWR VGND sg13g2_buf_1
Xoutput126 net126 Tile_X0Y0_FrameStrobe_O[10] VPWR VGND sg13g2_buf_1
Xoutput159 net159 Tile_X0Y0_N2BEGb[2] VPWR VGND sg13g2_buf_1
Xoutput115 net115 Tile_X0Y0_FrameData_O[2] VPWR VGND sg13g2_buf_1
Xoutput104 net104 Tile_X0Y0_FrameData_O[1] VPWR VGND sg13g2_buf_1
X_1504_ Tile_X0Y1_FrameData[11] Tile_X0Y1_FrameStrobe[4] Tile_X0Y1_IHP_BRAM_bot.Inst_IHP_BRAM_bot_ConfigMem.Inst_frame4_bit11.Q
+ VPWR VGND sg13g2_dlhq_1
X_0883_ VGND VPWR Tile_X0Y1_E2END[1] Tile_X0Y1_IHP_BRAM_bot.Inst_IHP_BRAM_bot_ConfigMem.Inst_frame2_bit0.Q
+ _0254_ _0253_ sg13g2_a21oi_1
X_1435_ Tile_X0Y1_FrameData[16] Tile_X0Y1_FrameStrobe[2] Tile_X0Y1_IHP_BRAM_bot.Inst_IHP_BRAM_bot_ConfigMem.Inst_frame2_bit16.Q
+ VPWR VGND sg13g2_dlhq_1
X_1366_ Tile_X0Y1_FrameData[21] Tile_X0Y1_FrameStrobe[0] Tile_X0Y1_IHP_BRAM_bot.Inst_IHP_BRAM_bot_ConfigMem.Inst_frame0_bit21.Q
+ VPWR VGND sg13g2_dlhq_1
X_1297_ Tile_X0Y0_FrameData[26] Tile_X0Y1_FrameStrobe[8] Tile_X0Y0_IHP_BRAM_top.Inst_IHP_BRAM_top_ConfigMem.Inst_frame8_bit26.Q
+ VPWR VGND sg13g2_dlhq_1
XFILLER_23_156 VPWR VGND sg13g2_fill_1
XFILLER_14_145 VPWR VGND sg13g2_fill_1
XFILLER_52_85 VPWR VGND sg13g2_fill_2
X_1220_ Tile_X0Y0_FrameData[7] Tile_X0Y1_FrameStrobe[5] Tile_X0Y0_IHP_BRAM_top.Inst_IHP_BRAM_top_ConfigMem.Inst_frame5_bit7.Q
+ VPWR VGND sg13g2_dlhq_1
X_1151_ Tile_X0Y0_FrameData[12] Tile_X0Y1_FrameStrobe[3] Tile_X0Y0_IHP_BRAM_top.Inst_IHP_BRAM_top_ConfigMem.Inst_frame3_bit12.Q
+ VPWR VGND sg13g2_dlhq_1
XFILLER_35_7 VPWR VGND sg13g2_fill_1
XFILLER_93_81 VPWR VGND sg13g2_fill_2
X_1082_ Tile_X0Y0_FrameData[17] Tile_X0Y1_FrameStrobe[1] Tile_X0Y0_IHP_BRAM_top.Inst_IHP_BRAM_top_ConfigMem.Inst_frame1_bit17.Q
+ VPWR VGND sg13g2_dlhq_1
XFILLER_9_182 VPWR VGND sg13g2_fill_1
X_0866_ Tile_X0Y1_IHP_BRAM_bot.Inst_IHP_BRAM_bot_ConfigMem.Inst_frame4_bit28.Q Tile_X0Y1_EE4END[5]
+ Tile_X0Y1_EE4END[13] Tile_X0Y1_E6END[5] Tile_X0Y1_IHP_BRAM_bot.Inst_IHP_BRAM_bot_switch_matrix.J_NS4_BEG5
+ Tile_X0Y1_IHP_BRAM_bot.Inst_IHP_BRAM_bot_ConfigMem.Inst_frame4_bit29.Q net39 VPWR
+ VGND sg13g2_mux4_1
X_0935_ Tile_X0Y1_IHP_BRAM_bot.Inst_IHP_BRAM_bot_ConfigMem.Inst_frame9_bit31.Q VPWR
+ _0284_ VGND Tile_X0Y1_E6END[10] Tile_X0Y1_IHP_BRAM_bot.Inst_IHP_BRAM_bot_ConfigMem.Inst_frame9_bit30.Q
+ sg13g2_o21ai_1
X_0797_ Tile_X0Y1_IHP_BRAM_bot.Inst_IHP_BRAM_bot_ConfigMem.Inst_frame6_bit8.Q A_DOUT_BRAM4
+ B_DOUT_BRAM4 _0104_ _0105_ Tile_X0Y1_IHP_BRAM_bot.Inst_IHP_BRAM_bot_ConfigMem.Inst_frame6_bit9.Q
+ Tile_X0Y1_IHP_BRAM_bot.Inst_IHP_BRAM_bot_switch_matrix.W2BEGb4 VPWR VGND sg13g2_mux4_1
XFILLER_87_159 VPWR VGND sg13g2_decap_8
X_1349_ Tile_X0Y0_FrameData[6] Tile_X0Y1_FrameStrobe[9] Tile_X0Y0_IHP_BRAM_top.Inst_IHP_BRAM_top_ConfigMem.Inst_frame9_bit6.Q
+ VPWR VGND sg13g2_dlhq_1
X_1418_ Tile_X0Y1_FrameData[1] Tile_X0Y1_FrameStrobe[1] Tile_X0Y1_IHP_BRAM_bot.Inst_IHP_BRAM_bot_ConfigMem.Inst_frame1_bit1.Q
+ VPWR VGND sg13g2_dlhq_1
XFILLER_98_59 VPWR VGND sg13g2_fill_1
XFILLER_7_119 VPWR VGND sg13g2_fill_2
X_0720_ VGND VPWR _0018_ _0185_ _0189_ _0188_ sg13g2_a21oi_1
X_0582_ Tile_X0Y0_IHP_BRAM_top.Inst_IHP_BRAM_top_ConfigMem.Inst_frame1_bit10.Q Tile_X0Y0_IHP_BRAM_top.Inst_IHP_BRAM_top_switch_matrix.N1END1
+ Tile_X0Y1_N4END[5] Tile_X0Y0_S1END[1] Tile_X0Y0_S4END[1] Tile_X0Y0_IHP_BRAM_top.Inst_IHP_BRAM_top_ConfigMem.Inst_frame1_bit11.Q
+ Tile_X0Y0_IHP_BRAM_top.Inst_IHP_BRAM_top_switch_matrix.J_NS4_BEG1 VPWR VGND sg13g2_mux4_1
X_0651_ Tile_X0Y0_E2MID[2] Tile_X0Y0_IHP_BRAM_top.Inst_IHP_BRAM_top_ConfigMem.Inst_frame2_bit22.Q
+ Tile_X0Y0_IHP_BRAM_top.Inst_IHP_BRAM_top_ConfigMem.Inst_frame2_bit23.Q _0130_ VPWR
+ VGND sg13g2_nor3_1
X_1134_ Tile_X0Y0_FrameData[29] Tile_X0Y1_FrameStrobe[3] Tile_X0Y0_IHP_BRAM_top.Inst_IHP_BRAM_top_ConfigMem.Inst_frame3_bit29.Q
+ VPWR VGND sg13g2_dlhq_1
X_1203_ Tile_X0Y0_FrameData[24] Tile_X0Y1_FrameStrobe[5] Tile_X0Y0_IHP_BRAM_top.Inst_IHP_BRAM_top_ConfigMem.Inst_frame5_bit24.Q
+ VPWR VGND sg13g2_dlhq_1
XFILLER_33_4 VPWR VGND sg13g2_fill_2
X_1065_ Tile_X0Y0_FrameData[2] Tile_X0Y1_FrameStrobe[0] Tile_X0Y0_IHP_BRAM_top.Inst_IHP_BRAM_top_ConfigMem.Inst_frame0_bit2.Q
+ VPWR VGND sg13g2_dlhq_1
XFILLER_92_162 VPWR VGND sg13g2_fill_1
X_1898_ Tile_X0Y1_IHP_BRAM_bot.Inst_IHP_BRAM_bot_switch_matrix.W2BEG7 net309 VPWR
+ VGND sg13g2_buf_1
X_0918_ _0021_ _0065_ _0269_ VPWR VGND sg13g2_nor2_1
X_0849_ Tile_X0Y1_IHP_BRAM_bot.Inst_IHP_BRAM_bot_ConfigMem.Inst_frame4_bit13.Q _0103_
+ _0240_ VPWR VGND Tile_X0Y1_IHP_BRAM_bot.Inst_IHP_BRAM_bot_ConfigMem.Inst_frame4_bit12.Q
+ sg13g2_nand3b_1
XFILLER_17_77 VPWR VGND sg13g2_fill_2
XFILLER_109_0 VPWR VGND sg13g2_fill_1
XFILLER_66_107 VPWR VGND sg13g2_fill_1
XFILLER_74_195 VPWR VGND sg13g2_fill_1
XFILLER_74_184 VPWR VGND sg13g2_decap_8
X_1752_ Tile_X0Y0_IHP_BRAM_top.Inst_IHP_BRAM_top_switch_matrix.N2BEGb6 net163 VPWR
+ VGND sg13g2_buf_1
X_0703_ Tile_X0Y0_IHP_BRAM_top.Inst_IHP_BRAM_top_ConfigMem.Inst_frame7_bit1.Q VPWR
+ _0174_ VGND _0172_ _0173_ sg13g2_o21ai_1
XFILLER_90_71 VPWR VGND sg13g2_fill_2
X_1683_ Tile_X0Y0_FrameData[1] net104 VPWR VGND sg13g2_buf_1
X_1821_ Tile_X0Y1_FrameData[2] net252 VPWR VGND sg13g2_buf_1
X_0634_ Tile_X0Y0_IHP_BRAM_top.Inst_IHP_BRAM_top_ConfigMem.Inst_frame3_bit28.Q Tile_X0Y0_E1END[1]
+ Tile_X0Y0_EE4END[5] Tile_X0Y0_EE4END[13] Tile_X0Y0_IHP_BRAM_top.Inst_IHP_BRAM_top_switch_matrix.J_NS4_BEG13
+ Tile_X0Y0_IHP_BRAM_top.Inst_IHP_BRAM_top_ConfigMem.Inst_frame3_bit29.Q net79 VPWR
+ VGND sg13g2_mux4_1
X_0496_ Tile_X0Y0_IHP_BRAM_top.Inst_IHP_BRAM_top_ConfigMem.Inst_frame9_bit8.Q Tile_X0Y0_E2MID[7]
+ Tile_X0Y0_E2END[7] Tile_X0Y0_E6END[7] Tile_X0Y0_IHP_BRAM_top.Inst_IHP_BRAM_top_switch_matrix.J_NS2_BEG0
+ Tile_X0Y0_IHP_BRAM_top.Inst_IHP_BRAM_top_ConfigMem.Inst_frame9_bit9.Q Tile_X0Y0_IHP_BRAM_top.Inst_IHP_BRAM_top_switch_matrix.N2BEG0
+ VPWR VGND sg13g2_mux4_1
X_0565_ Tile_X0Y0_IHP_BRAM_top.Inst_IHP_BRAM_top_ConfigMem.Inst_frame6_bit26.Q A_DOUT_BRAM13
+ B_DOUT_BRAM8 Tile_X0Y0_IHP_BRAM_top.Inst_IHP_BRAM_top_switch_matrix.J_NS4_BEG10
+ Tile_X0Y0_IHP_BRAM_top.Inst_IHP_BRAM_top_switch_matrix.J_NS2_BEG2 Tile_X0Y0_IHP_BRAM_top.Inst_IHP_BRAM_top_ConfigMem.Inst_frame6_bit27.Q
+ Tile_X0Y0_IHP_BRAM_top.Inst_IHP_BRAM_top_switch_matrix.WW4BEG5 VPWR VGND sg13g2_mux4_1
X_1117_ Tile_X0Y0_FrameData[14] Tile_X0Y1_FrameStrobe[2] Tile_X0Y0_IHP_BRAM_top.Inst_IHP_BRAM_top_ConfigMem.Inst_frame2_bit14.Q
+ VPWR VGND sg13g2_dlhq_1
X_1048_ Tile_X0Y0_FrameData[19] Tile_X0Y1_FrameStrobe[0] Tile_X0Y0_IHP_BRAM_top.Inst_IHP_BRAM_top_ConfigMem.Inst_frame0_bit19.Q
+ VPWR VGND sg13g2_dlhq_1
XFILLER_44_75 VPWR VGND sg13g2_fill_2
Xclkbuf_1_0__f_Tile_X0Y1_UserCLK clknet_0_Tile_X0Y1_UserCLK clknet_1_0__leaf_Tile_X0Y1_UserCLK
+ VPWR VGND sg13g2_buf_8
XFILLER_85_71 VPWR VGND sg13g2_fill_1
X_1735_ Tile_X0Y0_IHP_BRAM_top.Inst_IHP_BRAM_top_switch_matrix.N1BEG1 net146 VPWR
+ VGND sg13g2_buf_1
X_1804_ Tile_X0Y0_IHP_BRAM_top.Inst_IHP_BRAM_top_switch_matrix.WW4BEG1 net221 VPWR
+ VGND sg13g2_buf_1
X_1666_ Tile_X0Y1_FrameData[9] Tile_X0Y1_FrameStrobe[9] Tile_X0Y1_IHP_BRAM_bot.Inst_IHP_BRAM_bot_ConfigMem.Inst_frame9_bit9.Q
+ VPWR VGND sg13g2_dlhq_1
XFILLER_105_37 VPWR VGND sg13g2_fill_1
XFILLER_85_213 VPWR VGND sg13g2_fill_2
X_0617_ Tile_X0Y0_E2MID[1] Tile_X0Y0_IHP_BRAM_top.Inst_IHP_BRAM_top_ConfigMem.Inst_frame3_bit10.Q
+ Tile_X0Y0_IHP_BRAM_top.Inst_IHP_BRAM_top_ConfigMem.Inst_frame3_bit11.Q _0118_ VPWR
+ VGND sg13g2_nor3_1
X_0548_ Tile_X0Y0_IHP_BRAM_top.Inst_IHP_BRAM_top_ConfigMem.Inst_frame7_bit30.Q A_DOUT_BRAM15
+ B_DOUT_BRAM15 Tile_X0Y0_IHP_BRAM_top.Inst_IHP_BRAM_top_switch_matrix.J_NS2_BEG0
+ Tile_X0Y0_IHP_BRAM_top.Inst_IHP_BRAM_top_switch_matrix.J_NS2_BEG7 Tile_X0Y0_IHP_BRAM_top.Inst_IHP_BRAM_top_ConfigMem.Inst_frame7_bit31.Q
+ Tile_X0Y0_IHP_BRAM_top.Inst_IHP_BRAM_top_switch_matrix.W2BEG7 VPWR VGND sg13g2_mux4_1
X_1597_ Tile_X0Y1_FrameData[14] Tile_X0Y1_FrameStrobe[7] Tile_X0Y1_IHP_BRAM_bot.Inst_IHP_BRAM_bot_ConfigMem.Inst_frame7_bit14.Q
+ VPWR VGND sg13g2_dlhq_1
X_0479_ Tile_X0Y1_IHP_BRAM_bot.Inst_IHP_BRAM_bot_ConfigMem.Inst_frame0_bit28.Q Tile_X0Y1_N1END[2]
+ _0091_ VPWR VGND sg13g2_nor2b_1
XFILLER_53_143 VPWR VGND sg13g2_decap_8
XFILLER_53_154 VPWR VGND sg13g2_fill_1
XFILLER_107_156 VPWR VGND sg13g2_decap_8
XFILLER_30_77 VPWR VGND sg13g2_fill_2
XFILLER_29_184 VPWR VGND sg13g2_fill_2
XFILLER_44_154 VPWR VGND sg13g2_fill_2
XFILLER_72_8 VPWR VGND sg13g2_fill_2
X_1520_ Tile_X0Y1_FrameData[27] Tile_X0Y1_FrameStrobe[5] Tile_X0Y1_IHP_BRAM_bot.Inst_IHP_BRAM_bot_ConfigMem.Inst_frame5_bit27.Q
+ VPWR VGND sg13g2_dlhq_1
Xoutput319 net319 Tile_X0Y1_W6BEG[10] VPWR VGND sg13g2_buf_1
Xoutput308 net308 Tile_X0Y1_W2BEG[6] VPWR VGND sg13g2_buf_1
X_1451_ Tile_X0Y1_FrameData[0] Tile_X0Y1_FrameStrobe[2] Tile_X0Y1_IHP_BRAM_bot.Inst_IHP_BRAM_bot_ConfigMem.Inst_frame2_bit0.Q
+ VPWR VGND sg13g2_dlhq_1
X_1382_ Tile_X0Y1_FrameData[5] Tile_X0Y1_FrameStrobe[0] Tile_X0Y1_IHP_BRAM_bot.Inst_IHP_BRAM_bot_ConfigMem.Inst_frame0_bit5.Q
+ VPWR VGND sg13g2_dlhq_1
X_0402_ VPWR _0025_ Tile_X0Y1_IHP_BRAM_bot.Inst_IHP_BRAM_bot_ConfigMem.Inst_frame9_bit30.Q
+ VGND sg13g2_inv_1
X_1718_ Tile_X0Y1_FrameStrobe[4] net139 VPWR VGND sg13g2_buf_1
X_1649_ Tile_X0Y1_FrameData[26] Tile_X0Y1_FrameStrobe[9] Tile_X0Y1_IHP_BRAM_bot.Inst_IHP_BRAM_bot_ConfigMem.Inst_frame9_bit26.Q
+ VPWR VGND sg13g2_dlhq_1
XFILLER_76_18 VPWR VGND sg13g2_fill_2
XFILLER_26_121 VPWR VGND sg13g2_decap_4
XFILLER_2_48 VPWR VGND sg13g2_fill_1
X_0882_ Tile_X0Y1_IHP_BRAM_bot.Inst_IHP_BRAM_bot_ConfigMem.Inst_frame2_bit0.Q Tile_X0Y1_E2MID[1]
+ _0253_ VPWR VGND sg13g2_nor2b_1
X_0951_ _0027_ _0104_ _0299_ VPWR VGND sg13g2_nor2_1
Xoutput138 net138 Tile_X0Y0_FrameStrobe_O[3] VPWR VGND sg13g2_buf_1
Xoutput149 net149 Tile_X0Y0_N2BEG[0] VPWR VGND sg13g2_buf_1
Xoutput127 net127 Tile_X0Y0_FrameStrobe_O[11] VPWR VGND sg13g2_buf_1
Xoutput116 net116 Tile_X0Y0_FrameData_O[30] VPWR VGND sg13g2_buf_1
Xoutput105 net105 Tile_X0Y0_FrameData_O[20] VPWR VGND sg13g2_buf_1
XFILLER_63_4 VPWR VGND sg13g2_fill_2
X_1503_ Tile_X0Y1_FrameData[12] Tile_X0Y1_FrameStrobe[4] Tile_X0Y1_IHP_BRAM_bot.Inst_IHP_BRAM_bot_ConfigMem.Inst_frame4_bit12.Q
+ VPWR VGND sg13g2_dlhq_1
X_1296_ Tile_X0Y0_FrameData[27] Tile_X0Y1_FrameStrobe[8] Tile_X0Y0_IHP_BRAM_top.Inst_IHP_BRAM_top_ConfigMem.Inst_frame8_bit27.Q
+ VPWR VGND sg13g2_dlhq_1
X_1434_ Tile_X0Y1_FrameData[17] Tile_X0Y1_FrameStrobe[2] Tile_X0Y1_IHP_BRAM_bot.Inst_IHP_BRAM_bot_ConfigMem.Inst_frame2_bit17.Q
+ VPWR VGND sg13g2_dlhq_1
X_1365_ Tile_X0Y1_FrameData[22] Tile_X0Y1_FrameStrobe[0] Tile_X0Y1_IHP_BRAM_bot.Inst_IHP_BRAM_bot_ConfigMem.Inst_frame0_bit22.Q
+ VPWR VGND sg13g2_dlhq_1
XFILLER_11_35 VPWR VGND sg13g2_fill_1
XFILLER_14_102 VPWR VGND sg13g2_fill_1
XFILLER_36_87 VPWR VGND sg13g2_fill_2
XFILLER_14_124 VPWR VGND sg13g2_fill_2
XFILLER_52_64 VPWR VGND sg13g2_decap_4
XFILLER_77_83 VPWR VGND sg13g2_decap_8
XFILLER_77_72 VPWR VGND sg13g2_fill_1
X_1150_ Tile_X0Y0_FrameData[13] Tile_X0Y1_FrameStrobe[3] Tile_X0Y0_IHP_BRAM_top.Inst_IHP_BRAM_top_ConfigMem.Inst_frame3_bit13.Q
+ VPWR VGND sg13g2_dlhq_1
X_1081_ Tile_X0Y0_FrameData[18] Tile_X0Y1_FrameStrobe[1] Tile_X0Y0_IHP_BRAM_top.Inst_IHP_BRAM_top_ConfigMem.Inst_frame1_bit18.Q
+ VPWR VGND sg13g2_dlhq_1
X_0865_ Tile_X0Y1_IHP_BRAM_bot.Inst_IHP_BRAM_bot_ConfigMem.Inst_frame4_bit26.Q Tile_X0Y1_EE4END[4]
+ Tile_X0Y1_EE4END[12] Tile_X0Y1_E6END[4] Tile_X0Y1_IHP_BRAM_bot.Inst_IHP_BRAM_bot_switch_matrix.J_NS4_BEG4
+ Tile_X0Y1_IHP_BRAM_bot.Inst_IHP_BRAM_bot_ConfigMem.Inst_frame4_bit27.Q net38 VPWR
+ VGND sg13g2_mux4_1
X_0934_ VGND VPWR _0276_ _0278_ Tile_X0Y0_IHP_BRAM_top.N4BEG_outbuf_9.A _0283_ sg13g2_a21oi_1
X_0796_ Tile_X0Y1_IHP_BRAM_bot.Inst_IHP_BRAM_bot_ConfigMem.Inst_frame6_bit6.Q A_DOUT_BRAM3
+ B_DOUT_BRAM3 _0104_ _0105_ Tile_X0Y1_IHP_BRAM_bot.Inst_IHP_BRAM_bot_ConfigMem.Inst_frame6_bit7.Q
+ Tile_X0Y1_IHP_BRAM_bot.Inst_IHP_BRAM_bot_switch_matrix.W2BEGb3 VPWR VGND sg13g2_mux4_1
X_1417_ Tile_X0Y1_FrameData[2] Tile_X0Y1_FrameStrobe[1] Tile_X0Y1_IHP_BRAM_bot.Inst_IHP_BRAM_bot_ConfigMem.Inst_frame1_bit2.Q
+ VPWR VGND sg13g2_dlhq_1
X_1348_ Tile_X0Y0_FrameData[7] Tile_X0Y1_FrameStrobe[9] Tile_X0Y0_IHP_BRAM_top.Inst_IHP_BRAM_top_ConfigMem.Inst_frame9_bit7.Q
+ VPWR VGND sg13g2_dlhq_1
X_1279_ Tile_X0Y0_FrameData[12] Tile_X0Y1_FrameStrobe[7] Tile_X0Y0_IHP_BRAM_top.Inst_IHP_BRAM_top_ConfigMem.Inst_frame7_bit12.Q
+ VPWR VGND sg13g2_dlhq_1
XFILLER_22_12 VPWR VGND sg13g2_fill_2
XFILLER_8_36 VPWR VGND sg13g2_fill_1
XFILLER_8_14 VPWR VGND sg13g2_fill_1
XFILLER_88_93 VPWR VGND sg13g2_fill_1
X_0650_ VPWR VGND Tile_X0Y0_IHP_BRAM_top.Inst_IHP_BRAM_top_ConfigMem.Inst_frame2_bit20.Q
+ _0128_ _0129_ Tile_X0Y0_IHP_BRAM_top.Inst_IHP_BRAM_top_ConfigMem.Inst_frame2_bit21.Q
+ net53 _0042_ sg13g2_a221oi_1
X_0581_ Tile_X0Y0_IHP_BRAM_top.Inst_IHP_BRAM_top_ConfigMem.Inst_frame5_bit10.Q A_DOUT_BRAM9
+ B_DOUT_BRAM13 Tile_X0Y0_IHP_BRAM_top.Inst_IHP_BRAM_top_switch_matrix.J_NS4_BEG2
+ Tile_X0Y0_IHP_BRAM_top.Inst_IHP_BRAM_top_switch_matrix.J_NS2_BEG2 Tile_X0Y0_IHP_BRAM_top.Inst_IHP_BRAM_top_ConfigMem.Inst_frame5_bit11.Q
+ Tile_X0Y0_IHP_BRAM_top.Inst_IHP_BRAM_top_switch_matrix.WW4BEG13 VPWR VGND sg13g2_mux4_1
X_1064_ Tile_X0Y0_FrameData[3] Tile_X0Y1_FrameStrobe[0] Tile_X0Y0_IHP_BRAM_top.Inst_IHP_BRAM_top_ConfigMem.Inst_frame0_bit3.Q
+ VPWR VGND sg13g2_dlhq_1
X_1133_ Tile_X0Y0_FrameData[30] Tile_X0Y1_FrameStrobe[3] Tile_X0Y0_IHP_BRAM_top.Inst_IHP_BRAM_top_ConfigMem.Inst_frame3_bit30.Q
+ VPWR VGND sg13g2_dlhq_1
X_1202_ Tile_X0Y0_FrameData[25] Tile_X0Y1_FrameStrobe[5] Tile_X0Y0_IHP_BRAM_top.Inst_IHP_BRAM_top_ConfigMem.Inst_frame5_bit25.Q
+ VPWR VGND sg13g2_dlhq_1
XFILLER_108_37 VPWR VGND sg13g2_fill_2
X_0848_ _0237_ VPWR net2 VGND Tile_X0Y1_IHP_BRAM_bot.Inst_IHP_BRAM_bot_ConfigMem.Inst_frame4_bit11.Q
+ _0239_ sg13g2_o21ai_1
X_1897_ Tile_X0Y1_IHP_BRAM_bot.Inst_IHP_BRAM_bot_switch_matrix.W2BEG6 net308 VPWR
+ VGND sg13g2_buf_1
X_0917_ VGND VPWR _0022_ _0267_ _0268_ Tile_X0Y1_IHP_BRAM_bot.Inst_IHP_BRAM_bot_ConfigMem.Inst_frame9_bit26.Q
+ sg13g2_a21oi_1
X_0779_ Tile_X0Y1_IHP_BRAM_bot.Inst_IHP_BRAM_bot_ConfigMem.Inst_frame8_bit25.Q Tile_X0Y1_E1END[2]
+ Tile_X0Y1_E2END[1] Tile_X0Y1_E2MID[1] _0046_ Tile_X0Y1_IHP_BRAM_bot.Inst_IHP_BRAM_bot_ConfigMem.Inst_frame8_bit24.Q
+ Tile_X0Y1_IHP_BRAM_bot.Inst_IHP_BRAM_bot_switch_matrix.S2BEG6 VPWR VGND sg13g2_mux4_1
XFILLER_17_89 VPWR VGND sg13g2_fill_1
XFILLER_58_96 VPWR VGND sg13g2_decap_4
XFILLER_58_74 VPWR VGND sg13g2_decap_4
X_1820_ Tile_X0Y1_FrameData[1] net241 VPWR VGND sg13g2_buf_1
X_0702_ Tile_X0Y0_IHP_BRAM_top.Inst_IHP_BRAM_top_ConfigMem.Inst_frame7_bit0.Q VPWR
+ _0173_ VGND Tile_X0Y0_IHP_BRAM_top.Inst_IHP_BRAM_top_ConfigMem.Inst_frame8_bit31.Q
+ Tile_X0Y0_IHP_BRAM_top.Inst_IHP_BRAM_top_switch_matrix.J_NS4_BEG13 sg13g2_o21ai_1
XFILLER_99_70 VPWR VGND sg13g2_fill_2
X_1751_ Tile_X0Y0_IHP_BRAM_top.Inst_IHP_BRAM_top_switch_matrix.N2BEGb5 net162 VPWR
+ VGND sg13g2_buf_1
XFILLER_90_94 VPWR VGND sg13g2_fill_2
X_1682_ Tile_X0Y0_FrameData[0] net93 VPWR VGND sg13g2_buf_1
X_0633_ Tile_X0Y0_IHP_BRAM_top.Inst_IHP_BRAM_top_ConfigMem.Inst_frame3_bit26.Q Tile_X0Y0_E1END[0]
+ Tile_X0Y0_EE4END[4] Tile_X0Y0_EE4END[12] Tile_X0Y0_IHP_BRAM_top.Inst_IHP_BRAM_top_switch_matrix.J_NS4_BEG12
+ Tile_X0Y0_IHP_BRAM_top.Inst_IHP_BRAM_top_ConfigMem.Inst_frame3_bit27.Q net78 VPWR
+ VGND sg13g2_mux4_1
X_0564_ Tile_X0Y0_IHP_BRAM_top.Inst_IHP_BRAM_top_ConfigMem.Inst_frame1_bit28.Q Tile_X0Y0_IHP_BRAM_top.Inst_IHP_BRAM_top_switch_matrix.N1END2
+ Tile_X0Y1_N4END[6] Tile_X0Y0_S1END[2] Tile_X0Y0_S4END[2] Tile_X0Y0_IHP_BRAM_top.Inst_IHP_BRAM_top_ConfigMem.Inst_frame1_bit29.Q
+ Tile_X0Y0_IHP_BRAM_top.Inst_IHP_BRAM_top_switch_matrix.J_NS4_BEG10 VPWR VGND sg13g2_mux4_1
XFILLER_97_211 VPWR VGND sg13g2_fill_1
X_0495_ Tile_X0Y0_IHP_BRAM_top.Inst_IHP_BRAM_top_ConfigMem.Inst_frame9_bit6.Q Tile_X0Y0_E1END[3]
+ Tile_X0Y0_E6END[7] Tile_X0Y0_IHP_BRAM_top.Inst_IHP_BRAM_top_switch_matrix.J_NS4_BEG15
+ _0096_ Tile_X0Y0_IHP_BRAM_top.Inst_IHP_BRAM_top_ConfigMem.Inst_frame9_bit7.Q Tile_X0Y0_IHP_BRAM_top.Inst_IHP_BRAM_top_switch_matrix.N1BEG3
+ VPWR VGND sg13g2_mux4_1
XFILLER_57_119 VPWR VGND sg13g2_decap_8
X_1047_ Tile_X0Y0_FrameData[20] Tile_X0Y1_FrameStrobe[0] Tile_X0Y0_IHP_BRAM_top.Inst_IHP_BRAM_top_ConfigMem.Inst_frame0_bit20.Q
+ VPWR VGND sg13g2_dlhq_1
X_1116_ Tile_X0Y0_FrameData[15] Tile_X0Y1_FrameStrobe[2] Tile_X0Y0_IHP_BRAM_top.Inst_IHP_BRAM_top_ConfigMem.Inst_frame2_bit15.Q
+ VPWR VGND sg13g2_dlhq_1
XFILLER_80_166 VPWR VGND sg13g2_fill_1
XFILLER_8_215 VPWR VGND sg13g2_fill_1
XFILLER_79_211 VPWR VGND sg13g2_fill_1
XFILLER_62_111 VPWR VGND sg13g2_decap_8
X_1803_ Tile_X0Y0_IHP_BRAM_top.Inst_IHP_BRAM_top_switch_matrix.WW4BEG0 net214 VPWR
+ VGND sg13g2_buf_1
X_1734_ Tile_X0Y0_IHP_BRAM_top.Inst_IHP_BRAM_top_switch_matrix.N1BEG0 net145 VPWR
+ VGND sg13g2_buf_1
X_0616_ VPWR VGND Tile_X0Y0_IHP_BRAM_top.Inst_IHP_BRAM_top_ConfigMem.Inst_frame3_bit8.Q
+ _0116_ _0117_ Tile_X0Y0_IHP_BRAM_top.Inst_IHP_BRAM_top_ConfigMem.Inst_frame3_bit9.Q
+ net6 _0041_ sg13g2_a221oi_1
X_1596_ Tile_X0Y1_FrameData[15] Tile_X0Y1_FrameStrobe[7] Tile_X0Y1_IHP_BRAM_bot.Inst_IHP_BRAM_bot_ConfigMem.Inst_frame7_bit15.Q
+ VPWR VGND sg13g2_dlhq_1
X_1665_ Tile_X0Y1_FrameData[10] Tile_X0Y1_FrameStrobe[9] Tile_X0Y1_IHP_BRAM_bot.Inst_IHP_BRAM_bot_ConfigMem.Inst_frame9_bit10.Q
+ VPWR VGND sg13g2_dlhq_1
X_0547_ Tile_X0Y0_IHP_BRAM_top.Inst_IHP_BRAM_top_ConfigMem.Inst_frame7_bit28.Q A_DOUT_BRAM14
+ B_DOUT_BRAM14 Tile_X0Y0_IHP_BRAM_top.Inst_IHP_BRAM_top_switch_matrix.J_NS2_BEG1
+ Tile_X0Y0_IHP_BRAM_top.Inst_IHP_BRAM_top_switch_matrix.J_NS2_BEG6 Tile_X0Y0_IHP_BRAM_top.Inst_IHP_BRAM_top_ConfigMem.Inst_frame7_bit29.Q
+ Tile_X0Y0_IHP_BRAM_top.Inst_IHP_BRAM_top_switch_matrix.W2BEG6 VPWR VGND sg13g2_mux4_1
X_0478_ Tile_X0Y1_IHP_BRAM_bot.Inst_IHP_BRAM_bot_ConfigMem.Inst_frame0_bit29.Q _0089_
+ _0090_ VPWR VGND Tile_X0Y1_IHP_BRAM_bot.Inst_IHP_BRAM_bot_ConfigMem.Inst_frame0_bit28.Q
+ sg13g2_nand3b_1
XFILLER_53_166 VPWR VGND sg13g2_decap_4
XFILLER_53_188 VPWR VGND sg13g2_fill_1
XFILLER_30_56 VPWR VGND sg13g2_decap_4
XFILLER_76_214 VPWR VGND sg13g2_fill_2
XFILLER_55_86 VPWR VGND sg13g2_decap_8
XFILLER_71_52 VPWR VGND sg13g2_decap_8
X_1450_ Tile_X0Y1_FrameData[1] Tile_X0Y1_FrameStrobe[2] Tile_X0Y1_IHP_BRAM_bot.Inst_IHP_BRAM_bot_ConfigMem.Inst_frame2_bit1.Q
+ VPWR VGND sg13g2_dlhq_1
Xoutput309 net309 Tile_X0Y1_W2BEG[7] VPWR VGND sg13g2_buf_1
X_1381_ Tile_X0Y1_FrameData[6] Tile_X0Y1_FrameStrobe[0] Tile_X0Y1_IHP_BRAM_bot.Inst_IHP_BRAM_bot_ConfigMem.Inst_frame0_bit6.Q
+ VPWR VGND sg13g2_dlhq_1
X_0401_ VPWR _0024_ Tile_X0Y1_IHP_BRAM_bot.Inst_IHP_BRAM_bot_ConfigMem.Inst_frame9_bit28.Q
+ VGND sg13g2_inv_1
XFILLER_84_0 VPWR VGND sg13g2_decap_4
X_1717_ Tile_X0Y1_FrameStrobe[3] net138 VPWR VGND sg13g2_buf_1
X_1579_ Tile_X0Y1_FrameData[0] Tile_X0Y1_FrameStrobe[6] Tile_X0Y1_IHP_BRAM_bot.Inst_IHP_BRAM_bot_ConfigMem.Inst_frame6_bit0.Q
+ VPWR VGND sg13g2_dlhq_1
X_1648_ Tile_X0Y1_FrameData[27] Tile_X0Y1_FrameStrobe[9] Tile_X0Y1_IHP_BRAM_bot.Inst_IHP_BRAM_bot_ConfigMem.Inst_frame9_bit27.Q
+ VPWR VGND sg13g2_dlhq_1
XFILLER_25_12 VPWR VGND sg13g2_fill_2
XFILLER_106_81 VPWR VGND sg13g2_fill_1
XFILLER_17_122 VPWR VGND sg13g2_fill_1
XFILLER_32_103 VPWR VGND sg13g2_fill_2
X_0881_ Tile_X0Y1_IHP_BRAM_bot.Inst_IHP_BRAM_bot_ConfigMem.Inst_frame2_bit1.Q _0102_
+ _0252_ VPWR VGND Tile_X0Y1_IHP_BRAM_bot.Inst_IHP_BRAM_bot_ConfigMem.Inst_frame2_bit0.Q
+ sg13g2_nand3b_1
X_0950_ VGND VPWR _0028_ _0297_ _0298_ Tile_X0Y1_IHP_BRAM_bot.Inst_IHP_BRAM_bot_ConfigMem.Inst_frame8_bit3.Q
+ sg13g2_a21oi_1
Xoutput139 net139 Tile_X0Y0_FrameStrobe_O[4] VPWR VGND sg13g2_buf_1
Xoutput117 net117 Tile_X0Y0_FrameData_O[31] VPWR VGND sg13g2_buf_1
Xoutput128 net128 Tile_X0Y0_FrameStrobe_O[12] VPWR VGND sg13g2_buf_1
Xoutput106 net106 Tile_X0Y0_FrameData_O[21] VPWR VGND sg13g2_buf_1
X_1502_ Tile_X0Y1_FrameData[13] Tile_X0Y1_FrameStrobe[4] Tile_X0Y1_IHP_BRAM_bot.Inst_IHP_BRAM_bot_ConfigMem.Inst_frame4_bit13.Q
+ VPWR VGND sg13g2_dlhq_1
X_1433_ Tile_X0Y1_FrameData[18] Tile_X0Y1_FrameStrobe[2] Tile_X0Y1_IHP_BRAM_bot.Inst_IHP_BRAM_bot_ConfigMem.Inst_frame2_bit18.Q
+ VPWR VGND sg13g2_dlhq_1
X_1295_ Tile_X0Y0_FrameData[28] Tile_X0Y1_FrameStrobe[8] Tile_X0Y0_IHP_BRAM_top.Inst_IHP_BRAM_top_ConfigMem.Inst_frame8_bit28.Q
+ VPWR VGND sg13g2_dlhq_1
XFILLER_70_209 VPWR VGND sg13g2_fill_2
X_1364_ Tile_X0Y1_FrameData[23] Tile_X0Y1_FrameStrobe[0] Tile_X0Y1_IHP_BRAM_bot.Inst_IHP_BRAM_bot_ConfigMem.Inst_frame0_bit23.Q
+ VPWR VGND sg13g2_dlhq_1
XFILLER_36_55 VPWR VGND sg13g2_fill_1
XFILLER_52_87 VPWR VGND sg13g2_fill_1
XFILLER_96_117 VPWR VGND sg13g2_fill_1
X_1080_ Tile_X0Y0_FrameData[19] Tile_X0Y1_FrameStrobe[1] Tile_X0Y0_IHP_BRAM_top.Inst_IHP_BRAM_top_ConfigMem.Inst_frame1_bit19.Q
+ VPWR VGND sg13g2_dlhq_1
XFILLER_93_72 VPWR VGND sg13g2_fill_1
XFILLER_20_128 VPWR VGND sg13g2_fill_2
XFILLER_9_140 VPWR VGND sg13g2_fill_2
X_0795_ Tile_X0Y1_IHP_BRAM_bot.Inst_IHP_BRAM_bot_ConfigMem.Inst_frame6_bit4.Q A_DOUT_BRAM2
+ B_DOUT_BRAM2 _0103_ _0106_ Tile_X0Y1_IHP_BRAM_bot.Inst_IHP_BRAM_bot_ConfigMem.Inst_frame6_bit5.Q
+ Tile_X0Y1_IHP_BRAM_bot.Inst_IHP_BRAM_bot_switch_matrix.W2BEGb2 VPWR VGND sg13g2_mux4_1
X_0864_ Tile_X0Y1_IHP_BRAM_bot.Inst_IHP_BRAM_bot_ConfigMem.Inst_frame4_bit24.Q Tile_X0Y1_EE4END[3]
+ Tile_X0Y1_EE4END[11] Tile_X0Y1_E6END[3] _0230_ Tile_X0Y1_IHP_BRAM_bot.Inst_IHP_BRAM_bot_ConfigMem.Inst_frame4_bit25.Q
+ net37 VPWR VGND sg13g2_mux4_1
X_0933_ VGND VPWR _0024_ _0281_ _0283_ _0282_ sg13g2_a21oi_1
X_1347_ Tile_X0Y0_FrameData[8] Tile_X0Y1_FrameStrobe[9] Tile_X0Y0_IHP_BRAM_top.Inst_IHP_BRAM_top_ConfigMem.Inst_frame9_bit8.Q
+ VPWR VGND sg13g2_dlhq_1
X_1416_ Tile_X0Y1_FrameData[3] Tile_X0Y1_FrameStrobe[1] Tile_X0Y1_IHP_BRAM_bot.Inst_IHP_BRAM_bot_ConfigMem.Inst_frame1_bit3.Q
+ VPWR VGND sg13g2_dlhq_1
XFILLER_47_0 VPWR VGND sg13g2_decap_8
XFILLER_43_209 VPWR VGND sg13g2_fill_2
X_1278_ Tile_X0Y0_FrameData[13] Tile_X0Y1_FrameStrobe[7] Tile_X0Y0_IHP_BRAM_top.Inst_IHP_BRAM_top_ConfigMem.Inst_frame7_bit13.Q
+ VPWR VGND sg13g2_dlhq_1
XFILLER_78_139 VPWR VGND sg13g2_decap_4
XFILLER_111_214 VPWR VGND sg13g2_fill_2
X_0580_ Tile_X0Y0_IHP_BRAM_top.Inst_IHP_BRAM_top_ConfigMem.Inst_frame1_bit12.Q Tile_X0Y0_IHP_BRAM_top.Inst_IHP_BRAM_top_switch_matrix.N1END2
+ Tile_X0Y1_N4END[6] Tile_X0Y0_S1END[2] Tile_X0Y0_S4END[2] Tile_X0Y0_IHP_BRAM_top.Inst_IHP_BRAM_top_ConfigMem.Inst_frame1_bit13.Q
+ Tile_X0Y0_IHP_BRAM_top.Inst_IHP_BRAM_top_switch_matrix.J_NS4_BEG2 VPWR VGND sg13g2_mux4_1
X_1201_ Tile_X0Y0_FrameData[26] Tile_X0Y1_FrameStrobe[5] Tile_X0Y0_IHP_BRAM_top.Inst_IHP_BRAM_top_ConfigMem.Inst_frame5_bit26.Q
+ VPWR VGND sg13g2_dlhq_1
X_1063_ Tile_X0Y0_FrameData[4] Tile_X0Y1_FrameStrobe[0] Tile_X0Y0_IHP_BRAM_top.Inst_IHP_BRAM_top_ConfigMem.Inst_frame0_bit4.Q
+ VPWR VGND sg13g2_dlhq_1
X_1132_ Tile_X0Y0_FrameData[31] Tile_X0Y1_FrameStrobe[3] Tile_X0Y0_IHP_BRAM_top.Inst_IHP_BRAM_top_ConfigMem.Inst_frame3_bit31.Q
+ VPWR VGND sg13g2_dlhq_1
X_0916_ Tile_X0Y1_E1END[0] Tile_X0Y1_EE4END[0] Tile_X0Y1_IHP_BRAM_bot.Inst_IHP_BRAM_bot_ConfigMem.Inst_frame9_bit24.Q
+ _0267_ VPWR VGND sg13g2_mux2_1
X_1896_ Tile_X0Y1_IHP_BRAM_bot.Inst_IHP_BRAM_bot_switch_matrix.W2BEG5 net307 VPWR
+ VGND sg13g2_buf_1
X_0847_ VGND VPWR Tile_X0Y1_E2END[1] Tile_X0Y1_IHP_BRAM_bot.Inst_IHP_BRAM_bot_ConfigMem.Inst_frame4_bit10.Q
+ _0239_ _0238_ sg13g2_a21oi_1
X_0778_ Tile_X0Y1_IHP_BRAM_bot.Inst_IHP_BRAM_bot_ConfigMem.Inst_frame8_bit22.Q Tile_X0Y1_E1END[1]
+ Tile_X0Y1_E2MID[2] Tile_X0Y1_E2END[2] _0106_ Tile_X0Y1_IHP_BRAM_bot.Inst_IHP_BRAM_bot_ConfigMem.Inst_frame8_bit23.Q
+ Tile_X0Y1_IHP_BRAM_bot.Inst_IHP_BRAM_bot_switch_matrix.S2BEG5 VPWR VGND sg13g2_mux4_1
XFILLER_33_34 VPWR VGND sg13g2_fill_2
XFILLER_74_63 VPWR VGND sg13g2_fill_2
X_1750_ Tile_X0Y0_IHP_BRAM_top.Inst_IHP_BRAM_top_switch_matrix.N2BEGb4 net161 VPWR
+ VGND sg13g2_buf_1
XFILLER_88_7 VPWR VGND sg13g2_fill_2
X_0701_ Tile_X0Y0_IHP_BRAM_top.Inst_IHP_BRAM_top_switch_matrix.J_NS2_BEG5 Tile_X0Y0_IHP_BRAM_top.Inst_IHP_BRAM_top_ConfigMem.Inst_frame8_bit31.Q
+ _0172_ VPWR VGND sg13g2_nor2b_1
X_0632_ Tile_X0Y0_IHP_BRAM_top.Inst_IHP_BRAM_top_ConfigMem.Inst_frame3_bit24.Q Tile_X0Y0_EE4END[3]
+ Tile_X0Y0_EE4END[11] Tile_X0Y0_E6END[11] Tile_X0Y0_IHP_BRAM_top.Inst_IHP_BRAM_top_switch_matrix.J_NS4_BEG11
+ Tile_X0Y0_IHP_BRAM_top.Inst_IHP_BRAM_top_ConfigMem.Inst_frame3_bit25.Q net77 VPWR
+ VGND sg13g2_mux4_1
X_0563_ Tile_X0Y0_IHP_BRAM_top.Inst_IHP_BRAM_top_ConfigMem.Inst_frame6_bit24.Q A_DOUT_BRAM12
+ B_DOUT_BRAM8 Tile_X0Y0_IHP_BRAM_top.Inst_IHP_BRAM_top_switch_matrix.J_NS4_BEG11
+ Tile_X0Y0_IHP_BRAM_top.Inst_IHP_BRAM_top_switch_matrix.J_NS2_BEG3 Tile_X0Y0_IHP_BRAM_top.Inst_IHP_BRAM_top_ConfigMem.Inst_frame6_bit25.Q
+ Tile_X0Y0_IHP_BRAM_top.Inst_IHP_BRAM_top_switch_matrix.WW4BEG4 VPWR VGND sg13g2_mux4_1
X_1681_ clknet_1_0__leaf_Tile_X0Y1_UserCLK net73 VPWR VGND sg13g2_buf_1
X_0494_ Tile_X0Y0_IHP_BRAM_top.Inst_IHP_BRAM_top_ConfigMem.Inst_frame0_bit6.Q Tile_X0Y0_IHP_BRAM_top.Inst_IHP_BRAM_top_switch_matrix.N1END3
+ Tile_X0Y1_N4END[7] Tile_X0Y0_S1END[3] Tile_X0Y0_S4END[3] Tile_X0Y0_IHP_BRAM_top.Inst_IHP_BRAM_top_ConfigMem.Inst_frame0_bit7.Q
+ Tile_X0Y0_IHP_BRAM_top.Inst_IHP_BRAM_top_switch_matrix.J_NS4_BEG15 VPWR VGND sg13g2_mux4_1
X_1046_ Tile_X0Y0_FrameData[21] Tile_X0Y1_FrameStrobe[0] Tile_X0Y0_IHP_BRAM_top.Inst_IHP_BRAM_top_ConfigMem.Inst_frame0_bit21.Q
+ VPWR VGND sg13g2_dlhq_1
XFILLER_80_101 VPWR VGND sg13g2_decap_4
X_1115_ Tile_X0Y0_FrameData[16] Tile_X0Y1_FrameStrobe[2] Tile_X0Y0_IHP_BRAM_top.Inst_IHP_BRAM_top_ConfigMem.Inst_frame2_bit16.Q
+ VPWR VGND sg13g2_dlhq_1
X_1879_ Tile_X0Y0_IHP_BRAM_top.Inst_IHP_BRAM_top_switch_matrix.S4BEG0 net296 VPWR
+ VGND sg13g2_buf_1
XFILLER_95_18 VPWR VGND sg13g2_fill_2
XFILLER_44_77 VPWR VGND sg13g2_fill_1
XFILLER_62_156 VPWR VGND sg13g2_fill_1
XFILLER_47_186 VPWR VGND sg13g2_fill_2
X_1733_ Tile_X0Y1_FrameStrobe[19] net135 VPWR VGND sg13g2_buf_1
X_1802_ Tile_X0Y0_IHP_BRAM_top.Inst_IHP_BRAM_top_switch_matrix.W6BEG11 net204 VPWR
+ VGND sg13g2_buf_1
X_0546_ Tile_X0Y0_IHP_BRAM_top.Inst_IHP_BRAM_top_ConfigMem.Inst_frame7_bit26.Q A_DOUT_BRAM13
+ B_DOUT_BRAM13 Tile_X0Y0_IHP_BRAM_top.Inst_IHP_BRAM_top_switch_matrix.J_NS2_BEG2
+ Tile_X0Y0_IHP_BRAM_top.Inst_IHP_BRAM_top_switch_matrix.J_NS2_BEG5 Tile_X0Y0_IHP_BRAM_top.Inst_IHP_BRAM_top_ConfigMem.Inst_frame7_bit27.Q
+ Tile_X0Y0_IHP_BRAM_top.Inst_IHP_BRAM_top_switch_matrix.W2BEG5 VPWR VGND sg13g2_mux4_1
X_0615_ _0117_ Tile_X0Y0_E2END[0] Tile_X0Y0_IHP_BRAM_top.Inst_IHP_BRAM_top_ConfigMem.Inst_frame3_bit9.Q
+ VPWR VGND sg13g2_nand2b_1
X_1595_ Tile_X0Y1_FrameData[16] Tile_X0Y1_FrameStrobe[7] Tile_X0Y1_IHP_BRAM_bot.Inst_IHP_BRAM_bot_ConfigMem.Inst_frame7_bit16.Q
+ VPWR VGND sg13g2_dlhq_1
X_1664_ Tile_X0Y1_FrameData[11] Tile_X0Y1_FrameStrobe[9] Tile_X0Y1_IHP_BRAM_bot.Inst_IHP_BRAM_bot_ConfigMem.Inst_frame9_bit11.Q
+ VPWR VGND sg13g2_dlhq_1
X_0477_ Tile_X0Y0_IHP_BRAM_top.Inst_IHP_BRAM_top_ConfigMem.Inst_frame8_bit8.Q Tile_X0Y0_E1END[2]
+ Tile_X0Y0_E6END[10] Tile_X0Y0_IHP_BRAM_top.Inst_IHP_BRAM_top_switch_matrix.J_NS4_BEG14
+ _0088_ Tile_X0Y0_IHP_BRAM_top.Inst_IHP_BRAM_top_ConfigMem.Inst_frame8_bit9.Q _0089_
+ VPWR VGND sg13g2_mux4_1
XFILLER_85_215 VPWR VGND sg13g2_fill_1
XFILLER_53_123 VPWR VGND sg13g2_fill_2
X_1029_ VPWR VGND Tile_X0Y1_IHP_BRAM_bot.Inst_IHP_BRAM_bot_ConfigMem.Inst_frame3_bit27.Q
+ Tile_X0Y1_IHP_BRAM_bot.Inst_IHP_BRAM_bot_ConfigMem.Inst_frame3_bit26.Q _0369_ _0006_
+ _0371_ Tile_X0Y1_IHP_BRAM_bot.Inst_IHP_BRAM_bot_ConfigMem.Inst_frame3_bit28.Q sg13g2_a221oi_1
XFILLER_29_186 VPWR VGND sg13g2_fill_1
X_1380_ Tile_X0Y1_FrameData[7] Tile_X0Y1_FrameStrobe[0] Tile_X0Y1_IHP_BRAM_bot.Inst_IHP_BRAM_bot_ConfigMem.Inst_frame0_bit7.Q
+ VPWR VGND sg13g2_dlhq_1
X_0400_ VPWR _0023_ Tile_X0Y1_IHP_BRAM_bot.Inst_IHP_BRAM_bot_ConfigMem.Inst_frame9_bit27.Q
+ VGND sg13g2_inv_1
XFILLER_50_115 VPWR VGND sg13g2_decap_8
X_1716_ Tile_X0Y1_FrameStrobe[2] net137 VPWR VGND sg13g2_buf_1
XFILLER_104_128 VPWR VGND sg13g2_fill_2
X_0529_ Tile_X0Y0_IHP_BRAM_top.Inst_IHP_BRAM_top_ConfigMem.Inst_frame0_bit24.Q Tile_X0Y0_IHP_BRAM_top.Inst_IHP_BRAM_top_ConfigMem.Inst_frame0_bit25.Q
+ Tile_X0Y0_IHP_BRAM_top.Inst_IHP_BRAM_top_switch_matrix.N1END0 _0109_ VPWR VGND sg13g2_nor3_1
X_1578_ Tile_X0Y1_FrameData[1] Tile_X0Y1_FrameStrobe[6] Tile_X0Y1_IHP_BRAM_bot.Inst_IHP_BRAM_bot_ConfigMem.Inst_frame6_bit1.Q
+ VPWR VGND sg13g2_dlhq_1
X_1647_ Tile_X0Y1_FrameData[28] Tile_X0Y1_FrameStrobe[9] Tile_X0Y1_IHP_BRAM_bot.Inst_IHP_BRAM_bot_ConfigMem.Inst_frame9_bit28.Q
+ VPWR VGND sg13g2_dlhq_1
XFILLER_82_74 VPWR VGND sg13g2_decap_8
XFILLER_82_41 VPWR VGND sg13g2_decap_8
XFILLER_17_167 VPWR VGND sg13g2_fill_2
XFILLER_32_126 VPWR VGND sg13g2_decap_8
Xoutput107 net107 Tile_X0Y0_FrameData_O[22] VPWR VGND sg13g2_buf_1
X_0880_ _0249_ VPWR net47 VGND Tile_X0Y1_IHP_BRAM_bot.Inst_IHP_BRAM_bot_ConfigMem.Inst_frame3_bit31.Q
+ _0251_ sg13g2_o21ai_1
Xoutput129 net129 Tile_X0Y0_FrameStrobe_O[13] VPWR VGND sg13g2_buf_1
XFILLER_99_159 VPWR VGND sg13g2_fill_1
XFILLER_99_115 VPWR VGND sg13g2_fill_1
Xoutput118 net118 Tile_X0Y0_FrameData_O[3] VPWR VGND sg13g2_buf_1
X_1363_ Tile_X0Y1_FrameData[24] Tile_X0Y1_FrameStrobe[0] Tile_X0Y1_IHP_BRAM_bot.Inst_IHP_BRAM_bot_ConfigMem.Inst_frame0_bit24.Q
+ VPWR VGND sg13g2_dlhq_1
X_1432_ Tile_X0Y1_FrameData[19] Tile_X0Y1_FrameStrobe[2] Tile_X0Y1_IHP_BRAM_bot.Inst_IHP_BRAM_bot_ConfigMem.Inst_frame2_bit19.Q
+ VPWR VGND sg13g2_dlhq_1
X_1501_ Tile_X0Y1_FrameData[14] Tile_X0Y1_FrameStrobe[4] Tile_X0Y1_IHP_BRAM_bot.Inst_IHP_BRAM_bot_ConfigMem.Inst_frame4_bit14.Q
+ VPWR VGND sg13g2_dlhq_1
XFILLER_102_18 VPWR VGND sg13g2_fill_2
X_1294_ Tile_X0Y0_FrameData[29] Tile_X0Y1_FrameStrobe[8] Tile_X0Y0_IHP_BRAM_top.Inst_IHP_BRAM_top_ConfigMem.Inst_frame8_bit29.Q
+ VPWR VGND sg13g2_dlhq_1
XFILLER_77_63 VPWR VGND sg13g2_decap_8
XFILLER_7_0 VPWR VGND sg13g2_fill_1
X_0932_ Tile_X0Y1_IHP_BRAM_bot.Inst_IHP_BRAM_bot_ConfigMem.Inst_frame9_bit29.Q VPWR
+ _0282_ VGND _0279_ _0280_ sg13g2_o21ai_1
X_0794_ Tile_X0Y1_IHP_BRAM_bot.Inst_IHP_BRAM_bot_ConfigMem.Inst_frame6_bit2.Q A_DOUT_BRAM1
+ B_DOUT_BRAM1 _0102_ _0046_ Tile_X0Y1_IHP_BRAM_bot.Inst_IHP_BRAM_bot_ConfigMem.Inst_frame6_bit3.Q
+ Tile_X0Y1_IHP_BRAM_bot.Inst_IHP_BRAM_bot_switch_matrix.W2BEGb1 VPWR VGND sg13g2_mux4_1
X_0863_ Tile_X0Y1_IHP_BRAM_bot.Inst_IHP_BRAM_bot_ConfigMem.Inst_frame4_bit22.Q Tile_X0Y1_EE4END[2]
+ Tile_X0Y1_EE4END[10] Tile_X0Y1_E6END[2] _0231_ Tile_X0Y1_IHP_BRAM_bot.Inst_IHP_BRAM_bot_ConfigMem.Inst_frame4_bit23.Q
+ net36 VPWR VGND sg13g2_mux4_1
X_1346_ Tile_X0Y0_FrameData[9] Tile_X0Y1_FrameStrobe[9] Tile_X0Y0_IHP_BRAM_top.Inst_IHP_BRAM_top_ConfigMem.Inst_frame9_bit9.Q
+ VPWR VGND sg13g2_dlhq_1
X_1415_ Tile_X0Y1_FrameData[4] Tile_X0Y1_FrameStrobe[1] Tile_X0Y1_IHP_BRAM_bot.Inst_IHP_BRAM_bot_ConfigMem.Inst_frame1_bit4.Q
+ VPWR VGND sg13g2_dlhq_1
X_1277_ Tile_X0Y0_FrameData[14] Tile_X0Y1_FrameStrobe[7] Tile_X0Y0_IHP_BRAM_top.Inst_IHP_BRAM_top_ConfigMem.Inst_frame7_bit14.Q
+ VPWR VGND sg13g2_dlhq_1
XFILLER_22_14 VPWR VGND sg13g2_fill_1
XFILLER_47_88 VPWR VGND sg13g2_fill_1
XFILLER_88_51 VPWR VGND sg13g2_decap_4
X_1200_ Tile_X0Y0_FrameData[27] Tile_X0Y1_FrameStrobe[5] Tile_X0Y0_IHP_BRAM_top.Inst_IHP_BRAM_top_ConfigMem.Inst_frame5_bit27.Q
+ VPWR VGND sg13g2_dlhq_1
XFILLER_69_107 VPWR VGND sg13g2_decap_8
X_1062_ Tile_X0Y0_FrameData[5] Tile_X0Y1_FrameStrobe[0] Tile_X0Y0_IHP_BRAM_top.Inst_IHP_BRAM_top_ConfigMem.Inst_frame0_bit5.Q
+ VPWR VGND sg13g2_dlhq_1
X_1131_ Tile_X0Y0_FrameData[0] Tile_X0Y1_FrameStrobe[2] Tile_X0Y0_IHP_BRAM_top.Inst_IHP_BRAM_top_ConfigMem.Inst_frame2_bit0.Q
+ VPWR VGND sg13g2_dlhq_1
X_1895_ Tile_X0Y1_IHP_BRAM_bot.Inst_IHP_BRAM_bot_switch_matrix.W2BEG4 net306 VPWR
+ VGND sg13g2_buf_1
X_0915_ _0265_ VPWR _0266_ VGND _0021_ _0233_ sg13g2_o21ai_1
X_0846_ Tile_X0Y1_IHP_BRAM_bot.Inst_IHP_BRAM_bot_ConfigMem.Inst_frame4_bit10.Q Tile_X0Y1_E2MID[1]
+ _0238_ VPWR VGND sg13g2_nor2b_1
X_0777_ Tile_X0Y1_IHP_BRAM_bot.Inst_IHP_BRAM_bot_ConfigMem.Inst_frame8_bit21.Q Tile_X0Y1_E1END[0]
+ Tile_X0Y1_E2END[3] Tile_X0Y1_E2MID[3] _0105_ Tile_X0Y1_IHP_BRAM_bot.Inst_IHP_BRAM_bot_ConfigMem.Inst_frame8_bit20.Q
+ Tile_X0Y1_IHP_BRAM_bot.Inst_IHP_BRAM_bot_switch_matrix.S2BEG4 VPWR VGND sg13g2_mux4_1
X_1329_ Tile_X0Y0_FrameData[26] Tile_X0Y1_FrameStrobe[9] Tile_X0Y0_IHP_BRAM_top.Inst_IHP_BRAM_top_ConfigMem.Inst_frame9_bit26.Q
+ VPWR VGND sg13g2_dlhq_1
XFILLER_68_162 VPWR VGND sg13g2_fill_2
XFILLER_83_176 VPWR VGND sg13g2_fill_1
Xoutput290 net290 Tile_X0Y1_S4BEG[2] VPWR VGND sg13g2_buf_1
XFILLER_59_184 VPWR VGND sg13g2_decap_4
X_0700_ Tile_X0Y0_IHP_BRAM_top.Inst_IHP_BRAM_top_switch_matrix.J_NS4_BEG5 Tile_X0Y0_IHP_BRAM_top.Inst_IHP_BRAM_top_switch_matrix.J_NS4_BEG9
+ Tile_X0Y0_IHP_BRAM_top.Inst_IHP_BRAM_top_ConfigMem.Inst_frame8_bit31.Q _0171_ VPWR
+ VGND sg13g2_mux2_1
XFILLER_90_96 VPWR VGND sg13g2_fill_1
XFILLER_90_52 VPWR VGND sg13g2_fill_2
XFILLER_99_72 VPWR VGND sg13g2_fill_1
X_0631_ Tile_X0Y0_IHP_BRAM_top.Inst_IHP_BRAM_top_ConfigMem.Inst_frame3_bit22.Q Tile_X0Y0_EE4END[2]
+ Tile_X0Y0_EE4END[10] Tile_X0Y0_E6END[10] Tile_X0Y0_IHP_BRAM_top.Inst_IHP_BRAM_top_switch_matrix.J_NS4_BEG10
+ Tile_X0Y0_IHP_BRAM_top.Inst_IHP_BRAM_top_ConfigMem.Inst_frame3_bit23.Q net76 VPWR
+ VGND sg13g2_mux4_1
X_0562_ Tile_X0Y0_IHP_BRAM_top.Inst_IHP_BRAM_top_ConfigMem.Inst_frame1_bit30.Q Tile_X0Y0_IHP_BRAM_top.Inst_IHP_BRAM_top_switch_matrix.N1END3
+ Tile_X0Y1_N4END[7] Tile_X0Y0_S1END[3] Tile_X0Y0_S4END[3] Tile_X0Y0_IHP_BRAM_top.Inst_IHP_BRAM_top_ConfigMem.Inst_frame1_bit31.Q
+ Tile_X0Y0_IHP_BRAM_top.Inst_IHP_BRAM_top_switch_matrix.J_NS4_BEG11 VPWR VGND sg13g2_mux4_1
X_1680_ clknet_1_0__leaf_Tile_X0Y1_UserCLK net27 VPWR VGND sg13g2_buf_1
X_1114_ Tile_X0Y0_FrameData[17] Tile_X0Y1_FrameStrobe[2] Tile_X0Y0_IHP_BRAM_top.Inst_IHP_BRAM_top_ConfigMem.Inst_frame2_bit17.Q
+ VPWR VGND sg13g2_dlhq_1
XFILLER_65_165 VPWR VGND sg13g2_fill_1
X_0493_ Tile_X0Y1_IHP_BRAM_bot.Inst_IHP_BRAM_bot_ConfigMem.Inst_frame9_bit7.Q Tile_X0Y1_E1END[3]
+ Tile_X0Y1_IHP_BRAM_bot.Inst_IHP_BRAM_bot_switch_matrix.J_NS4_BEG15 Tile_X0Y1_E6END[7]
+ _0101_ Tile_X0Y1_IHP_BRAM_bot.Inst_IHP_BRAM_bot_ConfigMem.Inst_frame9_bit6.Q Tile_X0Y0_IHP_BRAM_top.Inst_IHP_BRAM_top_switch_matrix.N1END3
+ VPWR VGND sg13g2_mux4_1
X_1045_ Tile_X0Y0_FrameData[22] Tile_X0Y1_FrameStrobe[0] Tile_X0Y0_IHP_BRAM_top.Inst_IHP_BRAM_top_ConfigMem.Inst_frame0_bit22.Q
+ VPWR VGND sg13g2_dlhq_1
X_1878_ Tile_X0Y0_S4END[15] net295 VPWR VGND sg13g2_buf_1
X_0829_ Tile_X0Y1_IHP_BRAM_bot.Inst_IHP_BRAM_bot_ConfigMem.Inst_frame5_bit16.Q Tile_X0Y1_N4END[0]
+ Tile_X0Y0_S4END[4] Tile_X0Y1_IHP_BRAM_bot.Inst_IHP_BRAM_bot_switch_matrix.J_NS4_BEG11
+ Tile_X0Y1_IHP_BRAM_bot.Inst_IHP_BRAM_bot_switch_matrix.J_NS4_BEG15 Tile_X0Y1_IHP_BRAM_bot.Inst_IHP_BRAM_bot_ConfigMem.Inst_frame5_bit17.Q
+ Tile_X0Y1_IHP_BRAM_bot.Inst_IHP_BRAM_bot_switch_matrix.W6BEG0 VPWR VGND sg13g2_mux4_1
XFILLER_100_84 VPWR VGND sg13g2_decap_8
XFILLER_44_67 VPWR VGND sg13g2_fill_2
XFILLER_107_0 VPWR VGND sg13g2_fill_1
XFILLER_69_31 VPWR VGND sg13g2_fill_1
XFILLER_85_96 VPWR VGND sg13g2_fill_2
XFILLER_62_135 VPWR VGND sg13g2_fill_1
X_1732_ Tile_X0Y1_FrameStrobe[18] net134 VPWR VGND sg13g2_buf_1
X_1801_ Tile_X0Y0_IHP_BRAM_top.Inst_IHP_BRAM_top_switch_matrix.W6BEG10 net203 VPWR
+ VGND sg13g2_buf_1
X_1663_ Tile_X0Y1_FrameData[12] Tile_X0Y1_FrameStrobe[9] Tile_X0Y1_IHP_BRAM_bot.Inst_IHP_BRAM_bot_ConfigMem.Inst_frame9_bit12.Q
+ VPWR VGND sg13g2_dlhq_1
XFILLER_105_18 VPWR VGND sg13g2_fill_2
X_0476_ VPWR VGND _0086_ _0087_ Tile_X0Y0_IHP_BRAM_top.Inst_IHP_BRAM_top_ConfigMem.Inst_frame0_bit29.Q
+ _0008_ _0088_ Tile_X0Y0_IHP_BRAM_top.Inst_IHP_BRAM_top_ConfigMem.Inst_frame0_bit28.Q
+ sg13g2_a221oi_1
X_0614_ Tile_X0Y0_E2MID[0] Tile_X0Y0_IHP_BRAM_top.Inst_IHP_BRAM_top_ConfigMem.Inst_frame3_bit8.Q
+ Tile_X0Y0_IHP_BRAM_top.Inst_IHP_BRAM_top_ConfigMem.Inst_frame3_bit9.Q _0116_ VPWR
+ VGND sg13g2_nor3_1
X_1594_ Tile_X0Y1_FrameData[17] Tile_X0Y1_FrameStrobe[7] Tile_X0Y1_IHP_BRAM_bot.Inst_IHP_BRAM_bot_ConfigMem.Inst_frame7_bit17.Q
+ VPWR VGND sg13g2_dlhq_1
X_0545_ Tile_X0Y0_IHP_BRAM_top.Inst_IHP_BRAM_top_ConfigMem.Inst_frame7_bit24.Q A_DOUT_BRAM12
+ B_DOUT_BRAM12 Tile_X0Y0_IHP_BRAM_top.Inst_IHP_BRAM_top_switch_matrix.J_NS2_BEG3
+ Tile_X0Y0_IHP_BRAM_top.Inst_IHP_BRAM_top_switch_matrix.J_NS2_BEG4 Tile_X0Y0_IHP_BRAM_top.Inst_IHP_BRAM_top_ConfigMem.Inst_frame7_bit25.Q
+ Tile_X0Y0_IHP_BRAM_top.Inst_IHP_BRAM_top_switch_matrix.W2BEG4 VPWR VGND sg13g2_mux4_1
X_1028_ Tile_X0Y1_E2END[3] Tile_X0Y1_IHP_BRAM_bot.Inst_IHP_BRAM_bot_ConfigMem.Inst_frame3_bit27.Q
+ Tile_X0Y1_IHP_BRAM_bot.Inst_IHP_BRAM_bot_ConfigMem.Inst_frame3_bit28.Q _0370_ VPWR
+ VGND sg13g2_or3_1
XFILLER_5_209 VPWR VGND sg13g2_fill_2
XFILLER_55_44 VPWR VGND sg13g2_decap_8
XFILLER_71_32 VPWR VGND sg13g2_fill_2
XFILLER_96_62 VPWR VGND sg13g2_fill_1
X_1715_ Tile_X0Y1_FrameStrobe[1] net136 VPWR VGND sg13g2_buf_1
X_1646_ Tile_X0Y1_FrameData[29] Tile_X0Y1_FrameStrobe[9] Tile_X0Y1_IHP_BRAM_bot.Inst_IHP_BRAM_bot_ConfigMem.Inst_frame9_bit29.Q
+ VPWR VGND sg13g2_dlhq_1
X_0528_ _0108_ Tile_X0Y0_S1END[0] Tile_X0Y0_IHP_BRAM_top.Inst_IHP_BRAM_top_ConfigMem.Inst_frame0_bit24.Q
+ VPWR VGND sg13g2_nand2b_1
X_1577_ Tile_X0Y1_FrameData[2] Tile_X0Y1_FrameStrobe[6] Tile_X0Y1_IHP_BRAM_bot.Inst_IHP_BRAM_bot_ConfigMem.Inst_frame6_bit2.Q
+ VPWR VGND sg13g2_dlhq_1
X_0459_ Tile_X0Y1_IHP_BRAM_bot.Inst_IHP_BRAM_bot_ConfigMem.Inst_frame3_bit22.Q Tile_X0Y1_N2MID[6]
+ Tile_X0Y1_N2END[2] Tile_X0Y1_N2END[3] Tile_X0Y1_E2MID[0] Tile_X0Y1_IHP_BRAM_bot.Inst_IHP_BRAM_bot_ConfigMem.Inst_frame3_bit23.Q
+ _0075_ VPWR VGND sg13g2_mux4_1
XFILLER_25_14 VPWR VGND sg13g2_fill_1
XFILLER_41_57 VPWR VGND sg13g2_decap_4
XFILLER_103_162 VPWR VGND sg13g2_fill_2
XFILLER_66_21 VPWR VGND sg13g2_fill_2
Xoutput108 net108 Tile_X0Y0_FrameData_O[23] VPWR VGND sg13g2_buf_1
Xoutput119 net119 Tile_X0Y0_FrameData_O[4] VPWR VGND sg13g2_buf_1
X_1500_ Tile_X0Y1_FrameData[15] Tile_X0Y1_FrameStrobe[4] Tile_X0Y1_IHP_BRAM_bot.Inst_IHP_BRAM_bot_ConfigMem.Inst_frame4_bit15.Q
+ VPWR VGND sg13g2_dlhq_1
X_1293_ Tile_X0Y0_FrameData[30] Tile_X0Y1_FrameStrobe[8] Tile_X0Y0_IHP_BRAM_top.Inst_IHP_BRAM_top_ConfigMem.Inst_frame8_bit30.Q
+ VPWR VGND sg13g2_dlhq_1
X_1362_ Tile_X0Y1_FrameData[25] Tile_X0Y1_FrameStrobe[0] Tile_X0Y1_IHP_BRAM_bot.Inst_IHP_BRAM_bot_ConfigMem.Inst_frame0_bit25.Q
+ VPWR VGND sg13g2_dlhq_1
Xoutput90 net90 B_MEN_BRAM VPWR VGND sg13g2_buf_1
X_1431_ Tile_X0Y1_FrameData[20] Tile_X0Y1_FrameStrobe[2] Tile_X0Y1_IHP_BRAM_bot.Inst_IHP_BRAM_bot_ConfigMem.Inst_frame2_bit20.Q
+ VPWR VGND sg13g2_dlhq_1
X_1629_ Tile_X0Y1_FrameData[14] Tile_X0Y1_FrameStrobe[8] Tile_X0Y1_IHP_BRAM_bot.Inst_IHP_BRAM_bot_ConfigMem.Inst_frame8_bit14.Q
+ VPWR VGND sg13g2_dlhq_1
XFILLER_36_35 VPWR VGND sg13g2_fill_2
X_0862_ Tile_X0Y1_IHP_BRAM_bot.Inst_IHP_BRAM_bot_ConfigMem.Inst_frame4_bit20.Q Tile_X0Y1_EE4END[1]
+ Tile_X0Y1_EE4END[9] Tile_X0Y1_E6END[1] _0232_ Tile_X0Y1_IHP_BRAM_bot.Inst_IHP_BRAM_bot_ConfigMem.Inst_frame4_bit21.Q
+ net29 VPWR VGND sg13g2_mux4_1
X_0931_ Tile_X0Y1_IHP_BRAM_bot.Inst_IHP_BRAM_bot_switch_matrix.J_NS4_BEG5 Tile_X0Y1_IHP_BRAM_bot.Inst_IHP_BRAM_bot_switch_matrix.J_NS4_BEG9
+ Tile_X0Y1_IHP_BRAM_bot.Inst_IHP_BRAM_bot_ConfigMem.Inst_frame9_bit27.Q _0281_ VPWR
+ VGND sg13g2_mux2_1
X_0793_ Tile_X0Y1_IHP_BRAM_bot.Inst_IHP_BRAM_bot_ConfigMem.Inst_frame6_bit0.Q A_DOUT_BRAM0
+ B_DOUT_BRAM0 _0065_ _0107_ Tile_X0Y1_IHP_BRAM_bot.Inst_IHP_BRAM_bot_ConfigMem.Inst_frame6_bit1.Q
+ Tile_X0Y1_IHP_BRAM_bot.Inst_IHP_BRAM_bot_switch_matrix.W2BEGb0 VPWR VGND sg13g2_mux4_1
X_1345_ Tile_X0Y0_FrameData[10] Tile_X0Y1_FrameStrobe[9] Tile_X0Y0_IHP_BRAM_top.Inst_IHP_BRAM_top_ConfigMem.Inst_frame9_bit10.Q
+ VPWR VGND sg13g2_dlhq_1
X_1414_ Tile_X0Y1_FrameData[5] Tile_X0Y1_FrameStrobe[1] Tile_X0Y1_IHP_BRAM_bot.Inst_IHP_BRAM_bot_ConfigMem.Inst_frame1_bit5.Q
+ VPWR VGND sg13g2_dlhq_1
X_1276_ Tile_X0Y0_FrameData[15] Tile_X0Y1_FrameStrobe[7] Tile_X0Y0_IHP_BRAM_top.Inst_IHP_BRAM_top_ConfigMem.Inst_frame7_bit15.Q
+ VPWR VGND sg13g2_dlhq_1
XFILLER_105_202 VPWR VGND sg13g2_fill_2
XFILLER_42_211 VPWR VGND sg13g2_fill_1
XFILLER_69_119 VPWR VGND sg13g2_decap_4
X_1130_ Tile_X0Y0_FrameData[1] Tile_X0Y1_FrameStrobe[2] Tile_X0Y0_IHP_BRAM_top.Inst_IHP_BRAM_top_ConfigMem.Inst_frame2_bit1.Q
+ VPWR VGND sg13g2_dlhq_1
XFILLER_92_188 VPWR VGND sg13g2_fill_1
XFILLER_92_155 VPWR VGND sg13g2_decap_8
X_1061_ Tile_X0Y0_FrameData[6] Tile_X0Y1_FrameStrobe[0] Tile_X0Y0_IHP_BRAM_top.Inst_IHP_BRAM_top_ConfigMem.Inst_frame0_bit6.Q
+ VPWR VGND sg13g2_dlhq_1
X_1894_ Tile_X0Y1_IHP_BRAM_bot.Inst_IHP_BRAM_bot_switch_matrix.W2BEG3 net305 VPWR
+ VGND sg13g2_buf_1
X_0914_ VPWR _0265_ _0264_ VGND sg13g2_inv_1
X_0845_ Tile_X0Y1_IHP_BRAM_bot.Inst_IHP_BRAM_bot_ConfigMem.Inst_frame4_bit11.Q _0102_
+ _0237_ VPWR VGND Tile_X0Y1_IHP_BRAM_bot.Inst_IHP_BRAM_bot_ConfigMem.Inst_frame4_bit10.Q
+ sg13g2_nand3b_1
XFILLER_108_18 VPWR VGND sg13g2_fill_2
X_0776_ Tile_X0Y1_IHP_BRAM_bot.Inst_IHP_BRAM_bot_ConfigMem.Inst_frame8_bit19.Q Tile_X0Y1_E2MID[4]
+ Tile_X0Y1_E6END[11] Tile_X0Y1_E2END[4] _0104_ Tile_X0Y1_IHP_BRAM_bot.Inst_IHP_BRAM_bot_ConfigMem.Inst_frame8_bit18.Q
+ Tile_X0Y1_IHP_BRAM_bot.Inst_IHP_BRAM_bot_switch_matrix.S2BEG3 VPWR VGND sg13g2_mux4_1
XFILLER_52_0 VPWR VGND sg13g2_decap_8
X_1328_ Tile_X0Y0_FrameData[27] Tile_X0Y1_FrameStrobe[9] Tile_X0Y0_IHP_BRAM_top.Inst_IHP_BRAM_top_ConfigMem.Inst_frame9_bit27.Q
+ VPWR VGND sg13g2_dlhq_1
XFILLER_68_185 VPWR VGND sg13g2_decap_4
XFILLER_68_141 VPWR VGND sg13g2_fill_1
X_1259_ Tile_X0Y0_FrameData[0] Tile_X0Y1_FrameStrobe[6] Tile_X0Y0_IHP_BRAM_top.Inst_IHP_BRAM_top_ConfigMem.Inst_frame6_bit0.Q
+ VPWR VGND sg13g2_dlhq_1
XFILLER_17_59 VPWR VGND sg13g2_fill_1
XFILLER_33_36 VPWR VGND sg13g2_fill_1
XFILLER_33_58 VPWR VGND sg13g2_fill_2
XFILLER_58_33 VPWR VGND sg13g2_decap_4
Xoutput280 net280 Tile_X0Y1_S2BEGb[6] VPWR VGND sg13g2_buf_1
Xoutput291 net291 Tile_X0Y1_S4BEG[3] VPWR VGND sg13g2_buf_1
XFILLER_74_177 VPWR VGND sg13g2_decap_8
XFILLER_88_9 VPWR VGND sg13g2_fill_1
XFILLER_30_214 VPWR VGND sg13g2_fill_2
X_0630_ Tile_X0Y0_IHP_BRAM_top.Inst_IHP_BRAM_top_ConfigMem.Inst_frame3_bit20.Q Tile_X0Y0_EE4END[1]
+ Tile_X0Y0_EE4END[9] Tile_X0Y0_E6END[9] Tile_X0Y0_IHP_BRAM_top.Inst_IHP_BRAM_top_switch_matrix.J_NS4_BEG9
+ Tile_X0Y0_IHP_BRAM_top.Inst_IHP_BRAM_top_ConfigMem.Inst_frame3_bit21.Q net89 VPWR
+ VGND sg13g2_mux4_1
X_0561_ Tile_X0Y0_IHP_BRAM_top.Inst_IHP_BRAM_top_ConfigMem.Inst_frame6_bit22.Q A_DOUT_BRAM11
+ B_DOUT_BRAM15 Tile_X0Y0_IHP_BRAM_top.Inst_IHP_BRAM_top_switch_matrix.J_NS4_BEG12
+ Tile_X0Y0_IHP_BRAM_top.Inst_IHP_BRAM_top_switch_matrix.J_NS2_BEG4 Tile_X0Y0_IHP_BRAM_top.Inst_IHP_BRAM_top_ConfigMem.Inst_frame6_bit23.Q
+ Tile_X0Y0_IHP_BRAM_top.Inst_IHP_BRAM_top_switch_matrix.WW4BEG3 VPWR VGND sg13g2_mux4_1
XFILLER_2_170 VPWR VGND sg13g2_fill_2
X_0492_ _0098_ VPWR _0101_ VGND Tile_X0Y1_IHP_BRAM_bot.Inst_IHP_BRAM_bot_ConfigMem.Inst_frame0_bit31.Q
+ _0100_ sg13g2_o21ai_1
X_1044_ Tile_X0Y0_FrameData[23] Tile_X0Y1_FrameStrobe[0] Tile_X0Y0_IHP_BRAM_top.Inst_IHP_BRAM_top_ConfigMem.Inst_frame0_bit23.Q
+ VPWR VGND sg13g2_dlhq_1
XFILLER_65_133 VPWR VGND sg13g2_decap_4
X_1113_ Tile_X0Y0_FrameData[18] Tile_X0Y1_FrameStrobe[2] Tile_X0Y0_IHP_BRAM_top.Inst_IHP_BRAM_top_ConfigMem.Inst_frame2_bit18.Q
+ VPWR VGND sg13g2_dlhq_1
X_1877_ Tile_X0Y0_S4END[14] net294 VPWR VGND sg13g2_buf_1
X_0759_ Tile_X0Y0_IHP_BRAM_top.Inst_IHP_BRAM_top_ConfigMem.Inst_frame1_bit6.Q VPWR
+ _0222_ VGND Tile_X0Y0_S2END[3] Tile_X0Y0_IHP_BRAM_top.Inst_IHP_BRAM_top_ConfigMem.Inst_frame1_bit5.Q
+ sg13g2_o21ai_1
X_0828_ Tile_X0Y1_IHP_BRAM_bot.Inst_IHP_BRAM_bot_ConfigMem.Inst_frame5_bit14.Q A_DOUT_BRAM3
+ B_DOUT_BRAM7 _0233_ _0065_ Tile_X0Y1_IHP_BRAM_bot.Inst_IHP_BRAM_bot_ConfigMem.Inst_frame5_bit15.Q
+ Tile_X0Y1_IHP_BRAM_bot.Inst_IHP_BRAM_bot_switch_matrix.WW4BEG15 VPWR VGND sg13g2_mux4_1
XFILLER_44_35 VPWR VGND sg13g2_fill_1
XFILLER_100_41 VPWR VGND sg13g2_fill_1
XFILLER_60_12 VPWR VGND sg13g2_fill_1
XFILLER_69_87 VPWR VGND sg13g2_fill_2
XFILLER_5_18 VPWR VGND sg13g2_fill_2
X_1800_ Tile_X0Y0_IHP_BRAM_top.Inst_IHP_BRAM_top_switch_matrix.W6BEG9 net213 VPWR
+ VGND sg13g2_buf_1
X_1731_ Tile_X0Y1_FrameStrobe[17] net133 VPWR VGND sg13g2_buf_1
X_0613_ Tile_X0Y0_IHP_BRAM_top.Inst_IHP_BRAM_top_ConfigMem.Inst_frame3_bit6.Q Tile_X0Y0_EE4END[7]
+ Tile_X0Y0_EE4END[15] Tile_X0Y0_E6END[7] Tile_X0Y0_IHP_BRAM_top.Inst_IHP_BRAM_top_switch_matrix.J_NS4_BEG7
+ Tile_X0Y0_IHP_BRAM_top.Inst_IHP_BRAM_top_ConfigMem.Inst_frame3_bit7.Q net18 VPWR
+ VGND sg13g2_mux4_1
X_1662_ Tile_X0Y1_FrameData[13] Tile_X0Y1_FrameStrobe[9] Tile_X0Y1_IHP_BRAM_bot.Inst_IHP_BRAM_bot_ConfigMem.Inst_frame9_bit13.Q
+ VPWR VGND sg13g2_dlhq_1
X_0475_ Tile_X0Y0_IHP_BRAM_top.Inst_IHP_BRAM_top_ConfigMem.Inst_frame0_bit28.Q Tile_X0Y0_IHP_BRAM_top.Inst_IHP_BRAM_top_ConfigMem.Inst_frame0_bit29.Q
+ Tile_X0Y0_IHP_BRAM_top.Inst_IHP_BRAM_top_switch_matrix.N1END2 _0087_ VPWR VGND sg13g2_nor3_1
X_1593_ Tile_X0Y1_FrameData[18] Tile_X0Y1_FrameStrobe[7] Tile_X0Y1_IHP_BRAM_bot.Inst_IHP_BRAM_bot_ConfigMem.Inst_frame7_bit18.Q
+ VPWR VGND sg13g2_dlhq_1
X_0544_ Tile_X0Y0_IHP_BRAM_top.Inst_IHP_BRAM_top_ConfigMem.Inst_frame7_bit22.Q A_DOUT_BRAM11
+ B_DOUT_BRAM11 Tile_X0Y0_IHP_BRAM_top.Inst_IHP_BRAM_top_switch_matrix.J_NS2_BEG3
+ Tile_X0Y0_IHP_BRAM_top.Inst_IHP_BRAM_top_switch_matrix.J_NS2_BEG4 Tile_X0Y0_IHP_BRAM_top.Inst_IHP_BRAM_top_ConfigMem.Inst_frame7_bit23.Q
+ Tile_X0Y0_IHP_BRAM_top.Inst_IHP_BRAM_top_switch_matrix.W2BEG3 VPWR VGND sg13g2_mux4_1
X_1027_ _0369_ Tile_X0Y1_E2END[5] Tile_X0Y1_IHP_BRAM_bot.Inst_IHP_BRAM_bot_ConfigMem.Inst_frame3_bit28.Q
+ VPWR VGND sg13g2_nand2b_1
XFILLER_53_125 VPWR VGND sg13g2_fill_1
X_1929_ Tile_X0Y1_IHP_BRAM_bot.Inst_IHP_BRAM_bot_switch_matrix.WW4BEG10 net331 VPWR
+ VGND sg13g2_buf_1
XFILLER_107_149 VPWR VGND sg13g2_decap_8
XFILLER_52_180 VPWR VGND sg13g2_fill_1
XFILLER_106_182 VPWR VGND sg13g2_fill_1
XFILLER_106_160 VPWR VGND sg13g2_decap_8
XFILLER_29_90 VPWR VGND sg13g2_fill_1
X_1714_ Tile_X0Y1_FrameStrobe[0] net125 VPWR VGND sg13g2_buf_1
X_1576_ Tile_X0Y1_FrameData[3] Tile_X0Y1_FrameStrobe[6] Tile_X0Y1_IHP_BRAM_bot.Inst_IHP_BRAM_bot_ConfigMem.Inst_frame6_bit3.Q
+ VPWR VGND sg13g2_dlhq_1
X_1645_ Tile_X0Y1_FrameData[30] Tile_X0Y1_FrameStrobe[9] Tile_X0Y1_IHP_BRAM_bot.Inst_IHP_BRAM_bot_ConfigMem.Inst_frame9_bit30.Q
+ VPWR VGND sg13g2_dlhq_1
X_0389_ VPWR _0012_ Tile_X0Y0_IHP_BRAM_top.Inst_IHP_BRAM_top_ConfigMem.Inst_frame9_bit28.Q
+ VGND sg13g2_inv_1
X_0527_ Tile_X0Y0_IHP_BRAM_top.Inst_IHP_BRAM_top_ConfigMem.Inst_frame9_bit22.Q Tile_X0Y0_E2MID[0]
+ Tile_X0Y0_E2END[0] Tile_X0Y0_E6END[0] Tile_X0Y0_IHP_BRAM_top.Inst_IHP_BRAM_top_switch_matrix.J_NS2_BEG7
+ Tile_X0Y0_IHP_BRAM_top.Inst_IHP_BRAM_top_ConfigMem.Inst_frame9_bit23.Q Tile_X0Y0_IHP_BRAM_top.Inst_IHP_BRAM_top_switch_matrix.N2BEG7
+ VPWR VGND sg13g2_mux4_1
XFILLER_73_209 VPWR VGND sg13g2_fill_2
X_0458_ Tile_X0Y1_IHP_BRAM_bot.Inst_IHP_BRAM_bot_ConfigMem.Inst_frame3_bit22.Q Tile_X0Y1_E2MID[3]
+ Tile_X0Y1_E2MID[6] Tile_X0Y1_E2END[1] Tile_X0Y1_E2END[2] Tile_X0Y1_IHP_BRAM_bot.Inst_IHP_BRAM_bot_ConfigMem.Inst_frame3_bit23.Q
+ _0074_ VPWR VGND sg13g2_mux4_1
XFILLER_26_114 VPWR VGND sg13g2_decap_8
XFILLER_26_125 VPWR VGND sg13g2_fill_2
Xoutput109 net109 Tile_X0Y0_FrameData_O[24] VPWR VGND sg13g2_buf_1
Xoutput1 net1 A_ADDR_BRAM0 VPWR VGND sg13g2_buf_1
X_1430_ Tile_X0Y1_FrameData[21] Tile_X0Y1_FrameStrobe[2] Tile_X0Y1_IHP_BRAM_bot.Inst_IHP_BRAM_bot_ConfigMem.Inst_frame2_bit21.Q
+ VPWR VGND sg13g2_dlhq_1
X_1292_ Tile_X0Y0_FrameData[31] Tile_X0Y1_FrameStrobe[8] Tile_X0Y0_IHP_BRAM_top.Inst_IHP_BRAM_top_ConfigMem.Inst_frame8_bit31.Q
+ VPWR VGND sg13g2_dlhq_1
Xoutput80 net80 B_DIN_BRAM14 VPWR VGND sg13g2_buf_1
Xoutput91 net91 B_REN_BRAM VPWR VGND sg13g2_buf_1
X_1361_ Tile_X0Y1_FrameData[26] Tile_X0Y1_FrameStrobe[0] Tile_X0Y1_IHP_BRAM_bot.Inst_IHP_BRAM_bot_ConfigMem.Inst_frame0_bit26.Q
+ VPWR VGND sg13g2_dlhq_1
XFILLER_23_117 VPWR VGND sg13g2_fill_2
X_1559_ Tile_X0Y1_FrameData[20] Tile_X0Y1_FrameStrobe[6] Tile_X0Y1_IHP_BRAM_bot.Inst_IHP_BRAM_bot_ConfigMem.Inst_frame6_bit20.Q
+ VPWR VGND sg13g2_dlhq_1
X_1628_ Tile_X0Y1_FrameData[15] Tile_X0Y1_FrameStrobe[8] Tile_X0Y1_IHP_BRAM_bot.Inst_IHP_BRAM_bot_ConfigMem.Inst_frame8_bit15.Q
+ VPWR VGND sg13g2_dlhq_1
XFILLER_52_57 VPWR VGND sg13g2_decap_8
XFILLER_89_183 VPWR VGND sg13g2_fill_2
XFILLER_77_76 VPWR VGND sg13g2_decap_8
XFILLER_26_91 VPWR VGND sg13g2_decap_4
X_0792_ Tile_X0Y1_IHP_BRAM_bot.Inst_IHP_BRAM_bot_ConfigMem.Inst_frame7_bit30.Q A_DOUT_BRAM7
+ B_DOUT_BRAM7 _0065_ _0107_ Tile_X0Y1_IHP_BRAM_bot.Inst_IHP_BRAM_bot_ConfigMem.Inst_frame7_bit31.Q
+ Tile_X0Y1_IHP_BRAM_bot.Inst_IHP_BRAM_bot_switch_matrix.W2BEG7 VPWR VGND sg13g2_mux4_1
X_0861_ Tile_X0Y1_IHP_BRAM_bot.Inst_IHP_BRAM_bot_ConfigMem.Inst_frame4_bit18.Q Tile_X0Y1_EE4END[0]
+ Tile_X0Y1_EE4END[8] Tile_X0Y1_E6END[0] _0233_ Tile_X0Y1_IHP_BRAM_bot.Inst_IHP_BRAM_bot_ConfigMem.Inst_frame4_bit19.Q
+ net28 VPWR VGND sg13g2_mux4_1
X_0930_ Tile_X0Y1_IHP_BRAM_bot.Inst_IHP_BRAM_bot_ConfigMem.Inst_frame9_bit28.Q VPWR
+ _0280_ VGND Tile_X0Y1_IHP_BRAM_bot.Inst_IHP_BRAM_bot_ConfigMem.Inst_frame9_bit27.Q
+ Tile_X0Y1_IHP_BRAM_bot.Inst_IHP_BRAM_bot_switch_matrix.J_NS4_BEG13 sg13g2_o21ai_1
X_1413_ Tile_X0Y1_FrameData[6] Tile_X0Y1_FrameStrobe[1] Tile_X0Y1_IHP_BRAM_bot.Inst_IHP_BRAM_bot_ConfigMem.Inst_frame1_bit6.Q
+ VPWR VGND sg13g2_dlhq_1
X_1344_ Tile_X0Y0_FrameData[11] Tile_X0Y1_FrameStrobe[9] Tile_X0Y0_IHP_BRAM_top.Inst_IHP_BRAM_top_ConfigMem.Inst_frame9_bit11.Q
+ VPWR VGND sg13g2_dlhq_1
X_1275_ Tile_X0Y0_FrameData[16] Tile_X0Y1_FrameStrobe[7] Tile_X0Y0_IHP_BRAM_top.Inst_IHP_BRAM_top_ConfigMem.Inst_frame7_bit16.Q
+ VPWR VGND sg13g2_dlhq_1
XFILLER_3_73 VPWR VGND sg13g2_fill_1
X_1060_ Tile_X0Y0_FrameData[7] Tile_X0Y1_FrameStrobe[0] Tile_X0Y0_IHP_BRAM_top.Inst_IHP_BRAM_top_ConfigMem.Inst_frame0_bit7.Q
+ VPWR VGND sg13g2_dlhq_1
XFILLER_77_120 VPWR VGND sg13g2_decap_8
X_0844_ _0234_ VPWR net1 VGND Tile_X0Y1_IHP_BRAM_bot.Inst_IHP_BRAM_bot_ConfigMem.Inst_frame4_bit9.Q
+ _0236_ sg13g2_o21ai_1
X_0913_ Tile_X0Y1_IHP_BRAM_bot.Inst_IHP_BRAM_bot_ConfigMem.Inst_frame9_bit25.Q VPWR
+ _0264_ VGND Tile_X0Y1_E6END[8] Tile_X0Y1_IHP_BRAM_bot.Inst_IHP_BRAM_bot_ConfigMem.Inst_frame9_bit24.Q
+ sg13g2_o21ai_1
X_1893_ Tile_X0Y1_IHP_BRAM_bot.Inst_IHP_BRAM_bot_switch_matrix.W2BEG2 net304 VPWR
+ VGND sg13g2_buf_1
X_0775_ Tile_X0Y1_IHP_BRAM_bot.Inst_IHP_BRAM_bot_ConfigMem.Inst_frame8_bit17.Q Tile_X0Y1_E2MID[5]
+ Tile_X0Y1_E6END[10] Tile_X0Y1_E2END[5] _0103_ Tile_X0Y1_IHP_BRAM_bot.Inst_IHP_BRAM_bot_ConfigMem.Inst_frame8_bit16.Q
+ Tile_X0Y1_IHP_BRAM_bot.Inst_IHP_BRAM_bot_switch_matrix.S2BEG2 VPWR VGND sg13g2_mux4_1
XFILLER_45_0 VPWR VGND sg13g2_fill_2
X_1327_ Tile_X0Y0_FrameData[28] Tile_X0Y1_FrameStrobe[9] Tile_X0Y0_IHP_BRAM_top.Inst_IHP_BRAM_top_ConfigMem.Inst_frame9_bit28.Q
+ VPWR VGND sg13g2_dlhq_1
XFILLER_83_145 VPWR VGND sg13g2_fill_1
X_1189_ Tile_X0Y0_FrameData[6] Tile_X0Y1_FrameStrobe[4] Tile_X0Y0_IHP_BRAM_top.Inst_IHP_BRAM_top_ConfigMem.Inst_frame4_bit6.Q
+ VPWR VGND sg13g2_dlhq_1
X_1258_ Tile_X0Y0_FrameData[1] Tile_X0Y1_FrameStrobe[6] Tile_X0Y0_IHP_BRAM_top.Inst_IHP_BRAM_top_ConfigMem.Inst_frame6_bit1.Q
+ VPWR VGND sg13g2_dlhq_1
XFILLER_3_149 VPWR VGND sg13g2_fill_1
Xoutput270 net270 Tile_X0Y1_S2BEG[4] VPWR VGND sg13g2_buf_1
XFILLER_58_78 VPWR VGND sg13g2_fill_1
XFILLER_58_67 VPWR VGND sg13g2_decap_8
Xoutput281 net281 Tile_X0Y1_S2BEGb[7] VPWR VGND sg13g2_buf_1
Xoutput292 net292 Tile_X0Y1_S4BEG[4] VPWR VGND sg13g2_buf_1
XFILLER_99_41 VPWR VGND sg13g2_fill_1
X_0560_ Tile_X0Y0_IHP_BRAM_top.Inst_IHP_BRAM_top_ConfigMem.Inst_frame0_bit0.Q Tile_X0Y0_IHP_BRAM_top.Inst_IHP_BRAM_top_switch_matrix.N1END0
+ Tile_X0Y1_N4END[4] Tile_X0Y0_S1END[0] Tile_X0Y0_S4END[0] Tile_X0Y0_IHP_BRAM_top.Inst_IHP_BRAM_top_ConfigMem.Inst_frame0_bit1.Q
+ Tile_X0Y0_IHP_BRAM_top.Inst_IHP_BRAM_top_switch_matrix.J_NS4_BEG12 VPWR VGND sg13g2_mux4_1
X_0491_ VGND VPWR Tile_X0Y1_E6END[3] Tile_X0Y1_IHP_BRAM_bot.Inst_IHP_BRAM_bot_ConfigMem.Inst_frame0_bit30.Q
+ _0100_ _0099_ sg13g2_a21oi_1
X_1043_ Tile_X0Y0_FrameData[24] Tile_X0Y1_FrameStrobe[0] Tile_X0Y0_IHP_BRAM_top.Inst_IHP_BRAM_top_ConfigMem.Inst_frame0_bit24.Q
+ VPWR VGND sg13g2_dlhq_1
X_1112_ Tile_X0Y0_FrameData[19] Tile_X0Y1_FrameStrobe[2] Tile_X0Y0_IHP_BRAM_top.Inst_IHP_BRAM_top_ConfigMem.Inst_frame2_bit19.Q
+ VPWR VGND sg13g2_dlhq_1
XFILLER_21_215 VPWR VGND sg13g2_fill_1
X_1876_ Tile_X0Y0_S4END[13] net293 VPWR VGND sg13g2_buf_1
X_0758_ _0001_ Tile_X0Y0_IHP_BRAM_top.Inst_IHP_BRAM_top_ConfigMem.Inst_frame1_bit5.Q
+ Tile_X0Y0_IHP_BRAM_top.Inst_IHP_BRAM_top_ConfigMem.Inst_frame1_bit6.Q _0221_ VPWR
+ VGND sg13g2_nor3_1
X_0827_ Tile_X0Y1_IHP_BRAM_bot.Inst_IHP_BRAM_bot_ConfigMem.Inst_frame1_bit8.Q Tile_X0Y1_N1END[0]
+ Tile_X0Y1_N4END[0] _0111_ Tile_X0Y0_S4END[4] Tile_X0Y1_IHP_BRAM_bot.Inst_IHP_BRAM_bot_ConfigMem.Inst_frame1_bit9.Q
+ _0233_ VPWR VGND sg13g2_mux4_1
X_0689_ Tile_X0Y0_IHP_BRAM_top.Inst_IHP_BRAM_top_ConfigMem.Inst_frame8_bit2.Q Tile_X0Y0_E1END[3]
+ Tile_X0Y0_E6END[11] Tile_X0Y0_EE4END[3] Tile_X0Y0_IHP_BRAM_top.Inst_IHP_BRAM_top_switch_matrix.J_NS4_BEG3
+ Tile_X0Y0_IHP_BRAM_top.Inst_IHP_BRAM_top_ConfigMem.Inst_frame8_bit1.Q _0162_ VPWR
+ VGND sg13g2_mux4_1
XFILLER_28_48 VPWR VGND sg13g2_fill_1
XFILLER_44_69 VPWR VGND sg13g2_fill_1
X_1730_ Tile_X0Y1_FrameStrobe[16] net132 VPWR VGND sg13g2_buf_1
X_0612_ Tile_X0Y0_IHP_BRAM_top.Inst_IHP_BRAM_top_ConfigMem.Inst_frame3_bit4.Q Tile_X0Y0_EE4END[6]
+ Tile_X0Y0_EE4END[14] Tile_X0Y0_E6END[6] Tile_X0Y0_IHP_BRAM_top.Inst_IHP_BRAM_top_switch_matrix.J_NS4_BEG6
+ Tile_X0Y0_IHP_BRAM_top.Inst_IHP_BRAM_top_ConfigMem.Inst_frame3_bit5.Q net17 VPWR
+ VGND sg13g2_mux4_1
X_1592_ Tile_X0Y1_FrameData[19] Tile_X0Y1_FrameStrobe[7] Tile_X0Y1_IHP_BRAM_bot.Inst_IHP_BRAM_bot_ConfigMem.Inst_frame7_bit19.Q
+ VPWR VGND sg13g2_dlhq_1
X_1661_ Tile_X0Y1_FrameData[14] Tile_X0Y1_FrameStrobe[9] Tile_X0Y1_IHP_BRAM_bot.Inst_IHP_BRAM_bot_ConfigMem.Inst_frame9_bit14.Q
+ VPWR VGND sg13g2_dlhq_1
X_0474_ _0086_ Tile_X0Y0_S1END[2] Tile_X0Y0_IHP_BRAM_top.Inst_IHP_BRAM_top_ConfigMem.Inst_frame0_bit28.Q
+ VPWR VGND sg13g2_nand2b_1
X_0543_ Tile_X0Y0_IHP_BRAM_top.Inst_IHP_BRAM_top_ConfigMem.Inst_frame7_bit20.Q A_DOUT_BRAM10
+ B_DOUT_BRAM10 Tile_X0Y0_IHP_BRAM_top.Inst_IHP_BRAM_top_switch_matrix.J_NS2_BEG2
+ Tile_X0Y0_IHP_BRAM_top.Inst_IHP_BRAM_top_switch_matrix.J_NS2_BEG5 Tile_X0Y0_IHP_BRAM_top.Inst_IHP_BRAM_top_ConfigMem.Inst_frame7_bit21.Q
+ Tile_X0Y0_IHP_BRAM_top.Inst_IHP_BRAM_top_switch_matrix.W2BEG2 VPWR VGND sg13g2_mux4_1
X_1026_ VGND VPWR _0039_ _0367_ _0368_ _0365_ sg13g2_a21oi_1
XFILLER_53_159 VPWR VGND sg13g2_decap_8
XFILLER_61_181 VPWR VGND sg13g2_fill_1
X_1928_ Tile_X0Y1_IHP_BRAM_bot.Inst_IHP_BRAM_bot_switch_matrix.WW4BEG9 net345 VPWR
+ VGND sg13g2_buf_1
X_1859_ Tile_X0Y1_IHP_BRAM_bot.Inst_IHP_BRAM_bot_switch_matrix.S2BEG4 net270 VPWR
+ VGND sg13g2_buf_1
XFILLER_71_34 VPWR VGND sg13g2_fill_1
XFILLER_71_12 VPWR VGND sg13g2_fill_2
XFILLER_55_79 VPWR VGND sg13g2_decap_8
XFILLER_4_211 VPWR VGND sg13g2_fill_1
XFILLER_106_172 VPWR VGND sg13g2_fill_2
XFILLER_90_210 VPWR VGND sg13g2_fill_2
X_1713_ Tile_X0Y0_FrameData[31] net117 VPWR VGND sg13g2_buf_1
X_0526_ Tile_X0Y0_IHP_BRAM_top.Inst_IHP_BRAM_top_ConfigMem.Inst_frame0_bit23.Q Tile_X0Y0_IHP_BRAM_top.Inst_IHP_BRAM_top_switch_matrix.N2BEGb7
+ Tile_X0Y0_S2MID[7] Tile_X0Y1_N2MID[7] Tile_X0Y0_S2END[7] Tile_X0Y0_IHP_BRAM_top.Inst_IHP_BRAM_top_ConfigMem.Inst_frame0_bit22.Q
+ Tile_X0Y0_IHP_BRAM_top.Inst_IHP_BRAM_top_switch_matrix.J_NS2_BEG7 VPWR VGND sg13g2_mux4_1
X_1575_ Tile_X0Y1_FrameData[4] Tile_X0Y1_FrameStrobe[6] Tile_X0Y1_IHP_BRAM_bot.Inst_IHP_BRAM_bot_ConfigMem.Inst_frame6_bit4.Q
+ VPWR VGND sg13g2_dlhq_1
X_1644_ Tile_X0Y1_FrameData[31] Tile_X0Y1_FrameStrobe[9] Tile_X0Y1_IHP_BRAM_bot.Inst_IHP_BRAM_bot_ConfigMem.Inst_frame9_bit31.Q
+ VPWR VGND sg13g2_dlhq_1
X_0388_ VPWR _0011_ Tile_X0Y0_IHP_BRAM_top.Inst_IHP_BRAM_top_ConfigMem.Inst_frame9_bit25.Q
+ VGND sg13g2_inv_1
X_0457_ _0072_ VPWR _0073_ VGND _0066_ _0068_ sg13g2_o21ai_1
X_1009_ _0351_ VPWR _0352_ VGND _0005_ Tile_X0Y1_IHP_BRAM_bot.Inst_IHP_BRAM_bot_ConfigMem.Inst_frame3_bit18.Q
+ sg13g2_o21ai_1
XFILLER_66_78 VPWR VGND sg13g2_decap_4
XFILLER_40_151 VPWR VGND sg13g2_fill_1
XFILLER_40_173 VPWR VGND sg13g2_decap_8
XFILLER_40_184 VPWR VGND sg13g2_decap_4
Xoutput2 net2 A_ADDR_BRAM1 VPWR VGND sg13g2_buf_1
Xoutput70 net70 B_BM_BRAM7 VPWR VGND sg13g2_buf_1
X_1360_ Tile_X0Y1_FrameData[27] Tile_X0Y1_FrameStrobe[0] Tile_X0Y1_IHP_BRAM_bot.Inst_IHP_BRAM_bot_ConfigMem.Inst_frame0_bit27.Q
+ VPWR VGND sg13g2_dlhq_1
XFILLER_49_7 VPWR VGND sg13g2_decap_8
X_1291_ Tile_X0Y0_FrameData[0] Tile_X0Y1_FrameStrobe[7] Tile_X0Y0_IHP_BRAM_top.Inst_IHP_BRAM_top_ConfigMem.Inst_frame7_bit0.Q
+ VPWR VGND sg13g2_dlhq_1
Xoutput81 net81 B_DIN_BRAM15 VPWR VGND sg13g2_buf_1
Xoutput92 net92 B_WEN_BRAM VPWR VGND sg13g2_buf_1
XFILLER_75_0 VPWR VGND sg13g2_fill_1
XFILLER_100_123 VPWR VGND sg13g2_fill_2
X_1489_ Tile_X0Y1_FrameData[26] Tile_X0Y1_FrameStrobe[4] Tile_X0Y1_IHP_BRAM_bot.Inst_IHP_BRAM_bot_ConfigMem.Inst_frame4_bit26.Q
+ VPWR VGND sg13g2_dlhq_1
X_1558_ Tile_X0Y1_FrameData[21] Tile_X0Y1_FrameStrobe[6] Tile_X0Y1_IHP_BRAM_bot.Inst_IHP_BRAM_bot_ConfigMem.Inst_frame6_bit21.Q
+ VPWR VGND sg13g2_dlhq_1
X_1627_ Tile_X0Y1_FrameData[16] Tile_X0Y1_FrameStrobe[8] Tile_X0Y1_IHP_BRAM_bot.Inst_IHP_BRAM_bot_ConfigMem.Inst_frame8_bit16.Q
+ VPWR VGND sg13g2_dlhq_1
X_0509_ Tile_X0Y1_IHP_BRAM_bot.Inst_IHP_BRAM_bot_ConfigMem.Inst_frame9_bit15.Q Tile_X0Y1_E2MID[4]
+ Tile_X0Y1_E6END[4] Tile_X0Y1_E2END[4] _0104_ Tile_X0Y1_IHP_BRAM_bot.Inst_IHP_BRAM_bot_ConfigMem.Inst_frame9_bit14.Q
+ Tile_X0Y0_IHP_BRAM_top.Inst_IHP_BRAM_top_switch_matrix.N2BEGb3 VPWR VGND sg13g2_mux4_1
XFILLER_36_37 VPWR VGND sg13g2_fill_1
XFILLER_52_14 VPWR VGND sg13g2_fill_1
XFILLER_93_76 VPWR VGND sg13g2_fill_2
XFILLER_93_65 VPWR VGND sg13g2_decap_8
XFILLER_60_213 VPWR VGND sg13g2_fill_2
X_0791_ Tile_X0Y1_IHP_BRAM_bot.Inst_IHP_BRAM_bot_ConfigMem.Inst_frame7_bit28.Q A_DOUT_BRAM6
+ B_DOUT_BRAM6 _0102_ _0046_ Tile_X0Y1_IHP_BRAM_bot.Inst_IHP_BRAM_bot_ConfigMem.Inst_frame7_bit29.Q
+ Tile_X0Y1_IHP_BRAM_bot.Inst_IHP_BRAM_bot_switch_matrix.W2BEG6 VPWR VGND sg13g2_mux4_1
X_0860_ _0246_ VPWR net5 VGND Tile_X0Y1_IHP_BRAM_bot.Inst_IHP_BRAM_bot_ConfigMem.Inst_frame4_bit17.Q
+ _0248_ sg13g2_o21ai_1
X_1343_ Tile_X0Y0_FrameData[12] Tile_X0Y1_FrameStrobe[9] Tile_X0Y0_IHP_BRAM_top.Inst_IHP_BRAM_top_ConfigMem.Inst_frame9_bit12.Q
+ VPWR VGND sg13g2_dlhq_1
X_1412_ Tile_X0Y1_FrameData[7] Tile_X0Y1_FrameStrobe[1] Tile_X0Y1_IHP_BRAM_bot.Inst_IHP_BRAM_bot_ConfigMem.Inst_frame1_bit7.Q
+ VPWR VGND sg13g2_dlhq_1
X_1274_ Tile_X0Y0_FrameData[17] Tile_X0Y1_FrameStrobe[7] Tile_X0Y0_IHP_BRAM_top.Inst_IHP_BRAM_top_ConfigMem.Inst_frame7_bit17.Q
+ VPWR VGND sg13g2_dlhq_1
X_0989_ VGND VPWR _0326_ _0328_ Tile_X0Y1_IHP_BRAM_bot.Inst_IHP_BRAM_bot_switch_matrix.S4BEG2
+ _0333_ sg13g2_a21oi_1
XFILLER_86_132 VPWR VGND sg13g2_decap_8
XFILLER_47_36 VPWR VGND sg13g2_fill_1
XFILLER_47_47 VPWR VGND sg13g2_decap_8
XFILLER_63_35 VPWR VGND sg13g2_fill_2
XFILLER_10_110 VPWR VGND sg13g2_fill_2
XFILLER_5_0 VPWR VGND sg13g2_fill_1
X_1892_ Tile_X0Y1_IHP_BRAM_bot.Inst_IHP_BRAM_bot_switch_matrix.W2BEG1 net303 VPWR
+ VGND sg13g2_buf_1
X_0912_ Tile_X0Y1_IHP_BRAM_bot.Inst_IHP_BRAM_bot_ConfigMem.Inst_frame1_bit6.Q Tile_X0Y1_E1END[3]
+ Tile_X0Y1_EE4END[7] Tile_X0Y1_EE4END[15] Tile_X0Y1_IHP_BRAM_bot.Inst_IHP_BRAM_bot_switch_matrix.J_NS4_BEG15
+ Tile_X0Y1_IHP_BRAM_bot.Inst_IHP_BRAM_bot_ConfigMem.Inst_frame1_bit7.Q net70 VPWR
+ VGND sg13g2_mux4_1
X_0843_ VGND VPWR Tile_X0Y1_E2END[0] Tile_X0Y1_IHP_BRAM_bot.Inst_IHP_BRAM_bot_ConfigMem.Inst_frame4_bit8.Q
+ _0236_ _0235_ sg13g2_a21oi_1
X_0774_ Tile_X0Y1_IHP_BRAM_bot.Inst_IHP_BRAM_bot_ConfigMem.Inst_frame8_bit14.Q Tile_X0Y1_E2MID[6]
+ Tile_X0Y1_E2END[6] Tile_X0Y1_E6END[9] _0102_ Tile_X0Y1_IHP_BRAM_bot.Inst_IHP_BRAM_bot_ConfigMem.Inst_frame8_bit15.Q
+ Tile_X0Y1_IHP_BRAM_bot.Inst_IHP_BRAM_bot_switch_matrix.S2BEG1 VPWR VGND sg13g2_mux4_1
X_1326_ Tile_X0Y0_FrameData[29] Tile_X0Y1_FrameStrobe[9] Tile_X0Y0_IHP_BRAM_top.Inst_IHP_BRAM_top_ConfigMem.Inst_frame9_bit29.Q
+ VPWR VGND sg13g2_dlhq_1
XFILLER_38_0 VPWR VGND sg13g2_fill_1
X_1188_ Tile_X0Y0_FrameData[7] Tile_X0Y1_FrameStrobe[4] Tile_X0Y0_IHP_BRAM_top.Inst_IHP_BRAM_top_ConfigMem.Inst_frame4_bit7.Q
+ VPWR VGND sg13g2_dlhq_1
X_1257_ Tile_X0Y0_FrameData[2] Tile_X0Y1_FrameStrobe[6] Tile_X0Y0_IHP_BRAM_top.Inst_IHP_BRAM_top_ConfigMem.Inst_frame6_bit2.Q
+ VPWR VGND sg13g2_dlhq_1
XFILLER_33_27 VPWR VGND sg13g2_decap_8
Xoutput271 net271 Tile_X0Y1_S2BEG[5] VPWR VGND sg13g2_buf_1
Xoutput282 net282 Tile_X0Y1_S4BEG[0] VPWR VGND sg13g2_buf_1
Xoutput293 net293 Tile_X0Y1_S4BEG[5] VPWR VGND sg13g2_buf_1
Xoutput260 net260 Tile_X0Y1_FrameData_O[8] VPWR VGND sg13g2_buf_1
XFILLER_74_56 VPWR VGND sg13g2_decap_8
XFILLER_59_165 VPWR VGND sg13g2_fill_2
XFILLER_15_202 VPWR VGND sg13g2_fill_2
XFILLER_15_213 VPWR VGND sg13g2_fill_2
XFILLER_65_102 VPWR VGND sg13g2_fill_2
XFILLER_2_172 VPWR VGND sg13g2_fill_1
XFILLER_2_194 VPWR VGND sg13g2_fill_2
X_0490_ Tile_X0Y1_IHP_BRAM_bot.Inst_IHP_BRAM_bot_ConfigMem.Inst_frame0_bit30.Q Tile_X0Y1_N1END[3]
+ _0099_ VPWR VGND sg13g2_nor2b_1
X_1042_ Tile_X0Y0_FrameData[25] Tile_X0Y1_FrameStrobe[0] Tile_X0Y0_IHP_BRAM_top.Inst_IHP_BRAM_top_ConfigMem.Inst_frame0_bit25.Q
+ VPWR VGND sg13g2_dlhq_1
X_1111_ Tile_X0Y0_FrameData[20] Tile_X0Y1_FrameStrobe[2] Tile_X0Y0_IHP_BRAM_top.Inst_IHP_BRAM_top_ConfigMem.Inst_frame2_bit20.Q
+ VPWR VGND sg13g2_dlhq_1
XFILLER_48_90 VPWR VGND sg13g2_decap_8
X_1875_ Tile_X0Y0_S4END[12] net292 VPWR VGND sg13g2_buf_1
X_0688_ VGND VPWR _0014_ _0157_ _0161_ _0160_ sg13g2_a21oi_1
X_0757_ VGND VPWR _0220_ _0219_ Tile_X0Y0_IHP_BRAM_top.Inst_IHP_BRAM_top_ConfigMem.Inst_frame1_bit7.Q
+ sg13g2_or2_1
X_0826_ Tile_X0Y1_IHP_BRAM_bot.Inst_IHP_BRAM_bot_ConfigMem.Inst_frame5_bit12.Q A_DOUT_BRAM2
+ B_DOUT_BRAM6 _0232_ _0102_ Tile_X0Y1_IHP_BRAM_bot.Inst_IHP_BRAM_bot_ConfigMem.Inst_frame5_bit13.Q
+ Tile_X0Y1_IHP_BRAM_bot.Inst_IHP_BRAM_bot_switch_matrix.WW4BEG14 VPWR VGND sg13g2_mux4_1
X_1309_ Tile_X0Y0_FrameData[14] Tile_X0Y1_FrameStrobe[8] Tile_X0Y0_IHP_BRAM_top.Inst_IHP_BRAM_top_ConfigMem.Inst_frame8_bit14.Q
+ VPWR VGND sg13g2_dlhq_1
XFILLER_56_157 VPWR VGND sg13g2_fill_1
XFILLER_71_127 VPWR VGND sg13g2_decap_8
XFILLER_100_98 VPWR VGND sg13g2_fill_1
XFILLER_69_89 VPWR VGND sg13g2_fill_1
X_0611_ Tile_X0Y0_IHP_BRAM_top.Inst_IHP_BRAM_top_ConfigMem.Inst_frame3_bit2.Q Tile_X0Y0_EE4END[5]
+ Tile_X0Y0_EE4END[13] Tile_X0Y0_E6END[5] Tile_X0Y0_IHP_BRAM_top.Inst_IHP_BRAM_top_switch_matrix.J_NS4_BEG5
+ Tile_X0Y0_IHP_BRAM_top.Inst_IHP_BRAM_top_ConfigMem.Inst_frame3_bit3.Q net16 VPWR
+ VGND sg13g2_mux4_1
X_0542_ Tile_X0Y0_IHP_BRAM_top.Inst_IHP_BRAM_top_ConfigMem.Inst_frame7_bit18.Q A_DOUT_BRAM9
+ B_DOUT_BRAM9 Tile_X0Y0_IHP_BRAM_top.Inst_IHP_BRAM_top_switch_matrix.J_NS2_BEG1 Tile_X0Y0_IHP_BRAM_top.Inst_IHP_BRAM_top_switch_matrix.J_NS2_BEG6
+ Tile_X0Y0_IHP_BRAM_top.Inst_IHP_BRAM_top_ConfigMem.Inst_frame7_bit19.Q Tile_X0Y0_IHP_BRAM_top.Inst_IHP_BRAM_top_switch_matrix.W2BEG1
+ VPWR VGND sg13g2_mux4_1
X_1591_ Tile_X0Y1_FrameData[20] Tile_X0Y1_FrameStrobe[7] Tile_X0Y1_IHP_BRAM_bot.Inst_IHP_BRAM_bot_ConfigMem.Inst_frame7_bit20.Q
+ VPWR VGND sg13g2_dlhq_1
X_1660_ Tile_X0Y1_FrameData[15] Tile_X0Y1_FrameStrobe[9] Tile_X0Y1_IHP_BRAM_bot.Inst_IHP_BRAM_bot_ConfigMem.Inst_frame9_bit15.Q
+ VPWR VGND sg13g2_dlhq_1
X_0473_ Tile_X0Y0_IHP_BRAM_top.Inst_IHP_BRAM_top_ConfigMem.Inst_frame9_bit2.Q Tile_X0Y0_E1END[1]
+ Tile_X0Y0_E6END[5] Tile_X0Y0_IHP_BRAM_top.Inst_IHP_BRAM_top_switch_matrix.J_NS4_BEG13
+ _0080_ Tile_X0Y0_IHP_BRAM_top.Inst_IHP_BRAM_top_ConfigMem.Inst_frame9_bit3.Q Tile_X0Y0_IHP_BRAM_top.Inst_IHP_BRAM_top_switch_matrix.N1BEG1
+ VPWR VGND sg13g2_mux4_1
XFILLER_85_208 VPWR VGND sg13g2_fill_1
X_1025_ _0366_ VPWR _0367_ VGND Tile_X0Y1_E2END[4] Tile_X0Y1_IHP_BRAM_bot.Inst_IHP_BRAM_bot_ConfigMem.Inst_frame3_bit28.Q
+ sg13g2_o21ai_1
X_1858_ Tile_X0Y1_IHP_BRAM_bot.Inst_IHP_BRAM_bot_switch_matrix.S2BEG3 net269 VPWR
+ VGND sg13g2_buf_1
X_1927_ Tile_X0Y1_IHP_BRAM_bot.Inst_IHP_BRAM_bot_switch_matrix.WW4BEG8 net344 VPWR
+ VGND sg13g2_buf_1
X_0809_ Tile_X0Y1_IHP_BRAM_bot.Inst_IHP_BRAM_bot_ConfigMem.Inst_frame1_bit26.Q Tile_X0Y1_N1END[1]
+ Tile_X0Y1_N4END[1] _0081_ Tile_X0Y0_S4END[5] Tile_X0Y1_IHP_BRAM_bot.Inst_IHP_BRAM_bot_ConfigMem.Inst_frame1_bit27.Q
+ Tile_X0Y1_IHP_BRAM_bot.Inst_IHP_BRAM_bot_switch_matrix.J_NS4_BEG9 VPWR VGND sg13g2_mux4_1
X_1789_ Tile_X0Y0_IHP_BRAM_top.Inst_IHP_BRAM_top_switch_matrix.W2BEGb6 net200 VPWR
+ VGND sg13g2_buf_1
XFILLER_105_0 VPWR VGND sg13g2_fill_1
XFILLER_35_105 VPWR VGND sg13g2_fill_1
XFILLER_35_127 VPWR VGND sg13g2_decap_8
X_1712_ Tile_X0Y0_FrameData[30] net116 VPWR VGND sg13g2_buf_1
XANTENNA_1 VPWR VGND net17 sg13g2_antennanp
X_1643_ Tile_X0Y1_FrameData[0] Tile_X0Y1_FrameStrobe[8] Tile_X0Y1_IHP_BRAM_bot.Inst_IHP_BRAM_bot_ConfigMem.Inst_frame8_bit0.Q
+ VPWR VGND sg13g2_dlhq_1
X_1574_ Tile_X0Y1_FrameData[5] Tile_X0Y1_FrameStrobe[6] Tile_X0Y1_IHP_BRAM_bot.Inst_IHP_BRAM_bot_ConfigMem.Inst_frame6_bit5.Q
+ VPWR VGND sg13g2_dlhq_1
X_0525_ Tile_X0Y1_IHP_BRAM_bot.Inst_IHP_BRAM_bot_ConfigMem.Inst_frame9_bit22.Q Tile_X0Y1_E2MID[0]
+ Tile_X0Y1_E2END[0] Tile_X0Y1_E6END[0] _0107_ Tile_X0Y1_IHP_BRAM_bot.Inst_IHP_BRAM_bot_ConfigMem.Inst_frame9_bit23.Q
+ Tile_X0Y0_IHP_BRAM_top.Inst_IHP_BRAM_top_switch_matrix.N2BEGb7 VPWR VGND sg13g2_mux4_1
X_0456_ _0071_ Tile_X0Y1_IHP_BRAM_bot.Inst_IHP_BRAM_bot_ConfigMem.Inst_frame3_bit25.Q
+ _0072_ VPWR VGND sg13g2_nor2b_1
X_0387_ VPWR _0010_ Tile_X0Y0_E6END[0] VGND sg13g2_inv_1
XFILLER_81_211 VPWR VGND sg13g2_fill_1
X_1008_ VGND VPWR Tile_X0Y1_E2MID[6] Tile_X0Y1_IHP_BRAM_bot.Inst_IHP_BRAM_bot_ConfigMem.Inst_frame3_bit18.Q
+ _0351_ _0345_ sg13g2_a21oi_1
XFILLER_72_211 VPWR VGND sg13g2_fill_1
Xoutput93 net93 Tile_X0Y0_FrameData_O[0] VPWR VGND sg13g2_buf_1
Xoutput3 net3 A_ADDR_BRAM2 VPWR VGND sg13g2_buf_1
Xoutput82 net82 B_DIN_BRAM2 VPWR VGND sg13g2_buf_1
Xoutput71 net71 B_BM_BRAM8 VPWR VGND sg13g2_buf_1
Xoutput60 net60 B_BM_BRAM11 VPWR VGND sg13g2_buf_1
X_1290_ Tile_X0Y0_FrameData[1] Tile_X0Y1_FrameStrobe[7] Tile_X0Y0_IHP_BRAM_top.Inst_IHP_BRAM_top_ConfigMem.Inst_frame7_bit1.Q
+ VPWR VGND sg13g2_dlhq_1
X_1626_ Tile_X0Y1_FrameData[17] Tile_X0Y1_FrameStrobe[8] Tile_X0Y1_IHP_BRAM_bot.Inst_IHP_BRAM_bot_ConfigMem.Inst_frame8_bit17.Q
+ VPWR VGND sg13g2_dlhq_1
X_0439_ Tile_X0Y0_IHP_BRAM_top.Inst_IHP_BRAM_top_ConfigMem.Inst_frame1_bit2.Q Tile_X0Y0_S2END[2]
+ _0059_ VPWR VGND Tile_X0Y0_IHP_BRAM_top.Inst_IHP_BRAM_top_ConfigMem.Inst_frame1_bit1.Q
+ sg13g2_nand3b_1
X_1488_ Tile_X0Y1_FrameData[27] Tile_X0Y1_FrameStrobe[4] Tile_X0Y1_IHP_BRAM_bot.Inst_IHP_BRAM_bot_ConfigMem.Inst_frame4_bit27.Q
+ VPWR VGND sg13g2_dlhq_1
X_1557_ Tile_X0Y1_FrameData[22] Tile_X0Y1_FrameStrobe[6] Tile_X0Y1_IHP_BRAM_bot.Inst_IHP_BRAM_bot_ConfigMem.Inst_frame6_bit22.Q
+ VPWR VGND sg13g2_dlhq_1
X_0508_ Tile_X0Y1_IHP_BRAM_bot.Inst_IHP_BRAM_bot_ConfigMem.Inst_frame0_bit14.Q Tile_X0Y1_N2MID[3]
+ Tile_X0Y1_N2END[3] Tile_X0Y0_IHP_BRAM_top.Inst_IHP_BRAM_top_switch_matrix.S2BEG3
+ Tile_X0Y0_S2MID[3] Tile_X0Y1_IHP_BRAM_bot.Inst_IHP_BRAM_bot_ConfigMem.Inst_frame0_bit15.Q
+ _0104_ VPWR VGND sg13g2_mux4_1
XFILLER_89_185 VPWR VGND sg13g2_fill_1
X_0790_ Tile_X0Y1_IHP_BRAM_bot.Inst_IHP_BRAM_bot_ConfigMem.Inst_frame7_bit26.Q A_DOUT_BRAM5
+ B_DOUT_BRAM5 _0103_ _0106_ Tile_X0Y1_IHP_BRAM_bot.Inst_IHP_BRAM_bot_ConfigMem.Inst_frame7_bit27.Q
+ Tile_X0Y1_IHP_BRAM_bot.Inst_IHP_BRAM_bot_switch_matrix.W2BEG5 VPWR VGND sg13g2_mux4_1
X_1342_ Tile_X0Y0_FrameData[13] Tile_X0Y1_FrameStrobe[9] Tile_X0Y0_IHP_BRAM_top.Inst_IHP_BRAM_top_ConfigMem.Inst_frame9_bit13.Q
+ VPWR VGND sg13g2_dlhq_1
X_1273_ Tile_X0Y0_FrameData[18] Tile_X0Y1_FrameStrobe[7] Tile_X0Y0_IHP_BRAM_top.Inst_IHP_BRAM_top_ConfigMem.Inst_frame7_bit18.Q
+ VPWR VGND sg13g2_dlhq_1
X_1411_ Tile_X0Y1_FrameData[8] Tile_X0Y1_FrameStrobe[1] Tile_X0Y1_IHP_BRAM_bot.Inst_IHP_BRAM_bot_ConfigMem.Inst_frame1_bit8.Q
+ VPWR VGND sg13g2_dlhq_1
XFILLER_51_214 VPWR VGND sg13g2_fill_2
X_0988_ VGND VPWR _0034_ _0331_ _0333_ _0332_ sg13g2_a21oi_1
X_1609_ Tile_X0Y1_FrameData[2] Tile_X0Y1_FrameStrobe[7] Tile_X0Y1_IHP_BRAM_bot.Inst_IHP_BRAM_bot_ConfigMem.Inst_frame7_bit2.Q
+ VPWR VGND sg13g2_dlhq_1
XFILLER_103_98 VPWR VGND sg13g2_fill_1
XFILLER_12_73 VPWR VGND sg13g2_fill_1
XFILLER_88_44 VPWR VGND sg13g2_decap_8
XFILLER_77_144 VPWR VGND sg13g2_fill_1
XFILLER_18_211 VPWR VGND sg13g2_fill_1
XFILLER_37_92 VPWR VGND sg13g2_fill_2
X_0842_ Tile_X0Y1_IHP_BRAM_bot.Inst_IHP_BRAM_bot_ConfigMem.Inst_frame4_bit8.Q Tile_X0Y1_E2MID[0]
+ _0235_ VPWR VGND sg13g2_nor2b_1
X_1891_ Tile_X0Y1_IHP_BRAM_bot.Inst_IHP_BRAM_bot_switch_matrix.W2BEG0 net302 VPWR
+ VGND sg13g2_buf_1
X_0911_ Tile_X0Y1_IHP_BRAM_bot.Inst_IHP_BRAM_bot_ConfigMem.Inst_frame1_bit4.Q Tile_X0Y1_E1END[2]
+ Tile_X0Y1_EE4END[6] Tile_X0Y1_EE4END[14] Tile_X0Y1_IHP_BRAM_bot.Inst_IHP_BRAM_bot_switch_matrix.J_NS4_BEG14
+ Tile_X0Y1_IHP_BRAM_bot.Inst_IHP_BRAM_bot_ConfigMem.Inst_frame1_bit5.Q net69 VPWR
+ VGND sg13g2_mux4_1
X_0773_ Tile_X0Y1_IHP_BRAM_bot.Inst_IHP_BRAM_bot_ConfigMem.Inst_frame8_bit12.Q Tile_X0Y1_E2MID[7]
+ Tile_X0Y1_E2END[7] Tile_X0Y1_E6END[8] _0065_ Tile_X0Y1_IHP_BRAM_bot.Inst_IHP_BRAM_bot_ConfigMem.Inst_frame8_bit13.Q
+ Tile_X0Y1_IHP_BRAM_bot.Inst_IHP_BRAM_bot_switch_matrix.S2BEG0 VPWR VGND sg13g2_mux4_1
X_1325_ Tile_X0Y0_FrameData[30] Tile_X0Y1_FrameStrobe[9] Tile_X0Y0_IHP_BRAM_top.Inst_IHP_BRAM_top_ConfigMem.Inst_frame9_bit30.Q
+ VPWR VGND sg13g2_dlhq_1
XFILLER_68_100 VPWR VGND sg13g2_fill_2
X_1256_ Tile_X0Y0_FrameData[3] Tile_X0Y1_FrameStrobe[6] Tile_X0Y0_IHP_BRAM_top.Inst_IHP_BRAM_top_ConfigMem.Inst_frame6_bit3.Q
+ VPWR VGND sg13g2_dlhq_1
X_1187_ Tile_X0Y0_FrameData[8] Tile_X0Y1_FrameStrobe[4] Tile_X0Y0_IHP_BRAM_top.Inst_IHP_BRAM_top_ConfigMem.Inst_frame4_bit8.Q
+ VPWR VGND sg13g2_dlhq_1
Xoutput250 net250 Tile_X0Y1_FrameData_O[28] VPWR VGND sg13g2_buf_1
XFILLER_59_122 VPWR VGND sg13g2_decap_8
Xoutput272 net272 Tile_X0Y1_S2BEG[6] VPWR VGND sg13g2_buf_1
Xoutput283 net283 Tile_X0Y1_S4BEG[10] VPWR VGND sg13g2_buf_1
Xoutput294 net294 Tile_X0Y1_S4BEG[6] VPWR VGND sg13g2_buf_1
Xoutput261 net261 Tile_X0Y1_FrameData_O[9] VPWR VGND sg13g2_buf_1
XFILLER_74_114 VPWR VGND sg13g2_fill_2
XFILLER_82_191 VPWR VGND sg13g2_fill_1
X_1110_ Tile_X0Y0_FrameData[21] Tile_X0Y1_FrameStrobe[2] Tile_X0Y0_IHP_BRAM_top.Inst_IHP_BRAM_top_ConfigMem.Inst_frame2_bit21.Q
+ VPWR VGND sg13g2_dlhq_1
X_1041_ Tile_X0Y0_FrameData[26] Tile_X0Y1_FrameStrobe[0] Tile_X0Y0_IHP_BRAM_top.Inst_IHP_BRAM_top_ConfigMem.Inst_frame0_bit26.Q
+ VPWR VGND sg13g2_dlhq_1
X_1874_ Tile_X0Y0_S4END[11] net291 VPWR VGND sg13g2_buf_1
X_0825_ Tile_X0Y1_IHP_BRAM_bot.Inst_IHP_BRAM_bot_ConfigMem.Inst_frame1_bit10.Q Tile_X0Y1_N1END[1]
+ Tile_X0Y1_N4END[1] _0081_ Tile_X0Y0_S4END[5] Tile_X0Y1_IHP_BRAM_bot.Inst_IHP_BRAM_bot_ConfigMem.Inst_frame1_bit11.Q
+ _0232_ VPWR VGND sg13g2_mux4_1
X_0687_ Tile_X0Y0_IHP_BRAM_top.Inst_IHP_BRAM_top_ConfigMem.Inst_frame8_bit3.Q VPWR
+ _0160_ VGND _0158_ _0159_ sg13g2_o21ai_1
X_0756_ VGND VPWR Tile_X0Y0_IHP_BRAM_top.Inst_IHP_BRAM_top_ConfigMem.Inst_frame1_bit5.Q
+ _0217_ _0219_ _0218_ sg13g2_a21oi_1
XFILLER_50_0 VPWR VGND sg13g2_decap_8
X_1308_ Tile_X0Y0_FrameData[15] Tile_X0Y1_FrameStrobe[8] Tile_X0Y0_IHP_BRAM_top.Inst_IHP_BRAM_top_ConfigMem.Inst_frame8_bit15.Q
+ VPWR VGND sg13g2_dlhq_1
X_1239_ Tile_X0Y0_FrameData[20] Tile_X0Y1_FrameStrobe[6] Tile_X0Y0_IHP_BRAM_top.Inst_IHP_BRAM_top_ConfigMem.Inst_frame6_bit20.Q
+ VPWR VGND sg13g2_dlhq_1
XFILLER_109_20 VPWR VGND sg13g2_fill_1
XFILLER_69_57 VPWR VGND sg13g2_fill_2
XFILLER_55_180 VPWR VGND sg13g2_decap_8
XFILLER_109_182 VPWR VGND sg13g2_fill_1
X_0472_ Tile_X0Y0_IHP_BRAM_top.Inst_IHP_BRAM_top_ConfigMem.Inst_frame0_bit2.Q Tile_X0Y0_IHP_BRAM_top.Inst_IHP_BRAM_top_switch_matrix.N1END1
+ Tile_X0Y1_N4END[5] Tile_X0Y0_S1END[1] Tile_X0Y0_S4END[1] Tile_X0Y0_IHP_BRAM_top.Inst_IHP_BRAM_top_ConfigMem.Inst_frame0_bit3.Q
+ Tile_X0Y0_IHP_BRAM_top.Inst_IHP_BRAM_top_switch_matrix.J_NS4_BEG13 VPWR VGND sg13g2_mux4_1
X_0610_ Tile_X0Y0_IHP_BRAM_top.Inst_IHP_BRAM_top_ConfigMem.Inst_frame3_bit0.Q Tile_X0Y0_EE4END[4]
+ Tile_X0Y0_EE4END[12] Tile_X0Y0_E6END[4] Tile_X0Y0_IHP_BRAM_top.Inst_IHP_BRAM_top_switch_matrix.J_NS4_BEG4
+ Tile_X0Y0_IHP_BRAM_top.Inst_IHP_BRAM_top_ConfigMem.Inst_frame3_bit1.Q net15 VPWR
+ VGND sg13g2_mux4_1
X_0541_ Tile_X0Y0_IHP_BRAM_top.Inst_IHP_BRAM_top_ConfigMem.Inst_frame7_bit16.Q A_DOUT_BRAM8
+ B_DOUT_BRAM8 Tile_X0Y0_IHP_BRAM_top.Inst_IHP_BRAM_top_switch_matrix.J_NS2_BEG0 Tile_X0Y0_IHP_BRAM_top.Inst_IHP_BRAM_top_switch_matrix.J_NS2_BEG7
+ Tile_X0Y0_IHP_BRAM_top.Inst_IHP_BRAM_top_ConfigMem.Inst_frame7_bit17.Q Tile_X0Y0_IHP_BRAM_top.Inst_IHP_BRAM_top_switch_matrix.W2BEG0
+ VPWR VGND sg13g2_mux4_1
X_1590_ Tile_X0Y1_FrameData[21] Tile_X0Y1_FrameStrobe[7] Tile_X0Y1_IHP_BRAM_bot.Inst_IHP_BRAM_bot_ConfigMem.Inst_frame7_bit21.Q
+ VPWR VGND sg13g2_dlhq_1
XFILLER_50_70 VPWR VGND sg13g2_fill_1
XFILLER_50_92 VPWR VGND sg13g2_fill_2
X_1024_ _0366_ Tile_X0Y1_IHP_BRAM_bot.Inst_IHP_BRAM_bot_ConfigMem.Inst_frame3_bit28.Q
+ Tile_X0Y0_S2MID[3] VPWR VGND sg13g2_nand2b_1
X_1788_ Tile_X0Y0_IHP_BRAM_top.Inst_IHP_BRAM_top_switch_matrix.W2BEGb5 net199 VPWR
+ VGND sg13g2_buf_1
X_0808_ Tile_X0Y1_IHP_BRAM_bot.Inst_IHP_BRAM_bot_ConfigMem.Inst_frame6_bit26.Q A_DOUT_BRAM5
+ B_DOUT_BRAM1 Tile_X0Y1_IHP_BRAM_bot.Inst_IHP_BRAM_bot_switch_matrix.J_NS4_BEG10
+ _0103_ Tile_X0Y1_IHP_BRAM_bot.Inst_IHP_BRAM_bot_ConfigMem.Inst_frame6_bit27.Q Tile_X0Y1_IHP_BRAM_bot.Inst_IHP_BRAM_bot_switch_matrix.WW4BEG5
+ VPWR VGND sg13g2_mux4_1
X_1857_ Tile_X0Y1_IHP_BRAM_bot.Inst_IHP_BRAM_bot_switch_matrix.S2BEG2 net268 VPWR
+ VGND sg13g2_buf_1
X_1926_ Tile_X0Y1_IHP_BRAM_bot.Inst_IHP_BRAM_bot_switch_matrix.WW4BEG7 net343 VPWR
+ VGND sg13g2_buf_1
X_0739_ Tile_X0Y0_IHP_BRAM_top.Inst_IHP_BRAM_top_ConfigMem.Inst_frame2_bit30.Q VPWR
+ _0203_ VGND Tile_X0Y0_S2END[3] Tile_X0Y0_IHP_BRAM_top.Inst_IHP_BRAM_top_ConfigMem.Inst_frame2_bit29.Q
+ sg13g2_o21ai_1
XFILLER_71_14 VPWR VGND sg13g2_fill_1
XFILLER_96_66 VPWR VGND sg13g2_fill_2
X_1711_ Tile_X0Y0_FrameData[29] net114 VPWR VGND sg13g2_buf_1
XANTENNA_2 VPWR VGND net31 sg13g2_antennanp
X_1642_ Tile_X0Y1_FrameData[1] Tile_X0Y1_FrameStrobe[8] Tile_X0Y1_IHP_BRAM_bot.Inst_IHP_BRAM_bot_ConfigMem.Inst_frame8_bit1.Q
+ VPWR VGND sg13g2_dlhq_1
X_1573_ Tile_X0Y1_FrameData[6] Tile_X0Y1_FrameStrobe[6] Tile_X0Y1_IHP_BRAM_bot.Inst_IHP_BRAM_bot_ConfigMem.Inst_frame6_bit6.Q
+ VPWR VGND sg13g2_dlhq_1
X_0524_ Tile_X0Y1_IHP_BRAM_bot.Inst_IHP_BRAM_bot_ConfigMem.Inst_frame0_bit22.Q Tile_X0Y1_N2MID[7]
+ Tile_X0Y1_N2END[7] Tile_X0Y0_IHP_BRAM_top.Inst_IHP_BRAM_top_switch_matrix.S2BEG7
+ Tile_X0Y0_S2MID[7] Tile_X0Y1_IHP_BRAM_bot.Inst_IHP_BRAM_bot_ConfigMem.Inst_frame0_bit23.Q
+ _0107_ VPWR VGND sg13g2_mux4_1
X_0455_ VPWR VGND _0070_ Tile_X0Y1_IHP_BRAM_bot.Inst_IHP_BRAM_bot_ConfigMem.Inst_frame3_bit22.Q
+ _0069_ Tile_X0Y1_IHP_BRAM_bot.Inst_IHP_BRAM_bot_ConfigMem.Inst_frame3_bit24.Q _0071_
+ _0006_ sg13g2_a221oi_1
X_0386_ VPWR _0009_ Tile_X0Y0_E6END[3] VGND sg13g2_inv_1
X_1007_ VGND VPWR Tile_X0Y1_E2END[2] Tile_X0Y1_IHP_BRAM_bot.Inst_IHP_BRAM_bot_ConfigMem.Inst_frame3_bit18.Q
+ _0350_ _0349_ sg13g2_a21oi_1
XFILLER_34_183 VPWR VGND sg13g2_fill_2
X_1909_ Tile_X0Y1_IHP_BRAM_bot.Inst_IHP_BRAM_bot_switch_matrix.W6BEG2 net322 VPWR
+ VGND sg13g2_buf_1
XFILLER_25_172 VPWR VGND sg13g2_fill_1
XFILLER_40_142 VPWR VGND sg13g2_decap_8
Xoutput94 net94 Tile_X0Y0_FrameData_O[10] VPWR VGND sg13g2_buf_1
Xoutput50 net50 B_ADDR_BRAM3 VPWR VGND sg13g2_buf_1
Xoutput4 net4 A_ADDR_BRAM3 VPWR VGND sg13g2_buf_1
Xoutput61 net61 B_BM_BRAM12 VPWR VGND sg13g2_buf_1
Xoutput83 net83 B_DIN_BRAM3 VPWR VGND sg13g2_buf_1
Xoutput72 net72 B_BM_BRAM9 VPWR VGND sg13g2_buf_1
XFILLER_16_194 VPWR VGND sg13g2_fill_1
X_1556_ Tile_X0Y1_FrameData[23] Tile_X0Y1_FrameStrobe[6] Tile_X0Y1_IHP_BRAM_bot.Inst_IHP_BRAM_bot_ConfigMem.Inst_frame6_bit23.Q
+ VPWR VGND sg13g2_dlhq_1
X_1625_ Tile_X0Y1_FrameData[18] Tile_X0Y1_FrameStrobe[8] Tile_X0Y1_IHP_BRAM_bot.Inst_IHP_BRAM_bot_ConfigMem.Inst_frame8_bit18.Q
+ VPWR VGND sg13g2_dlhq_1
XFILLER_98_175 VPWR VGND sg13g2_fill_2
X_0507_ Tile_X0Y0_IHP_BRAM_top.Inst_IHP_BRAM_top_ConfigMem.Inst_frame8_bit19.Q Tile_X0Y0_E2MID[4]
+ Tile_X0Y0_E6END[11] Tile_X0Y0_E2END[4] Tile_X0Y0_IHP_BRAM_top.Inst_IHP_BRAM_top_switch_matrix.J_NS2_BEG3
+ Tile_X0Y0_IHP_BRAM_top.Inst_IHP_BRAM_top_ConfigMem.Inst_frame8_bit18.Q Tile_X0Y0_IHP_BRAM_top.Inst_IHP_BRAM_top_switch_matrix.S2BEG3
+ VPWR VGND sg13g2_mux4_1
X_0438_ Tile_X0Y0_IHP_BRAM_top.Inst_IHP_BRAM_top_ConfigMem.Inst_frame1_bit0.Q VPWR
+ _0058_ VGND _0054_ _0057_ sg13g2_o21ai_1
X_1487_ Tile_X0Y1_FrameData[28] Tile_X0Y1_FrameStrobe[4] Tile_X0Y1_IHP_BRAM_bot.Inst_IHP_BRAM_bot_ConfigMem.Inst_frame4_bit28.Q
+ VPWR VGND sg13g2_dlhq_1
XFILLER_108_214 VPWR VGND sg13g2_fill_2
XFILLER_60_215 VPWR VGND sg13g2_fill_1
X_1410_ Tile_X0Y1_FrameData[9] Tile_X0Y1_FrameStrobe[1] Tile_X0Y1_IHP_BRAM_bot.Inst_IHP_BRAM_bot_ConfigMem.Inst_frame1_bit9.Q
+ VPWR VGND sg13g2_dlhq_1
XFILLER_95_156 VPWR VGND sg13g2_decap_8
XFILLER_95_101 VPWR VGND sg13g2_fill_1
X_1341_ Tile_X0Y0_FrameData[14] Tile_X0Y1_FrameStrobe[9] Tile_X0Y0_IHP_BRAM_top.Inst_IHP_BRAM_top_ConfigMem.Inst_frame9_bit14.Q
+ VPWR VGND sg13g2_dlhq_1
X_1272_ Tile_X0Y0_FrameData[19] Tile_X0Y1_FrameStrobe[7] Tile_X0Y0_IHP_BRAM_top.Inst_IHP_BRAM_top_ConfigMem.Inst_frame7_bit19.Q
+ VPWR VGND sg13g2_dlhq_1
X_0987_ Tile_X0Y1_IHP_BRAM_bot.Inst_IHP_BRAM_bot_ConfigMem.Inst_frame7_bit4.Q VPWR
+ _0332_ VGND _0329_ _0330_ sg13g2_o21ai_1
X_1539_ Tile_X0Y1_FrameData[8] Tile_X0Y1_FrameStrobe[5] Tile_X0Y1_IHP_BRAM_bot.Inst_IHP_BRAM_bot_ConfigMem.Inst_frame5_bit8.Q
+ VPWR VGND sg13g2_dlhq_1
X_1608_ Tile_X0Y1_FrameData[3] Tile_X0Y1_FrameStrobe[7] Tile_X0Y1_IHP_BRAM_bot.Inst_IHP_BRAM_bot_ConfigMem.Inst_frame7_bit3.Q
+ VPWR VGND sg13g2_dlhq_1
XFILLER_12_41 VPWR VGND sg13g2_fill_2
XFILLER_92_115 VPWR VGND sg13g2_fill_2
XFILLER_92_104 VPWR VGND sg13g2_decap_4
XFILLER_77_167 VPWR VGND sg13g2_fill_2
X_0841_ Tile_X0Y1_IHP_BRAM_bot.Inst_IHP_BRAM_bot_ConfigMem.Inst_frame4_bit9.Q _0065_
+ _0234_ VPWR VGND Tile_X0Y1_IHP_BRAM_bot.Inst_IHP_BRAM_bot_ConfigMem.Inst_frame4_bit8.Q
+ sg13g2_nand3b_1
X_1890_ Tile_X0Y1_IHP_BRAM_bot.Inst_IHP_BRAM_bot_switch_matrix.W1BEG3 net301 VPWR
+ VGND sg13g2_buf_1
X_0910_ Tile_X0Y1_IHP_BRAM_bot.Inst_IHP_BRAM_bot_ConfigMem.Inst_frame1_bit2.Q Tile_X0Y1_E1END[1]
+ Tile_X0Y1_EE4END[5] Tile_X0Y1_EE4END[13] Tile_X0Y1_IHP_BRAM_bot.Inst_IHP_BRAM_bot_switch_matrix.J_NS4_BEG13
+ Tile_X0Y1_IHP_BRAM_bot.Inst_IHP_BRAM_bot_ConfigMem.Inst_frame1_bit3.Q net68 VPWR
+ VGND sg13g2_mux4_1
X_0772_ Tile_X0Y1_IHP_BRAM_bot.Inst_IHP_BRAM_bot_ConfigMem.Inst_frame8_bit10.Q Tile_X0Y1_E1END[3]
+ Tile_X0Y1_E6END[11] Tile_X0Y1_IHP_BRAM_bot.Inst_IHP_BRAM_bot_switch_matrix.J_NS4_BEG15
+ _0101_ Tile_X0Y1_IHP_BRAM_bot.Inst_IHP_BRAM_bot_ConfigMem.Inst_frame8_bit11.Q Tile_X0Y1_IHP_BRAM_bot.Inst_IHP_BRAM_bot_switch_matrix.S1BEG3
+ VPWR VGND sg13g2_mux4_1
X_1324_ Tile_X0Y0_FrameData[31] Tile_X0Y1_FrameStrobe[9] Tile_X0Y0_IHP_BRAM_top.Inst_IHP_BRAM_top_ConfigMem.Inst_frame9_bit31.Q
+ VPWR VGND sg13g2_dlhq_1
X_1186_ Tile_X0Y0_FrameData[9] Tile_X0Y1_FrameStrobe[4] Tile_X0Y0_IHP_BRAM_top.Inst_IHP_BRAM_top_ConfigMem.Inst_frame4_bit9.Q
+ VPWR VGND sg13g2_dlhq_1
XFILLER_68_189 VPWR VGND sg13g2_fill_1
XFILLER_68_178 VPWR VGND sg13g2_decap_8
XFILLER_68_123 VPWR VGND sg13g2_fill_1
X_1255_ Tile_X0Y0_FrameData[4] Tile_X0Y1_FrameStrobe[6] Tile_X0Y0_IHP_BRAM_top.Inst_IHP_BRAM_top_ConfigMem.Inst_frame6_bit4.Q
+ VPWR VGND sg13g2_dlhq_1
XFILLER_24_215 VPWR VGND sg13g2_fill_1
Xoutput251 net251 Tile_X0Y1_FrameData_O[29] VPWR VGND sg13g2_buf_1
Xoutput240 net240 Tile_X0Y1_FrameData_O[19] VPWR VGND sg13g2_buf_1
XFILLER_58_37 VPWR VGND sg13g2_fill_2
Xoutput284 net284 Tile_X0Y1_S4BEG[11] VPWR VGND sg13g2_buf_1
Xoutput295 net295 Tile_X0Y1_S4BEG[7] VPWR VGND sg13g2_buf_1
Xoutput262 net262 Tile_X0Y1_S1BEG[0] VPWR VGND sg13g2_buf_1
Xoutput273 net273 Tile_X0Y1_S2BEG[7] VPWR VGND sg13g2_buf_1
XFILLER_82_170 VPWR VGND sg13g2_fill_2
XFILLER_74_159 VPWR VGND sg13g2_fill_1
XFILLER_15_215 VPWR VGND sg13g2_fill_1
XFILLER_99_22 VPWR VGND sg13g2_fill_2
XFILLER_90_24 VPWR VGND sg13g2_decap_8
X_1040_ Tile_X0Y0_FrameData[27] Tile_X0Y1_FrameStrobe[0] Tile_X0Y0_IHP_BRAM_top.Inst_IHP_BRAM_top_ConfigMem.Inst_frame0_bit27.Q
+ VPWR VGND sg13g2_dlhq_1
XFILLER_65_126 VPWR VGND sg13g2_decap_8
XFILLER_65_104 VPWR VGND sg13g2_fill_1
XFILLER_2_196 VPWR VGND sg13g2_fill_1
X_1873_ Tile_X0Y0_S4END[10] net290 VPWR VGND sg13g2_buf_1
X_0755_ Tile_X0Y0_IHP_BRAM_top.Inst_IHP_BRAM_top_ConfigMem.Inst_frame1_bit6.Q VPWR
+ _0218_ VGND Tile_X0Y0_IHP_BRAM_top.Inst_IHP_BRAM_top_ConfigMem.Inst_frame1_bit5.Q
+ _0216_ sg13g2_o21ai_1
X_0824_ Tile_X0Y1_IHP_BRAM_bot.Inst_IHP_BRAM_bot_ConfigMem.Inst_frame5_bit10.Q A_DOUT_BRAM1
+ B_DOUT_BRAM5 _0231_ _0103_ Tile_X0Y1_IHP_BRAM_bot.Inst_IHP_BRAM_bot_ConfigMem.Inst_frame5_bit11.Q
+ Tile_X0Y1_IHP_BRAM_bot.Inst_IHP_BRAM_bot_switch_matrix.WW4BEG13 VPWR VGND sg13g2_mux4_1
X_0686_ Tile_X0Y0_IHP_BRAM_top.Inst_IHP_BRAM_top_ConfigMem.Inst_frame8_bit2.Q VPWR
+ _0159_ VGND Tile_X0Y0_IHP_BRAM_top.Inst_IHP_BRAM_top_ConfigMem.Inst_frame8_bit1.Q
+ Tile_X0Y0_IHP_BRAM_top.Inst_IHP_BRAM_top_switch_matrix.J_NS4_BEG15 sg13g2_o21ai_1
XFILLER_28_18 VPWR VGND sg13g2_fill_2
XFILLER_43_0 VPWR VGND sg13g2_fill_1
X_1169_ Tile_X0Y0_FrameData[26] Tile_X0Y1_FrameStrobe[4] Tile_X0Y0_IHP_BRAM_top.Inst_IHP_BRAM_top_ConfigMem.Inst_frame4_bit26.Q
+ VPWR VGND sg13g2_dlhq_1
X_1307_ Tile_X0Y0_FrameData[16] Tile_X0Y1_FrameStrobe[8] Tile_X0Y0_IHP_BRAM_top.Inst_IHP_BRAM_top_ConfigMem.Inst_frame8_bit16.Q
+ VPWR VGND sg13g2_dlhq_1
X_1238_ Tile_X0Y0_FrameData[21] Tile_X0Y1_FrameStrobe[6] Tile_X0Y0_IHP_BRAM_top.Inst_IHP_BRAM_top_ConfigMem.Inst_frame6_bit21.Q
+ VPWR VGND sg13g2_dlhq_1
XFILLER_64_192 VPWR VGND sg13g2_fill_2
XFILLER_34_61 VPWR VGND sg13g2_decap_8
X_0471_ Tile_X0Y1_IHP_BRAM_bot.Inst_IHP_BRAM_bot_ConfigMem.Inst_frame9_bit3.Q Tile_X0Y1_E1END[1]
+ Tile_X0Y1_IHP_BRAM_bot.Inst_IHP_BRAM_bot_switch_matrix.J_NS4_BEG13 Tile_X0Y1_E6END[5]
+ _0085_ Tile_X0Y1_IHP_BRAM_bot.Inst_IHP_BRAM_bot_ConfigMem.Inst_frame9_bit2.Q Tile_X0Y0_IHP_BRAM_top.Inst_IHP_BRAM_top_switch_matrix.N1END1
+ VPWR VGND sg13g2_mux4_1
X_0540_ Tile_X0Y0_IHP_BRAM_top.Inst_IHP_BRAM_top_ConfigMem.Inst_frame7_bit15.Q Tile_X0Y0_IHP_BRAM_top.Inst_IHP_BRAM_top_switch_matrix.N1END3
+ A_DOUT_BRAM9 Tile_X0Y0_S1END[3] A_DOUT_BRAM12 Tile_X0Y0_IHP_BRAM_top.Inst_IHP_BRAM_top_ConfigMem.Inst_frame7_bit14.Q
+ Tile_X0Y0_IHP_BRAM_top.Inst_IHP_BRAM_top_switch_matrix.W1BEG3 VPWR VGND sg13g2_mux4_1
XFILLER_93_210 VPWR VGND sg13g2_fill_2
X_1023_ _0039_ Tile_X0Y1_IHP_BRAM_bot.Inst_IHP_BRAM_bot_ConfigMem.Inst_frame3_bit28.Q
+ Tile_X0Y0_IHP_BRAM_top.Inst_IHP_BRAM_top_switch_matrix.S2BEG0 _0365_ VPWR VGND sg13g2_nor3_1
X_1925_ Tile_X0Y1_IHP_BRAM_bot.Inst_IHP_BRAM_bot_switch_matrix.WW4BEG6 net342 VPWR
+ VGND sg13g2_buf_1
X_1787_ Tile_X0Y0_IHP_BRAM_top.Inst_IHP_BRAM_top_switch_matrix.W2BEGb4 net198 VPWR
+ VGND sg13g2_buf_1
X_0738_ _0001_ Tile_X0Y0_IHP_BRAM_top.Inst_IHP_BRAM_top_ConfigMem.Inst_frame2_bit29.Q
+ Tile_X0Y0_IHP_BRAM_top.Inst_IHP_BRAM_top_ConfigMem.Inst_frame2_bit30.Q _0202_ VPWR
+ VGND sg13g2_nor3_1
X_1856_ Tile_X0Y1_IHP_BRAM_bot.Inst_IHP_BRAM_bot_switch_matrix.S2BEG1 net267 VPWR
+ VGND sg13g2_buf_1
X_0807_ Tile_X0Y1_IHP_BRAM_bot.Inst_IHP_BRAM_bot_ConfigMem.Inst_frame1_bit28.Q Tile_X0Y1_N1END[2]
+ Tile_X0Y1_N4END[2] _0089_ Tile_X0Y0_S4END[6] Tile_X0Y1_IHP_BRAM_bot.Inst_IHP_BRAM_bot_ConfigMem.Inst_frame1_bit29.Q
+ Tile_X0Y1_IHP_BRAM_bot.Inst_IHP_BRAM_bot_switch_matrix.J_NS4_BEG10 VPWR VGND sg13g2_mux4_1
X_0669_ Tile_X0Y0_IHP_BRAM_top.Inst_IHP_BRAM_top_switch_matrix.J_NS2_BEG1 Tile_X0Y0_IHP_BRAM_top.Inst_IHP_BRAM_top_ConfigMem.Inst_frame9_bit27.Q
+ _0144_ VPWR VGND sg13g2_nor2b_1
XFILLER_29_126 VPWR VGND sg13g2_fill_2
XFILLER_44_118 VPWR VGND sg13g2_fill_2
XFILLER_71_59 VPWR VGND sg13g2_fill_2
XFILLER_106_153 VPWR VGND sg13g2_decap_8
XFILLER_29_61 VPWR VGND sg13g2_decap_4
XFILLER_28_181 VPWR VGND sg13g2_fill_2
XFILLER_43_173 VPWR VGND sg13g2_fill_2
XANTENNA_3 VPWR VGND net172 sg13g2_antennanp
X_1710_ Tile_X0Y0_FrameData[28] net113 VPWR VGND sg13g2_buf_1
X_1572_ Tile_X0Y1_FrameData[7] Tile_X0Y1_FrameStrobe[6] Tile_X0Y1_IHP_BRAM_bot.Inst_IHP_BRAM_bot_ConfigMem.Inst_frame6_bit7.Q
+ VPWR VGND sg13g2_dlhq_1
XFILLER_6_98 VPWR VGND sg13g2_fill_1
X_1641_ Tile_X0Y1_FrameData[2] Tile_X0Y1_FrameStrobe[8] Tile_X0Y1_IHP_BRAM_bot.Inst_IHP_BRAM_bot_ConfigMem.Inst_frame8_bit2.Q
+ VPWR VGND sg13g2_dlhq_1
X_0385_ VPWR _0008_ Tile_X0Y0_E6END[2] VGND sg13g2_inv_1
XFILLER_66_210 VPWR VGND sg13g2_fill_2
X_0523_ Tile_X0Y0_IHP_BRAM_top.Inst_IHP_BRAM_top_ConfigMem.Inst_frame8_bit27.Q Tile_X0Y0_E1END[3]
+ Tile_X0Y0_E2END[0] Tile_X0Y0_E2MID[0] Tile_X0Y0_IHP_BRAM_top.Inst_IHP_BRAM_top_switch_matrix.J_NS2_BEG7
+ Tile_X0Y0_IHP_BRAM_top.Inst_IHP_BRAM_top_ConfigMem.Inst_frame8_bit26.Q Tile_X0Y0_IHP_BRAM_top.Inst_IHP_BRAM_top_switch_matrix.S2BEG7
+ VPWR VGND sg13g2_mux4_1
X_0454_ Tile_X0Y1_E2END[5] Tile_X0Y1_IHP_BRAM_bot.Inst_IHP_BRAM_bot_ConfigMem.Inst_frame3_bit23.Q
+ _0070_ VPWR VGND Tile_X0Y1_IHP_BRAM_bot.Inst_IHP_BRAM_bot_ConfigMem.Inst_frame3_bit24.Q
+ sg13g2_nand3b_1
X_1006_ _0349_ Tile_X0Y1_IHP_BRAM_bot.Inst_IHP_BRAM_bot_ConfigMem.Inst_frame3_bit19.Q
+ Tile_X0Y1_IHP_BRAM_bot.Inst_IHP_BRAM_bot_ConfigMem.Inst_frame3_bit20.Q VPWR VGND
+ sg13g2_nand2_1
X_1908_ Tile_X0Y1_IHP_BRAM_bot.Inst_IHP_BRAM_bot_switch_matrix.W6BEG1 net321 VPWR
+ VGND sg13g2_buf_1
X_1839_ Tile_X0Y1_FrameData[20] net242 VPWR VGND sg13g2_buf_1
XFILLER_66_48 VPWR VGND sg13g2_fill_2
XFILLER_17_107 VPWR VGND sg13g2_fill_1
XFILLER_15_74 VPWR VGND sg13g2_fill_1
XFILLER_25_195 VPWR VGND sg13g2_fill_1
XFILLER_110_0 VPWR VGND sg13g2_fill_1
Xoutput5 net5 A_ADDR_BRAM4 VPWR VGND sg13g2_buf_1
Xoutput95 net95 Tile_X0Y0_FrameData_O[11] VPWR VGND sg13g2_buf_1
Xoutput40 net40 A_DIN_BRAM6 VPWR VGND sg13g2_buf_1
Xoutput84 net84 B_DIN_BRAM4 VPWR VGND sg13g2_buf_1
Xoutput51 net51 B_ADDR_BRAM4 VPWR VGND sg13g2_buf_1
Xoutput62 net62 B_BM_BRAM13 VPWR VGND sg13g2_buf_1
Xoutput73 net73 B_CLK_BRAM VPWR VGND sg13g2_buf_1
X_0506_ Tile_X0Y0_IHP_BRAM_top.Inst_IHP_BRAM_top_ConfigMem.Inst_frame9_bit13.Q Tile_X0Y0_E2MID[5]
+ Tile_X0Y0_E6END[5] Tile_X0Y0_E2END[5] Tile_X0Y0_IHP_BRAM_top.Inst_IHP_BRAM_top_switch_matrix.J_NS2_BEG2
+ Tile_X0Y0_IHP_BRAM_top.Inst_IHP_BRAM_top_ConfigMem.Inst_frame9_bit12.Q Tile_X0Y0_IHP_BRAM_top.Inst_IHP_BRAM_top_switch_matrix.N2BEG2
+ VPWR VGND sg13g2_mux4_1
X_1555_ Tile_X0Y1_FrameData[24] Tile_X0Y1_FrameStrobe[6] Tile_X0Y1_IHP_BRAM_bot.Inst_IHP_BRAM_bot_ConfigMem.Inst_frame6_bit24.Q
+ VPWR VGND sg13g2_dlhq_1
X_1624_ Tile_X0Y1_FrameData[19] Tile_X0Y1_FrameStrobe[8] Tile_X0Y1_IHP_BRAM_bot.Inst_IHP_BRAM_bot_ConfigMem.Inst_frame8_bit19.Q
+ VPWR VGND sg13g2_dlhq_1
X_0437_ _0057_ _0055_ _0056_ VPWR VGND sg13g2_nand2_1
X_1486_ Tile_X0Y1_FrameData[29] Tile_X0Y1_FrameStrobe[4] Tile_X0Y1_IHP_BRAM_bot.Inst_IHP_BRAM_bot_ConfigMem.Inst_frame4_bit29.Q
+ VPWR VGND sg13g2_dlhq_1
XFILLER_26_84 VPWR VGND sg13g2_decap_8
XFILLER_26_95 VPWR VGND sg13g2_fill_2
XFILLER_42_83 VPWR VGND sg13g2_fill_1
X_1340_ Tile_X0Y0_FrameData[15] Tile_X0Y1_FrameStrobe[9] Tile_X0Y0_IHP_BRAM_top.Inst_IHP_BRAM_top_ConfigMem.Inst_frame9_bit15.Q
+ VPWR VGND sg13g2_dlhq_1
XFILLER_47_7 VPWR VGND sg13g2_fill_1
X_1271_ Tile_X0Y0_FrameData[20] Tile_X0Y1_FrameStrobe[7] Tile_X0Y0_IHP_BRAM_top.Inst_IHP_BRAM_top_ConfigMem.Inst_frame7_bit20.Q
+ VPWR VGND sg13g2_dlhq_1
Xclkbuf_0_Tile_X0Y1_UserCLK Tile_X0Y1_UserCLK clknet_0_Tile_X0Y1_UserCLK VPWR VGND
+ sg13g2_buf_8
XFILLER_8_191 VPWR VGND sg13g2_fill_1
X_0986_ Tile_X0Y1_IHP_BRAM_bot.Inst_IHP_BRAM_bot_switch_matrix.J_NS4_BEG6 Tile_X0Y1_IHP_BRAM_bot.Inst_IHP_BRAM_bot_switch_matrix.J_NS4_BEG10
+ Tile_X0Y1_IHP_BRAM_bot.Inst_IHP_BRAM_bot_ConfigMem.Inst_frame7_bit2.Q _0331_ VPWR
+ VGND sg13g2_mux2_1
X_1538_ Tile_X0Y1_FrameData[9] Tile_X0Y1_FrameStrobe[5] Tile_X0Y1_IHP_BRAM_bot.Inst_IHP_BRAM_bot_ConfigMem.Inst_frame5_bit9.Q
+ VPWR VGND sg13g2_dlhq_1
X_1469_ Tile_X0Y1_FrameData[14] Tile_X0Y1_FrameStrobe[3] Tile_X0Y1_IHP_BRAM_bot.Inst_IHP_BRAM_bot_ConfigMem.Inst_frame3_bit14.Q
+ VPWR VGND sg13g2_dlhq_1
X_1607_ Tile_X0Y1_FrameData[4] Tile_X0Y1_FrameStrobe[7] Tile_X0Y1_IHP_BRAM_bot.Inst_IHP_BRAM_bot_ConfigMem.Inst_frame7_bit4.Q
+ VPWR VGND sg13g2_dlhq_1
XFILLER_103_45 VPWR VGND sg13g2_fill_2
XFILLER_77_113 VPWR VGND sg13g2_decap_8
XFILLER_33_205 VPWR VGND sg13g2_fill_2
X_0840_ Tile_X0Y1_IHP_BRAM_bot.Inst_IHP_BRAM_bot_ConfigMem.Inst_frame4_bit7.Q A_DOUT_BRAM3
+ Tile_X0Y1_IHP_BRAM_bot.Inst_IHP_BRAM_bot_switch_matrix.J_NS4_BEG4 _0233_ _0107_
+ Tile_X0Y1_IHP_BRAM_bot.Inst_IHP_BRAM_bot_ConfigMem.Inst_frame4_bit6.Q Tile_X0Y1_IHP_BRAM_bot.Inst_IHP_BRAM_bot_switch_matrix.W6BEG11
+ VPWR VGND sg13g2_mux4_1
X_0771_ Tile_X0Y1_IHP_BRAM_bot.Inst_IHP_BRAM_bot_ConfigMem.Inst_frame8_bit8.Q Tile_X0Y1_E1END[2]
+ Tile_X0Y1_E6END[10] Tile_X0Y1_IHP_BRAM_bot.Inst_IHP_BRAM_bot_switch_matrix.J_NS4_BEG14
+ _0093_ Tile_X0Y1_IHP_BRAM_bot.Inst_IHP_BRAM_bot_ConfigMem.Inst_frame8_bit9.Q Tile_X0Y1_IHP_BRAM_bot.Inst_IHP_BRAM_bot_switch_matrix.S1BEG2
+ VPWR VGND sg13g2_mux4_1
XFILLER_110_210 VPWR VGND sg13g2_fill_2
X_1323_ Tile_X0Y0_FrameData[0] Tile_X0Y1_FrameStrobe[8] Tile_X0Y0_IHP_BRAM_top.Inst_IHP_BRAM_top_ConfigMem.Inst_frame8_bit0.Q
+ VPWR VGND sg13g2_dlhq_1
X_1185_ Tile_X0Y0_FrameData[10] Tile_X0Y1_FrameStrobe[4] Tile_X0Y0_IHP_BRAM_top.Inst_IHP_BRAM_top_ConfigMem.Inst_frame4_bit10.Q
+ VPWR VGND sg13g2_dlhq_1
XFILLER_83_138 VPWR VGND sg13g2_decap_8
X_1254_ Tile_X0Y0_FrameData[5] Tile_X0Y1_FrameStrobe[6] Tile_X0Y0_IHP_BRAM_top.Inst_IHP_BRAM_top_ConfigMem.Inst_frame6_bit5.Q
+ VPWR VGND sg13g2_dlhq_1
X_0969_ VPWR _0315_ _0314_ VGND sg13g2_inv_1
Xoutput241 net241 Tile_X0Y1_FrameData_O[1] VPWR VGND sg13g2_buf_1
Xoutput252 net252 Tile_X0Y1_FrameData_O[2] VPWR VGND sg13g2_buf_1
Xoutput230 net230 Tile_X0Y1_FrameData_O[0] VPWR VGND sg13g2_buf_1
XFILLER_74_116 VPWR VGND sg13g2_fill_1
Xoutput263 net263 Tile_X0Y1_S1BEG[1] VPWR VGND sg13g2_buf_1
Xoutput274 net274 Tile_X0Y1_S2BEGb[0] VPWR VGND sg13g2_buf_1
Xoutput285 net285 Tile_X0Y1_S4BEG[12] VPWR VGND sg13g2_buf_1
Xoutput296 net296 Tile_X0Y1_S4BEG[8] VPWR VGND sg13g2_buf_1
XFILLER_3_0 VPWR VGND sg13g2_fill_1
X_1872_ Tile_X0Y0_S4END[9] net289 VPWR VGND sg13g2_buf_1
X_0685_ Tile_X0Y0_IHP_BRAM_top.Inst_IHP_BRAM_top_switch_matrix.J_NS2_BEG3 Tile_X0Y0_IHP_BRAM_top.Inst_IHP_BRAM_top_ConfigMem.Inst_frame8_bit1.Q
+ _0158_ VPWR VGND sg13g2_nor2b_1
X_0754_ Tile_X0Y0_E2END[1] Tile_X0Y0_E2END[2] Tile_X0Y0_IHP_BRAM_top.Inst_IHP_BRAM_top_ConfigMem.Inst_frame1_bit4.Q
+ _0217_ VPWR VGND sg13g2_mux2_1
X_0823_ Tile_X0Y1_IHP_BRAM_bot.Inst_IHP_BRAM_bot_ConfigMem.Inst_frame1_bit12.Q Tile_X0Y1_N1END[2]
+ Tile_X0Y1_N4END[2] _0089_ Tile_X0Y0_S4END[6] Tile_X0Y1_IHP_BRAM_bot.Inst_IHP_BRAM_bot_ConfigMem.Inst_frame1_bit13.Q
+ _0231_ VPWR VGND sg13g2_mux4_1
X_1306_ Tile_X0Y0_FrameData[17] Tile_X0Y1_FrameStrobe[8] Tile_X0Y0_IHP_BRAM_top.Inst_IHP_BRAM_top_ConfigMem.Inst_frame8_bit17.Q
+ VPWR VGND sg13g2_dlhq_1
XFILLER_36_0 VPWR VGND sg13g2_fill_1
X_1168_ Tile_X0Y0_FrameData[27] Tile_X0Y1_FrameStrobe[4] Tile_X0Y0_IHP_BRAM_top.Inst_IHP_BRAM_top_ConfigMem.Inst_frame4_bit27.Q
+ VPWR VGND sg13g2_dlhq_1
X_1237_ Tile_X0Y0_FrameData[22] Tile_X0Y1_FrameStrobe[6] Tile_X0Y0_IHP_BRAM_top.Inst_IHP_BRAM_top_ConfigMem.Inst_frame6_bit22.Q
+ VPWR VGND sg13g2_dlhq_1
X_1099_ Tile_X0Y0_FrameData[0] Tile_X0Y1_FrameStrobe[1] Tile_X0Y0_IHP_BRAM_top.Inst_IHP_BRAM_top_ConfigMem.Inst_frame1_bit0.Q
+ VPWR VGND sg13g2_dlhq_1
XFILLER_100_57 VPWR VGND sg13g2_fill_2
X_0470_ _0082_ VPWR _0085_ VGND Tile_X0Y1_IHP_BRAM_bot.Inst_IHP_BRAM_bot_ConfigMem.Inst_frame0_bit27.Q
+ _0084_ sg13g2_o21ai_1
XFILLER_38_105 VPWR VGND sg13g2_decap_4
X_1022_ VGND VPWR _0360_ _0364_ net46 _0356_ sg13g2_a21oi_1
X_1924_ Tile_X0Y1_IHP_BRAM_bot.Inst_IHP_BRAM_bot_switch_matrix.WW4BEG5 net341 VPWR
+ VGND sg13g2_buf_1
X_1855_ Tile_X0Y1_IHP_BRAM_bot.Inst_IHP_BRAM_bot_switch_matrix.S2BEG0 net266 VPWR
+ VGND sg13g2_buf_1
X_0668_ Tile_X0Y0_IHP_BRAM_top.Inst_IHP_BRAM_top_switch_matrix.J_NS4_BEG5 Tile_X0Y0_IHP_BRAM_top.Inst_IHP_BRAM_top_switch_matrix.J_NS4_BEG9
+ Tile_X0Y0_IHP_BRAM_top.Inst_IHP_BRAM_top_ConfigMem.Inst_frame9_bit27.Q _0143_ VPWR
+ VGND sg13g2_mux2_1
X_0737_ VGND VPWR _0201_ _0200_ Tile_X0Y0_IHP_BRAM_top.Inst_IHP_BRAM_top_ConfigMem.Inst_frame2_bit31.Q
+ sg13g2_or2_1
X_1786_ Tile_X0Y0_IHP_BRAM_top.Inst_IHP_BRAM_top_switch_matrix.W2BEGb3 net197 VPWR
+ VGND sg13g2_buf_1
X_0806_ Tile_X0Y1_IHP_BRAM_bot.Inst_IHP_BRAM_bot_ConfigMem.Inst_frame6_bit24.Q A_DOUT_BRAM4
+ B_DOUT_BRAM0 Tile_X0Y1_IHP_BRAM_bot.Inst_IHP_BRAM_bot_switch_matrix.J_NS4_BEG11
+ _0104_ Tile_X0Y1_IHP_BRAM_bot.Inst_IHP_BRAM_bot_ConfigMem.Inst_frame6_bit25.Q Tile_X0Y1_IHP_BRAM_bot.Inst_IHP_BRAM_bot_switch_matrix.WW4BEG4
+ VPWR VGND sg13g2_mux4_1
X_0599_ Tile_X0Y0_IHP_BRAM_top.Inst_IHP_BRAM_top_ConfigMem.Inst_frame4_bit10.Q Tile_X0Y0_EE4END[1]
+ Tile_X0Y0_EE4END[9] Tile_X0Y0_E6END[1] Tile_X0Y0_IHP_BRAM_top.Inst_IHP_BRAM_top_switch_matrix.J_NS4_BEG1
+ Tile_X0Y0_IHP_BRAM_top.Inst_IHP_BRAM_top_ConfigMem.Inst_frame4_bit11.Q net43 VPWR
+ VGND sg13g2_mux4_1
X_0522_ Tile_X0Y0_IHP_BRAM_top.Inst_IHP_BRAM_top_ConfigMem.Inst_frame9_bit20.Q Tile_X0Y0_E2MID[1]
+ Tile_X0Y0_E2END[1] Tile_X0Y0_E6END[1] Tile_X0Y0_IHP_BRAM_top.Inst_IHP_BRAM_top_switch_matrix.J_NS2_BEG6
+ Tile_X0Y0_IHP_BRAM_top.Inst_IHP_BRAM_top_ConfigMem.Inst_frame9_bit21.Q Tile_X0Y0_IHP_BRAM_top.Inst_IHP_BRAM_top_switch_matrix.N2BEG6
+ VPWR VGND sg13g2_mux4_1
X_1571_ Tile_X0Y1_FrameData[8] Tile_X0Y1_FrameStrobe[6] Tile_X0Y1_IHP_BRAM_bot.Inst_IHP_BRAM_bot_ConfigMem.Inst_frame6_bit8.Q
+ VPWR VGND sg13g2_dlhq_1
X_1640_ Tile_X0Y1_FrameData[3] Tile_X0Y1_FrameStrobe[8] Tile_X0Y1_IHP_BRAM_bot.Inst_IHP_BRAM_bot_ConfigMem.Inst_frame8_bit3.Q
+ VPWR VGND sg13g2_dlhq_1
XANTENNA_4 VPWR VGND Tile_X0Y0_S2MID[1] sg13g2_antennanp
X_0384_ VPWR _0007_ Tile_X0Y0_E6END[1] VGND sg13g2_inv_1
X_0453_ _0004_ VPWR _0069_ VGND Tile_X0Y1_IHP_BRAM_bot.Inst_IHP_BRAM_bot_ConfigMem.Inst_frame3_bit24.Q
+ Tile_X0Y1_E2END[3] sg13g2_o21ai_1
XFILLER_19_160 VPWR VGND sg13g2_fill_2
X_1005_ _0348_ Tile_X0Y1_E2END[1] _0037_ VPWR VGND sg13g2_nand2_1
X_1838_ Tile_X0Y1_FrameData[19] net240 VPWR VGND sg13g2_buf_1
X_1907_ Tile_X0Y1_IHP_BRAM_bot.Inst_IHP_BRAM_bot_switch_matrix.W6BEG0 net318 VPWR
+ VGND sg13g2_buf_1
X_1769_ Tile_X0Y0_IHP_BRAM_top.Inst_IHP_BRAM_top_switch_matrix.N4BEG3 net171 VPWR
+ VGND sg13g2_buf_1
XFILLER_111_190 VPWR VGND sg13g2_fill_1
XFILLER_82_48 VPWR VGND sg13g2_fill_1
XFILLER_40_188 VPWR VGND sg13g2_fill_2
XFILLER_103_0 VPWR VGND sg13g2_fill_2
Xoutput41 net41 A_DIN_BRAM7 VPWR VGND sg13g2_buf_1
Xoutput6 net6 A_ADDR_BRAM5 VPWR VGND sg13g2_buf_1
Xoutput30 net30 A_DIN_BRAM10 VPWR VGND sg13g2_buf_1
Xoutput52 net52 B_ADDR_BRAM5 VPWR VGND sg13g2_buf_1
XFILLER_31_30 VPWR VGND sg13g2_decap_4
Xoutput96 net96 Tile_X0Y0_FrameData_O[12] VPWR VGND sg13g2_buf_1
Xoutput74 net74 B_DIN_BRAM0 VPWR VGND sg13g2_buf_1
Xoutput85 net85 B_DIN_BRAM5 VPWR VGND sg13g2_buf_1
Xoutput63 net63 B_BM_BRAM14 VPWR VGND sg13g2_buf_1
XFILLER_16_163 VPWR VGND sg13g2_fill_2
XFILLER_100_116 VPWR VGND sg13g2_decap_8
XFILLER_98_177 VPWR VGND sg13g2_fill_1
X_0505_ Tile_X0Y0_IHP_BRAM_top.Inst_IHP_BRAM_top_ConfigMem.Inst_frame0_bit13.Q Tile_X0Y0_IHP_BRAM_top.Inst_IHP_BRAM_top_switch_matrix.N2BEGb2
+ Tile_X0Y0_S2MID[2] Tile_X0Y1_N2MID[2] Tile_X0Y0_S2END[2] Tile_X0Y0_IHP_BRAM_top.Inst_IHP_BRAM_top_ConfigMem.Inst_frame0_bit12.Q
+ Tile_X0Y0_IHP_BRAM_top.Inst_IHP_BRAM_top_switch_matrix.J_NS2_BEG2 VPWR VGND sg13g2_mux4_1
X_0436_ Tile_X0Y0_IHP_BRAM_top.Inst_IHP_BRAM_top_ConfigMem.Inst_frame1_bit2.Q VPWR
+ _0056_ VGND Tile_X0Y0_IHP_BRAM_top.Inst_IHP_BRAM_top_ConfigMem.Inst_frame1_bit1.Q
+ Tile_X0Y0_S2END[3] sg13g2_o21ai_1
X_1554_ Tile_X0Y1_FrameData[25] Tile_X0Y1_FrameStrobe[6] Tile_X0Y1_IHP_BRAM_bot.Inst_IHP_BRAM_bot_ConfigMem.Inst_frame6_bit25.Q
+ VPWR VGND sg13g2_dlhq_1
X_1623_ Tile_X0Y1_FrameData[20] Tile_X0Y1_FrameStrobe[8] Tile_X0Y1_IHP_BRAM_bot.Inst_IHP_BRAM_bot_ConfigMem.Inst_frame8_bit20.Q
+ VPWR VGND sg13g2_dlhq_1
X_1485_ Tile_X0Y1_FrameData[30] Tile_X0Y1_FrameStrobe[4] Tile_X0Y1_IHP_BRAM_bot.Inst_IHP_BRAM_bot_ConfigMem.Inst_frame4_bit30.Q
+ VPWR VGND sg13g2_dlhq_1
.ends
