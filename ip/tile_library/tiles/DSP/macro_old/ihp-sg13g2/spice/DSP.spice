* NGSPICE file created from DSP.ext - technology: ihp-sg13g2

* Black-box entry subcircuit for sg13g2_o21ai_1 abstract view
.subckt sg13g2_o21ai_1 B1 VDD Y VSS A1 A2
.ends

* Black-box entry subcircuit for sg13g2_a21oi_1 abstract view
.subckt sg13g2_a21oi_1 VSS VDD A1 A2 Y B1
.ends

* Black-box entry subcircuit for sg13g2_xnor2_1 abstract view
.subckt sg13g2_xnor2_1 Y A B VDD VSS
.ends

* Black-box entry subcircuit for sg13g2_dlhq_1 abstract view
.subckt sg13g2_dlhq_1 D GATE Q VDD VSS
.ends

* Black-box entry subcircuit for sg13g2_dfrbpq_1 abstract view
.subckt sg13g2_dfrbpq_1 RESET_B VSS VDD D Q CLK
.ends

* Black-box entry subcircuit for sg13g2_or2_1 abstract view
.subckt sg13g2_or2_1 VSS VDD X B A
.ends

* Black-box entry subcircuit for sg13g2_fill_1 abstract view
.subckt sg13g2_fill_1 VDD VSS
.ends

* Black-box entry subcircuit for sg13g2_nor2_1 abstract view
.subckt sg13g2_nor2_1 A B Y VDD VSS
.ends

* Black-box entry subcircuit for sg13g2_nand2_1 abstract view
.subckt sg13g2_nand2_1 Y A B VDD VSS
.ends

* Black-box entry subcircuit for sg13g2_buf_1 abstract view
.subckt sg13g2_buf_1 A X VDD VSS
.ends

* Black-box entry subcircuit for sg13g2_mux4_1 abstract view
.subckt sg13g2_mux4_1 S0 A0 A1 A2 A3 S1 X VDD VSS
.ends

* Black-box entry subcircuit for sg13g2_nand2b_1 abstract view
.subckt sg13g2_nand2b_1 Y B A_N VDD VSS
.ends

* Black-box entry subcircuit for sg13g2_inv_1 abstract view
.subckt sg13g2_inv_1 VDD Y A VSS
.ends

* Black-box entry subcircuit for sg13g2_fill_2 abstract view
.subckt sg13g2_fill_2 VDD VSS
.ends

* Black-box entry subcircuit for sg13g2_decap_4 abstract view
.subckt sg13g2_decap_4 VDD VSS
.ends

* Black-box entry subcircuit for sg13g2_buf_8 abstract view
.subckt sg13g2_buf_8 A X VDD VSS
.ends

* Black-box entry subcircuit for sg13g2_decap_8 abstract view
.subckt sg13g2_decap_8 VDD VSS
.ends

* Black-box entry subcircuit for sg13g2_mux2_1 abstract view
.subckt sg13g2_mux2_1 A0 A1 S X VDD VSS
.ends

* Black-box entry subcircuit for sg13g2_nor2b_1 abstract view
.subckt sg13g2_nor2b_1 A B_N Y VDD VSS
.ends

* Black-box entry subcircuit for sg13g2_antennanp abstract view
.subckt sg13g2_antennanp VDD VSS A
.ends

* Black-box entry subcircuit for sg13g2_tiehi abstract view
.subckt sg13g2_tiehi VDD VSS L_HI
.ends

* Black-box entry subcircuit for sg13g2_a22oi_1 abstract view
.subckt sg13g2_a22oi_1 Y B1 B2 A2 A1 VDD VSS
.ends

* Black-box entry subcircuit for sg13g2_xor2_1 abstract view
.subckt sg13g2_xor2_1 B A X VDD VSS
.ends

* Black-box entry subcircuit for sg13g2_and2_1 abstract view
.subckt sg13g2_and2_1 A B X VDD VSS
.ends

* Black-box entry subcircuit for sg13g2_a221oi_1 abstract view
.subckt sg13g2_a221oi_1 VDD VSS B2 C1 B1 A1 Y A2
.ends

* Black-box entry subcircuit for sg13g2_nand3b_1 abstract view
.subckt sg13g2_nand3b_1 B C Y VDD VSS A_N
.ends

* Black-box entry subcircuit for sg13g2_nand3_1 abstract view
.subckt sg13g2_nand3_1 B C A Y VDD VSS
.ends

* Black-box entry subcircuit for sg13g2_a21o_1 abstract view
.subckt sg13g2_a21o_1 A2 A1 B1 X VDD VSS
.ends

* Black-box entry subcircuit for sg13g2_or3_1 abstract view
.subckt sg13g2_or3_1 A B C X VDD VSS
.ends

* Black-box entry subcircuit for sg13g2_and3_1 abstract view
.subckt sg13g2_and3_1 X A B C VDD VSS
.ends

* Black-box entry subcircuit for sg13g2_nor3_1 abstract view
.subckt sg13g2_nor3_1 A B C Y VDD VSS
.ends

* Black-box entry subcircuit for sg13g2_nand4_1 abstract view
.subckt sg13g2_nand4_1 B C A Y VDD VSS D
.ends

* Black-box entry subcircuit for sg13g2_or4_1 abstract view
.subckt sg13g2_or4_1 A B C D X VDD VSS
.ends

.subckt DSP Tile_X0Y0_E1BEG[0] Tile_X0Y0_E1BEG[1] Tile_X0Y0_E1BEG[2] Tile_X0Y0_E1BEG[3]
+ Tile_X0Y0_E1END[0] Tile_X0Y0_E1END[1] Tile_X0Y0_E1END[2] Tile_X0Y0_E1END[3] Tile_X0Y0_E2BEG[0]
+ Tile_X0Y0_E2BEG[1] Tile_X0Y0_E2BEG[2] Tile_X0Y0_E2BEG[3] Tile_X0Y0_E2BEG[4] Tile_X0Y0_E2BEG[5]
+ Tile_X0Y0_E2BEG[6] Tile_X0Y0_E2BEG[7] Tile_X0Y0_E2BEGb[0] Tile_X0Y0_E2BEGb[1] Tile_X0Y0_E2BEGb[2]
+ Tile_X0Y0_E2BEGb[3] Tile_X0Y0_E2BEGb[4] Tile_X0Y0_E2BEGb[5] Tile_X0Y0_E2BEGb[6]
+ Tile_X0Y0_E2BEGb[7] Tile_X0Y0_E2END[0] Tile_X0Y0_E2END[1] Tile_X0Y0_E2END[2] Tile_X0Y0_E2END[3]
+ Tile_X0Y0_E2END[4] Tile_X0Y0_E2END[5] Tile_X0Y0_E2END[6] Tile_X0Y0_E2END[7] Tile_X0Y0_E2MID[0]
+ Tile_X0Y0_E2MID[1] Tile_X0Y0_E2MID[2] Tile_X0Y0_E2MID[3] Tile_X0Y0_E2MID[4] Tile_X0Y0_E2MID[5]
+ Tile_X0Y0_E2MID[6] Tile_X0Y0_E2MID[7] Tile_X0Y0_E6BEG[0] Tile_X0Y0_E6BEG[10] Tile_X0Y0_E6BEG[11]
+ Tile_X0Y0_E6BEG[1] Tile_X0Y0_E6BEG[2] Tile_X0Y0_E6BEG[3] Tile_X0Y0_E6BEG[4] Tile_X0Y0_E6BEG[5]
+ Tile_X0Y0_E6BEG[6] Tile_X0Y0_E6BEG[7] Tile_X0Y0_E6BEG[8] Tile_X0Y0_E6BEG[9] Tile_X0Y0_E6END[0]
+ Tile_X0Y0_E6END[10] Tile_X0Y0_E6END[11] Tile_X0Y0_E6END[1] Tile_X0Y0_E6END[2] Tile_X0Y0_E6END[3]
+ Tile_X0Y0_E6END[4] Tile_X0Y0_E6END[5] Tile_X0Y0_E6END[6] Tile_X0Y0_E6END[7] Tile_X0Y0_E6END[8]
+ Tile_X0Y0_E6END[9] Tile_X0Y0_EE4BEG[0] Tile_X0Y0_EE4BEG[10] Tile_X0Y0_EE4BEG[11]
+ Tile_X0Y0_EE4BEG[12] Tile_X0Y0_EE4BEG[13] Tile_X0Y0_EE4BEG[14] Tile_X0Y0_EE4BEG[15]
+ Tile_X0Y0_EE4BEG[1] Tile_X0Y0_EE4BEG[2] Tile_X0Y0_EE4BEG[3] Tile_X0Y0_EE4BEG[4]
+ Tile_X0Y0_EE4BEG[5] Tile_X0Y0_EE4BEG[6] Tile_X0Y0_EE4BEG[7] Tile_X0Y0_EE4BEG[8]
+ Tile_X0Y0_EE4BEG[9] Tile_X0Y0_EE4END[0] Tile_X0Y0_EE4END[10] Tile_X0Y0_EE4END[11]
+ Tile_X0Y0_EE4END[12] Tile_X0Y0_EE4END[13] Tile_X0Y0_EE4END[14] Tile_X0Y0_EE4END[15]
+ Tile_X0Y0_EE4END[1] Tile_X0Y0_EE4END[2] Tile_X0Y0_EE4END[3] Tile_X0Y0_EE4END[4]
+ Tile_X0Y0_EE4END[5] Tile_X0Y0_EE4END[6] Tile_X0Y0_EE4END[7] Tile_X0Y0_EE4END[8]
+ Tile_X0Y0_EE4END[9] Tile_X0Y0_FrameData[0] Tile_X0Y0_FrameData[10] Tile_X0Y0_FrameData[11]
+ Tile_X0Y0_FrameData[12] Tile_X0Y0_FrameData[13] Tile_X0Y0_FrameData[14] Tile_X0Y0_FrameData[15]
+ Tile_X0Y0_FrameData[16] Tile_X0Y0_FrameData[17] Tile_X0Y0_FrameData[18] Tile_X0Y0_FrameData[19]
+ Tile_X0Y0_FrameData[1] Tile_X0Y0_FrameData[20] Tile_X0Y0_FrameData[21] Tile_X0Y0_FrameData[22]
+ Tile_X0Y0_FrameData[23] Tile_X0Y0_FrameData[24] Tile_X0Y0_FrameData[25] Tile_X0Y0_FrameData[26]
+ Tile_X0Y0_FrameData[27] Tile_X0Y0_FrameData[28] Tile_X0Y0_FrameData[29] Tile_X0Y0_FrameData[2]
+ Tile_X0Y0_FrameData[30] Tile_X0Y0_FrameData[31] Tile_X0Y0_FrameData[3] Tile_X0Y0_FrameData[4]
+ Tile_X0Y0_FrameData[5] Tile_X0Y0_FrameData[6] Tile_X0Y0_FrameData[7] Tile_X0Y0_FrameData[8]
+ Tile_X0Y0_FrameData[9] Tile_X0Y0_FrameData_O[0] Tile_X0Y0_FrameData_O[10] Tile_X0Y0_FrameData_O[11]
+ Tile_X0Y0_FrameData_O[12] Tile_X0Y0_FrameData_O[13] Tile_X0Y0_FrameData_O[14] Tile_X0Y0_FrameData_O[15]
+ Tile_X0Y0_FrameData_O[16] Tile_X0Y0_FrameData_O[17] Tile_X0Y0_FrameData_O[18] Tile_X0Y0_FrameData_O[19]
+ Tile_X0Y0_FrameData_O[1] Tile_X0Y0_FrameData_O[20] Tile_X0Y0_FrameData_O[21] Tile_X0Y0_FrameData_O[22]
+ Tile_X0Y0_FrameData_O[23] Tile_X0Y0_FrameData_O[24] Tile_X0Y0_FrameData_O[25] Tile_X0Y0_FrameData_O[26]
+ Tile_X0Y0_FrameData_O[27] Tile_X0Y0_FrameData_O[28] Tile_X0Y0_FrameData_O[29] Tile_X0Y0_FrameData_O[2]
+ Tile_X0Y0_FrameData_O[30] Tile_X0Y0_FrameData_O[31] Tile_X0Y0_FrameData_O[3] Tile_X0Y0_FrameData_O[4]
+ Tile_X0Y0_FrameData_O[5] Tile_X0Y0_FrameData_O[6] Tile_X0Y0_FrameData_O[7] Tile_X0Y0_FrameData_O[8]
+ Tile_X0Y0_FrameData_O[9] Tile_X0Y0_FrameStrobe_O[0] Tile_X0Y0_FrameStrobe_O[10]
+ Tile_X0Y0_FrameStrobe_O[11] Tile_X0Y0_FrameStrobe_O[12] Tile_X0Y0_FrameStrobe_O[13]
+ Tile_X0Y0_FrameStrobe_O[14] Tile_X0Y0_FrameStrobe_O[15] Tile_X0Y0_FrameStrobe_O[16]
+ Tile_X0Y0_FrameStrobe_O[17] Tile_X0Y0_FrameStrobe_O[18] Tile_X0Y0_FrameStrobe_O[19]
+ Tile_X0Y0_FrameStrobe_O[1] Tile_X0Y0_FrameStrobe_O[2] Tile_X0Y0_FrameStrobe_O[3]
+ Tile_X0Y0_FrameStrobe_O[4] Tile_X0Y0_FrameStrobe_O[5] Tile_X0Y0_FrameStrobe_O[6]
+ Tile_X0Y0_FrameStrobe_O[7] Tile_X0Y0_FrameStrobe_O[8] Tile_X0Y0_FrameStrobe_O[9]
+ Tile_X0Y0_N1BEG[0] Tile_X0Y0_N1BEG[1] Tile_X0Y0_N1BEG[2] Tile_X0Y0_N1BEG[3] Tile_X0Y0_N2BEG[0]
+ Tile_X0Y0_N2BEG[1] Tile_X0Y0_N2BEG[2] Tile_X0Y0_N2BEG[3] Tile_X0Y0_N2BEG[4] Tile_X0Y0_N2BEG[5]
+ Tile_X0Y0_N2BEG[6] Tile_X0Y0_N2BEG[7] Tile_X0Y0_N2BEGb[0] Tile_X0Y0_N2BEGb[1] Tile_X0Y0_N2BEGb[2]
+ Tile_X0Y0_N2BEGb[3] Tile_X0Y0_N2BEGb[4] Tile_X0Y0_N2BEGb[5] Tile_X0Y0_N2BEGb[6]
+ Tile_X0Y0_N2BEGb[7] Tile_X0Y0_N4BEG[0] Tile_X0Y0_N4BEG[10] Tile_X0Y0_N4BEG[11] Tile_X0Y0_N4BEG[12]
+ Tile_X0Y0_N4BEG[13] Tile_X0Y0_N4BEG[14] Tile_X0Y0_N4BEG[15] Tile_X0Y0_N4BEG[1] Tile_X0Y0_N4BEG[2]
+ Tile_X0Y0_N4BEG[3] Tile_X0Y0_N4BEG[4] Tile_X0Y0_N4BEG[5] Tile_X0Y0_N4BEG[6] Tile_X0Y0_N4BEG[7]
+ Tile_X0Y0_N4BEG[8] Tile_X0Y0_N4BEG[9] Tile_X0Y0_NN4BEG[0] Tile_X0Y0_NN4BEG[10] Tile_X0Y0_NN4BEG[11]
+ Tile_X0Y0_NN4BEG[12] Tile_X0Y0_NN4BEG[13] Tile_X0Y0_NN4BEG[14] Tile_X0Y0_NN4BEG[15]
+ Tile_X0Y0_NN4BEG[1] Tile_X0Y0_NN4BEG[2] Tile_X0Y0_NN4BEG[3] Tile_X0Y0_NN4BEG[4]
+ Tile_X0Y0_NN4BEG[5] Tile_X0Y0_NN4BEG[6] Tile_X0Y0_NN4BEG[7] Tile_X0Y0_NN4BEG[8]
+ Tile_X0Y0_NN4BEG[9] Tile_X0Y0_S1END[0] Tile_X0Y0_S1END[1] Tile_X0Y0_S1END[2] Tile_X0Y0_S1END[3]
+ Tile_X0Y0_S2END[0] Tile_X0Y0_S2END[1] Tile_X0Y0_S2END[2] Tile_X0Y0_S2END[3] Tile_X0Y0_S2END[4]
+ Tile_X0Y0_S2END[5] Tile_X0Y0_S2END[6] Tile_X0Y0_S2END[7] Tile_X0Y0_S2MID[0] Tile_X0Y0_S2MID[1]
+ Tile_X0Y0_S2MID[2] Tile_X0Y0_S2MID[3] Tile_X0Y0_S2MID[4] Tile_X0Y0_S2MID[5] Tile_X0Y0_S2MID[6]
+ Tile_X0Y0_S2MID[7] Tile_X0Y0_S4END[0] Tile_X0Y0_S4END[10] Tile_X0Y0_S4END[11] Tile_X0Y0_S4END[12]
+ Tile_X0Y0_S4END[13] Tile_X0Y0_S4END[14] Tile_X0Y0_S4END[15] Tile_X0Y0_S4END[1] Tile_X0Y0_S4END[2]
+ Tile_X0Y0_S4END[3] Tile_X0Y0_S4END[4] Tile_X0Y0_S4END[5] Tile_X0Y0_S4END[6] Tile_X0Y0_S4END[7]
+ Tile_X0Y0_S4END[8] Tile_X0Y0_S4END[9] Tile_X0Y0_SS4END[0] Tile_X0Y0_SS4END[10] Tile_X0Y0_SS4END[11]
+ Tile_X0Y0_SS4END[12] Tile_X0Y0_SS4END[13] Tile_X0Y0_SS4END[14] Tile_X0Y0_SS4END[15]
+ Tile_X0Y0_SS4END[1] Tile_X0Y0_SS4END[2] Tile_X0Y0_SS4END[3] Tile_X0Y0_SS4END[4]
+ Tile_X0Y0_SS4END[5] Tile_X0Y0_SS4END[6] Tile_X0Y0_SS4END[7] Tile_X0Y0_SS4END[8]
+ Tile_X0Y0_SS4END[9] Tile_X0Y0_UserCLKo Tile_X0Y0_W1BEG[0] Tile_X0Y0_W1BEG[1] Tile_X0Y0_W1BEG[2]
+ Tile_X0Y0_W1BEG[3] Tile_X0Y0_W1END[0] Tile_X0Y0_W1END[1] Tile_X0Y0_W1END[2] Tile_X0Y0_W1END[3]
+ Tile_X0Y0_W2BEG[0] Tile_X0Y0_W2BEG[1] Tile_X0Y0_W2BEG[2] Tile_X0Y0_W2BEG[3] Tile_X0Y0_W2BEG[4]
+ Tile_X0Y0_W2BEG[5] Tile_X0Y0_W2BEG[6] Tile_X0Y0_W2BEG[7] Tile_X0Y0_W2BEGb[0] Tile_X0Y0_W2BEGb[1]
+ Tile_X0Y0_W2BEGb[2] Tile_X0Y0_W2BEGb[3] Tile_X0Y0_W2BEGb[4] Tile_X0Y0_W2BEGb[5]
+ Tile_X0Y0_W2BEGb[6] Tile_X0Y0_W2BEGb[7] Tile_X0Y0_W2END[0] Tile_X0Y0_W2END[1] Tile_X0Y0_W2END[2]
+ Tile_X0Y0_W2END[3] Tile_X0Y0_W2END[4] Tile_X0Y0_W2END[5] Tile_X0Y0_W2END[6] Tile_X0Y0_W2END[7]
+ Tile_X0Y0_W2MID[0] Tile_X0Y0_W2MID[1] Tile_X0Y0_W2MID[2] Tile_X0Y0_W2MID[3] Tile_X0Y0_W2MID[4]
+ Tile_X0Y0_W2MID[5] Tile_X0Y0_W2MID[6] Tile_X0Y0_W2MID[7] Tile_X0Y0_W6BEG[0] Tile_X0Y0_W6BEG[10]
+ Tile_X0Y0_W6BEG[11] Tile_X0Y0_W6BEG[1] Tile_X0Y0_W6BEG[2] Tile_X0Y0_W6BEG[3] Tile_X0Y0_W6BEG[4]
+ Tile_X0Y0_W6BEG[5] Tile_X0Y0_W6BEG[6] Tile_X0Y0_W6BEG[7] Tile_X0Y0_W6BEG[8] Tile_X0Y0_W6BEG[9]
+ Tile_X0Y0_W6END[0] Tile_X0Y0_W6END[10] Tile_X0Y0_W6END[11] Tile_X0Y0_W6END[1] Tile_X0Y0_W6END[2]
+ Tile_X0Y0_W6END[3] Tile_X0Y0_W6END[4] Tile_X0Y0_W6END[5] Tile_X0Y0_W6END[6] Tile_X0Y0_W6END[7]
+ Tile_X0Y0_W6END[8] Tile_X0Y0_W6END[9] Tile_X0Y0_WW4BEG[0] Tile_X0Y0_WW4BEG[10] Tile_X0Y0_WW4BEG[11]
+ Tile_X0Y0_WW4BEG[12] Tile_X0Y0_WW4BEG[13] Tile_X0Y0_WW4BEG[14] Tile_X0Y0_WW4BEG[15]
+ Tile_X0Y0_WW4BEG[1] Tile_X0Y0_WW4BEG[2] Tile_X0Y0_WW4BEG[3] Tile_X0Y0_WW4BEG[4]
+ Tile_X0Y0_WW4BEG[5] Tile_X0Y0_WW4BEG[6] Tile_X0Y0_WW4BEG[7] Tile_X0Y0_WW4BEG[8]
+ Tile_X0Y0_WW4BEG[9] Tile_X0Y0_WW4END[0] Tile_X0Y0_WW4END[10] Tile_X0Y0_WW4END[11]
+ Tile_X0Y0_WW4END[12] Tile_X0Y0_WW4END[13] Tile_X0Y0_WW4END[14] Tile_X0Y0_WW4END[15]
+ Tile_X0Y0_WW4END[1] Tile_X0Y0_WW4END[2] Tile_X0Y0_WW4END[3] Tile_X0Y0_WW4END[4]
+ Tile_X0Y0_WW4END[5] Tile_X0Y0_WW4END[6] Tile_X0Y0_WW4END[7] Tile_X0Y0_WW4END[8]
+ Tile_X0Y0_WW4END[9] Tile_X0Y1_E1BEG[0] Tile_X0Y1_E1BEG[1] Tile_X0Y1_E1BEG[2] Tile_X0Y1_E1BEG[3]
+ Tile_X0Y1_E1END[0] Tile_X0Y1_E1END[1] Tile_X0Y1_E1END[2] Tile_X0Y1_E1END[3] Tile_X0Y1_E2BEG[0]
+ Tile_X0Y1_E2BEG[1] Tile_X0Y1_E2BEG[2] Tile_X0Y1_E2BEG[3] Tile_X0Y1_E2BEG[4] Tile_X0Y1_E2BEG[5]
+ Tile_X0Y1_E2BEG[6] Tile_X0Y1_E2BEG[7] Tile_X0Y1_E2BEGb[0] Tile_X0Y1_E2BEGb[1] Tile_X0Y1_E2BEGb[2]
+ Tile_X0Y1_E2BEGb[3] Tile_X0Y1_E2BEGb[4] Tile_X0Y1_E2BEGb[5] Tile_X0Y1_E2BEGb[6]
+ Tile_X0Y1_E2BEGb[7] Tile_X0Y1_E2END[0] Tile_X0Y1_E2END[1] Tile_X0Y1_E2END[2] Tile_X0Y1_E2END[3]
+ Tile_X0Y1_E2END[4] Tile_X0Y1_E2END[5] Tile_X0Y1_E2END[6] Tile_X0Y1_E2END[7] Tile_X0Y1_E2MID[0]
+ Tile_X0Y1_E2MID[1] Tile_X0Y1_E2MID[2] Tile_X0Y1_E2MID[3] Tile_X0Y1_E2MID[4] Tile_X0Y1_E2MID[5]
+ Tile_X0Y1_E2MID[6] Tile_X0Y1_E2MID[7] Tile_X0Y1_E6BEG[0] Tile_X0Y1_E6BEG[10] Tile_X0Y1_E6BEG[11]
+ Tile_X0Y1_E6BEG[1] Tile_X0Y1_E6BEG[2] Tile_X0Y1_E6BEG[3] Tile_X0Y1_E6BEG[4] Tile_X0Y1_E6BEG[5]
+ Tile_X0Y1_E6BEG[6] Tile_X0Y1_E6BEG[7] Tile_X0Y1_E6BEG[8] Tile_X0Y1_E6BEG[9] Tile_X0Y1_E6END[0]
+ Tile_X0Y1_E6END[10] Tile_X0Y1_E6END[11] Tile_X0Y1_E6END[1] Tile_X0Y1_E6END[2] Tile_X0Y1_E6END[3]
+ Tile_X0Y1_E6END[4] Tile_X0Y1_E6END[5] Tile_X0Y1_E6END[6] Tile_X0Y1_E6END[7] Tile_X0Y1_E6END[8]
+ Tile_X0Y1_E6END[9] Tile_X0Y1_EE4BEG[0] Tile_X0Y1_EE4BEG[10] Tile_X0Y1_EE4BEG[11]
+ Tile_X0Y1_EE4BEG[12] Tile_X0Y1_EE4BEG[13] Tile_X0Y1_EE4BEG[14] Tile_X0Y1_EE4BEG[15]
+ Tile_X0Y1_EE4BEG[1] Tile_X0Y1_EE4BEG[2] Tile_X0Y1_EE4BEG[3] Tile_X0Y1_EE4BEG[4]
+ Tile_X0Y1_EE4BEG[5] Tile_X0Y1_EE4BEG[6] Tile_X0Y1_EE4BEG[7] Tile_X0Y1_EE4BEG[8]
+ Tile_X0Y1_EE4BEG[9] Tile_X0Y1_EE4END[0] Tile_X0Y1_EE4END[10] Tile_X0Y1_EE4END[11]
+ Tile_X0Y1_EE4END[12] Tile_X0Y1_EE4END[13] Tile_X0Y1_EE4END[14] Tile_X0Y1_EE4END[15]
+ Tile_X0Y1_EE4END[1] Tile_X0Y1_EE4END[2] Tile_X0Y1_EE4END[3] Tile_X0Y1_EE4END[4]
+ Tile_X0Y1_EE4END[5] Tile_X0Y1_EE4END[6] Tile_X0Y1_EE4END[7] Tile_X0Y1_EE4END[8]
+ Tile_X0Y1_EE4END[9] Tile_X0Y1_FrameData[0] Tile_X0Y1_FrameData[10] Tile_X0Y1_FrameData[11]
+ Tile_X0Y1_FrameData[12] Tile_X0Y1_FrameData[13] Tile_X0Y1_FrameData[14] Tile_X0Y1_FrameData[15]
+ Tile_X0Y1_FrameData[16] Tile_X0Y1_FrameData[17] Tile_X0Y1_FrameData[18] Tile_X0Y1_FrameData[19]
+ Tile_X0Y1_FrameData[1] Tile_X0Y1_FrameData[20] Tile_X0Y1_FrameData[21] Tile_X0Y1_FrameData[22]
+ Tile_X0Y1_FrameData[23] Tile_X0Y1_FrameData[24] Tile_X0Y1_FrameData[25] Tile_X0Y1_FrameData[26]
+ Tile_X0Y1_FrameData[27] Tile_X0Y1_FrameData[28] Tile_X0Y1_FrameData[29] Tile_X0Y1_FrameData[2]
+ Tile_X0Y1_FrameData[30] Tile_X0Y1_FrameData[31] Tile_X0Y1_FrameData[3] Tile_X0Y1_FrameData[4]
+ Tile_X0Y1_FrameData[5] Tile_X0Y1_FrameData[6] Tile_X0Y1_FrameData[7] Tile_X0Y1_FrameData[8]
+ Tile_X0Y1_FrameData[9] Tile_X0Y1_FrameData_O[0] Tile_X0Y1_FrameData_O[10] Tile_X0Y1_FrameData_O[11]
+ Tile_X0Y1_FrameData_O[12] Tile_X0Y1_FrameData_O[13] Tile_X0Y1_FrameData_O[14] Tile_X0Y1_FrameData_O[15]
+ Tile_X0Y1_FrameData_O[16] Tile_X0Y1_FrameData_O[17] Tile_X0Y1_FrameData_O[18] Tile_X0Y1_FrameData_O[19]
+ Tile_X0Y1_FrameData_O[1] Tile_X0Y1_FrameData_O[20] Tile_X0Y1_FrameData_O[21] Tile_X0Y1_FrameData_O[22]
+ Tile_X0Y1_FrameData_O[23] Tile_X0Y1_FrameData_O[24] Tile_X0Y1_FrameData_O[25] Tile_X0Y1_FrameData_O[26]
+ Tile_X0Y1_FrameData_O[27] Tile_X0Y1_FrameData_O[28] Tile_X0Y1_FrameData_O[29] Tile_X0Y1_FrameData_O[2]
+ Tile_X0Y1_FrameData_O[30] Tile_X0Y1_FrameData_O[31] Tile_X0Y1_FrameData_O[3] Tile_X0Y1_FrameData_O[4]
+ Tile_X0Y1_FrameData_O[5] Tile_X0Y1_FrameData_O[6] Tile_X0Y1_FrameData_O[7] Tile_X0Y1_FrameData_O[8]
+ Tile_X0Y1_FrameData_O[9] Tile_X0Y1_FrameStrobe[0] Tile_X0Y1_FrameStrobe[10] Tile_X0Y1_FrameStrobe[11]
+ Tile_X0Y1_FrameStrobe[12] Tile_X0Y1_FrameStrobe[13] Tile_X0Y1_FrameStrobe[14] Tile_X0Y1_FrameStrobe[15]
+ Tile_X0Y1_FrameStrobe[16] Tile_X0Y1_FrameStrobe[17] Tile_X0Y1_FrameStrobe[18] Tile_X0Y1_FrameStrobe[19]
+ Tile_X0Y1_FrameStrobe[1] Tile_X0Y1_FrameStrobe[2] Tile_X0Y1_FrameStrobe[3] Tile_X0Y1_FrameStrobe[4]
+ Tile_X0Y1_FrameStrobe[5] Tile_X0Y1_FrameStrobe[6] Tile_X0Y1_FrameStrobe[7] Tile_X0Y1_FrameStrobe[8]
+ Tile_X0Y1_FrameStrobe[9] Tile_X0Y1_N1END[0] Tile_X0Y1_N1END[1] Tile_X0Y1_N1END[2]
+ Tile_X0Y1_N1END[3] Tile_X0Y1_N2END[0] Tile_X0Y1_N2END[1] Tile_X0Y1_N2END[2] Tile_X0Y1_N2END[3]
+ Tile_X0Y1_N2END[4] Tile_X0Y1_N2END[5] Tile_X0Y1_N2END[6] Tile_X0Y1_N2END[7] Tile_X0Y1_N2MID[0]
+ Tile_X0Y1_N2MID[1] Tile_X0Y1_N2MID[2] Tile_X0Y1_N2MID[3] Tile_X0Y1_N2MID[4] Tile_X0Y1_N2MID[5]
+ Tile_X0Y1_N2MID[6] Tile_X0Y1_N2MID[7] Tile_X0Y1_N4END[0] Tile_X0Y1_N4END[10] Tile_X0Y1_N4END[11]
+ Tile_X0Y1_N4END[12] Tile_X0Y1_N4END[13] Tile_X0Y1_N4END[14] Tile_X0Y1_N4END[15]
+ Tile_X0Y1_N4END[1] Tile_X0Y1_N4END[2] Tile_X0Y1_N4END[3] Tile_X0Y1_N4END[4] Tile_X0Y1_N4END[5]
+ Tile_X0Y1_N4END[6] Tile_X0Y1_N4END[7] Tile_X0Y1_N4END[8] Tile_X0Y1_N4END[9] Tile_X0Y1_NN4END[0]
+ Tile_X0Y1_NN4END[10] Tile_X0Y1_NN4END[11] Tile_X0Y1_NN4END[12] Tile_X0Y1_NN4END[13]
+ Tile_X0Y1_NN4END[14] Tile_X0Y1_NN4END[15] Tile_X0Y1_NN4END[1] Tile_X0Y1_NN4END[2]
+ Tile_X0Y1_NN4END[3] Tile_X0Y1_NN4END[4] Tile_X0Y1_NN4END[5] Tile_X0Y1_NN4END[6]
+ Tile_X0Y1_NN4END[7] Tile_X0Y1_NN4END[8] Tile_X0Y1_NN4END[9] Tile_X0Y1_S1BEG[0] Tile_X0Y1_S1BEG[1]
+ Tile_X0Y1_S1BEG[2] Tile_X0Y1_S1BEG[3] Tile_X0Y1_S2BEG[0] Tile_X0Y1_S2BEG[1] Tile_X0Y1_S2BEG[2]
+ Tile_X0Y1_S2BEG[3] Tile_X0Y1_S2BEG[4] Tile_X0Y1_S2BEG[5] Tile_X0Y1_S2BEG[6] Tile_X0Y1_S2BEG[7]
+ Tile_X0Y1_S2BEGb[0] Tile_X0Y1_S2BEGb[1] Tile_X0Y1_S2BEGb[2] Tile_X0Y1_S2BEGb[3]
+ Tile_X0Y1_S2BEGb[4] Tile_X0Y1_S2BEGb[5] Tile_X0Y1_S2BEGb[6] Tile_X0Y1_S2BEGb[7]
+ Tile_X0Y1_S4BEG[0] Tile_X0Y1_S4BEG[10] Tile_X0Y1_S4BEG[11] Tile_X0Y1_S4BEG[12] Tile_X0Y1_S4BEG[13]
+ Tile_X0Y1_S4BEG[14] Tile_X0Y1_S4BEG[15] Tile_X0Y1_S4BEG[1] Tile_X0Y1_S4BEG[2] Tile_X0Y1_S4BEG[3]
+ Tile_X0Y1_S4BEG[4] Tile_X0Y1_S4BEG[5] Tile_X0Y1_S4BEG[6] Tile_X0Y1_S4BEG[7] Tile_X0Y1_S4BEG[8]
+ Tile_X0Y1_S4BEG[9] Tile_X0Y1_SS4BEG[0] Tile_X0Y1_SS4BEG[10] Tile_X0Y1_SS4BEG[11]
+ Tile_X0Y1_SS4BEG[12] Tile_X0Y1_SS4BEG[13] Tile_X0Y1_SS4BEG[14] Tile_X0Y1_SS4BEG[15]
+ Tile_X0Y1_SS4BEG[1] Tile_X0Y1_SS4BEG[2] Tile_X0Y1_SS4BEG[3] Tile_X0Y1_SS4BEG[4]
+ Tile_X0Y1_SS4BEG[5] Tile_X0Y1_SS4BEG[6] Tile_X0Y1_SS4BEG[7] Tile_X0Y1_SS4BEG[8]
+ Tile_X0Y1_SS4BEG[9] Tile_X0Y1_UserCLK Tile_X0Y1_W1BEG[0] Tile_X0Y1_W1BEG[1] Tile_X0Y1_W1BEG[2]
+ Tile_X0Y1_W1BEG[3] Tile_X0Y1_W1END[0] Tile_X0Y1_W1END[1] Tile_X0Y1_W1END[2] Tile_X0Y1_W1END[3]
+ Tile_X0Y1_W2BEG[0] Tile_X0Y1_W2BEG[1] Tile_X0Y1_W2BEG[2] Tile_X0Y1_W2BEG[3] Tile_X0Y1_W2BEG[4]
+ Tile_X0Y1_W2BEG[5] Tile_X0Y1_W2BEG[6] Tile_X0Y1_W2BEG[7] Tile_X0Y1_W2BEGb[0] Tile_X0Y1_W2BEGb[1]
+ Tile_X0Y1_W2BEGb[2] Tile_X0Y1_W2BEGb[3] Tile_X0Y1_W2BEGb[4] Tile_X0Y1_W2BEGb[5]
+ Tile_X0Y1_W2BEGb[6] Tile_X0Y1_W2BEGb[7] Tile_X0Y1_W2END[0] Tile_X0Y1_W2END[1] Tile_X0Y1_W2END[2]
+ Tile_X0Y1_W2END[3] Tile_X0Y1_W2END[4] Tile_X0Y1_W2END[5] Tile_X0Y1_W2END[6] Tile_X0Y1_W2END[7]
+ Tile_X0Y1_W2MID[0] Tile_X0Y1_W2MID[1] Tile_X0Y1_W2MID[2] Tile_X0Y1_W2MID[3] Tile_X0Y1_W2MID[4]
+ Tile_X0Y1_W2MID[5] Tile_X0Y1_W2MID[6] Tile_X0Y1_W2MID[7] Tile_X0Y1_W6BEG[0] Tile_X0Y1_W6BEG[10]
+ Tile_X0Y1_W6BEG[11] Tile_X0Y1_W6BEG[1] Tile_X0Y1_W6BEG[2] Tile_X0Y1_W6BEG[3] Tile_X0Y1_W6BEG[4]
+ Tile_X0Y1_W6BEG[5] Tile_X0Y1_W6BEG[6] Tile_X0Y1_W6BEG[7] Tile_X0Y1_W6BEG[8] Tile_X0Y1_W6BEG[9]
+ Tile_X0Y1_W6END[0] Tile_X0Y1_W6END[10] Tile_X0Y1_W6END[11] Tile_X0Y1_W6END[1] Tile_X0Y1_W6END[2]
+ Tile_X0Y1_W6END[3] Tile_X0Y1_W6END[4] Tile_X0Y1_W6END[5] Tile_X0Y1_W6END[6] Tile_X0Y1_W6END[7]
+ Tile_X0Y1_W6END[8] Tile_X0Y1_W6END[9] Tile_X0Y1_WW4BEG[0] Tile_X0Y1_WW4BEG[10] Tile_X0Y1_WW4BEG[11]
+ Tile_X0Y1_WW4BEG[12] Tile_X0Y1_WW4BEG[13] Tile_X0Y1_WW4BEG[14] Tile_X0Y1_WW4BEG[15]
+ Tile_X0Y1_WW4BEG[1] Tile_X0Y1_WW4BEG[2] Tile_X0Y1_WW4BEG[3] Tile_X0Y1_WW4BEG[4]
+ Tile_X0Y1_WW4BEG[5] Tile_X0Y1_WW4BEG[6] Tile_X0Y1_WW4BEG[7] Tile_X0Y1_WW4BEG[8]
+ Tile_X0Y1_WW4BEG[9] Tile_X0Y1_WW4END[0] Tile_X0Y1_WW4END[10] Tile_X0Y1_WW4END[11]
+ Tile_X0Y1_WW4END[12] Tile_X0Y1_WW4END[13] Tile_X0Y1_WW4END[14] Tile_X0Y1_WW4END[15]
+ Tile_X0Y1_WW4END[1] Tile_X0Y1_WW4END[2] Tile_X0Y1_WW4END[3] Tile_X0Y1_WW4END[4]
+ Tile_X0Y1_WW4END[5] Tile_X0Y1_WW4END[6] Tile_X0Y1_WW4END[7] Tile_X0Y1_WW4END[8]
+ Tile_X0Y1_WW4END[9] VGND VPWR
X_3086_ _1462_ VPWR _1463_ VGND Tile_X0Y0_DSP_top.Inst_DSP_top_ConfigMem.Inst_frame1_bit20.Q
+ Tile_X0Y0_DSP_top.Inst_DSP_top_switch_matrix.bot2top2 sg13g2_o21ai_1
X_3155_ VGND VPWR Tile_X0Y0_DSP_top.Inst_DSP_top_ConfigMem.Inst_frame3_bit21.Q _1527_
+ _1529_ _1528_ sg13g2_a21oi_1
X_3988_ _0122_ VPWR _2277_ VGND Tile_X0Y0_DSP_top.Inst_DSP_top_ConfigMem.Inst_frame10_bit24.Q
+ Tile_X0Y0_DSP_top.Inst_DSP_top_switch_matrix.bot2top8 sg13g2_o21ai_1
X_2939_ _1316_ _1263_ _1264_ VPWR VGND sg13g2_xnor2_1
X_5727_ Tile_X0Y1_FrameData[28] Tile_X0Y1_FrameStrobe[2] Tile_X0Y1_DSP_bot.Inst_DSP_bot_ConfigMem.Inst_frame2_bit28.Q
+ VPWR VGND sg13g2_dlhq_1
X_5589_ Tile_X0Y0_FrameData[24] Tile_X0Y1_FrameStrobe[12] Tile_X0Y0_DSP_top.Inst_DSP_top_ConfigMem.Inst_frame12_bit24.Q
+ VPWR VGND sg13g2_dlhq_1
X_5658_ _2491_ VGND VPWR Tile_X0Y0_DSP_top.Inst_DSP_top_switch_matrix.inst_cus_mux81_buf_top2bot16.X
+ Tile_X0Y1_DSP_bot.Inst_MULADD.C_reg\[18\] clknet_3_7_0_Tile_X0Y1_UserCLK_regs sg13g2_dfrbpq_1
X_4609_ VGND VPWR _0362_ _0361_ Tile_X0Y1_DSP_bot.Inst_DSP_bot_ConfigMem.Inst_frame4_bit21.Q
+ sg13g2_or2_1
XFILLER_13_199 VPWR VGND sg13g2_fill_1
XFILLER_5_354 VPWR VGND sg13g2_fill_1
X_3911_ _2208_ _2210_ Tile_X0Y0_DSP_top.Inst_DSP_top_switch_matrix.NN4BEG1 VPWR VGND
+ sg13g2_nor2_1
X_3842_ VGND VPWR _0036_ Tile_X0Y0_DSP_top.Inst_DSP_top_ConfigMem.Inst_frame1_bit0.Q
+ _2163_ _2162_ sg13g2_a21oi_1
X_4891_ VGND VPWR Tile_X0Y0_DSP_top.Inst_DSP_top_ConfigMem.Inst_frame2_bit14.Q _0631_
+ _0632_ Tile_X0Y0_DSP_top.Inst_DSP_top_ConfigMem.Inst_frame2_bit15.Q sg13g2_a21oi_1
X_4960_ _0697_ Tile_X0Y1_DSP_bot.Inst_DSP_bot_ConfigMem.Inst_frame1_bit16.Q _0128_
+ VPWR VGND sg13g2_nand2_1
X_3773_ VGND VPWR Tile_X0Y1_N2MID[0] Tile_X0Y0_DSP_top.Inst_DSP_top_ConfigMem.Inst_frame4_bit28.Q
+ _2103_ Tile_X0Y0_DSP_top.Inst_DSP_top_ConfigMem.Inst_frame4_bit29.Q sg13g2_a21oi_1
X_5443_ Tile_X0Y0_FrameData[10] Tile_X0Y1_FrameStrobe[7] Tile_X0Y0_DSP_top.Inst_DSP_top_ConfigMem.Inst_frame7_bit10.Q
+ VPWR VGND sg13g2_dlhq_1
X_5374_ Tile_X0Y0_FrameData[15] Tile_X0Y1_FrameStrobe[5] Tile_X0Y0_DSP_top.Inst_DSP_top_ConfigMem.Inst_frame5_bit15.Q
+ VPWR VGND sg13g2_dlhq_1
X_5512_ Tile_X0Y0_FrameData[5] Tile_X0Y1_FrameStrobe[9] Tile_X0Y0_DSP_top.Inst_DSP_top_ConfigMem.Inst_frame9_bit5.Q
+ VPWR VGND sg13g2_dlhq_1
X_2724_ VGND VPWR Tile_X0Y1_DSP_bot.Inst_DSP_bot_ConfigMem.Inst_frame2_bit16.Q _0130_
+ _1108_ _1107_ sg13g2_a21oi_1
X_6492_ Tile_X0Y1_W6END[9] Tile_X0Y1_W6BEG[7] VPWR VGND sg13g2_buf_1
X_2655_ VGND VPWR Tile_X0Y1_DSP_bot.Inst_DSP_bot_ConfigMem.Inst_frame3_bit13.Q _1040_
+ _1043_ _1042_ sg13g2_a21oi_1
X_3207_ Tile_X0Y0_DSP_top.Inst_DSP_top_ConfigMem.Inst_frame7_bit16.Q Tile_X0Y0_DSP_top.Inst_DSP_top_switch_matrix.N2BEGb6
+ Tile_X0Y0_E2MID[6] Tile_X0Y0_W2MID[6] Tile_X0Y0_DSP_top.Inst_DSP_top_switch_matrix.JN2BEG5
+ Tile_X0Y0_DSP_top.Inst_DSP_top_ConfigMem.Inst_frame7_bit17.Q _1578_ VPWR VGND sg13g2_mux4_1
X_2586_ _0975_ Tile_X0Y0_S2MID[3] Tile_X0Y0_DSP_top.Inst_DSP_top_ConfigMem.Inst_frame6_bit2.Q
+ VPWR VGND sg13g2_nand2b_1
X_4256_ Tile_X0Y1_DSP_bot.Inst_DSP_bot_switch_matrix.clr _2130_ _0019_ VPWR VGND sg13g2_nor2_1
XFILLER_47_18 VPWR VGND sg13g2_fill_1
X_4325_ VPWR _0088_ Tile_X0Y1_DSP_bot.Inst_DSP_bot_ConfigMem.Inst_frame7_bit11.Q VGND
+ sg13g2_inv_1
X_4187_ Tile_X0Y1_DSP_bot.Inst_DSP_bot_ConfigMem.Inst_frame9_bit7.Q _2429_ _2430_
+ VPWR VGND sg13g2_nor2_1
X_3138_ Tile_X0Y0_DSP_top.Inst_DSP_top_ConfigMem.Inst_frame8_bit14.Q _1510_ _1511_
+ _1512_ _0668_ Tile_X0Y0_DSP_top.Inst_DSP_top_ConfigMem.Inst_frame8_bit15.Q Tile_X0Y0_DSP_top.Inst_DSP_top_switch_matrix.inst_cus_mux41_buf_top2bot10.X
+ VPWR VGND sg13g2_mux4_1
X_3069_ VGND VPWR _1158_ _1436_ _1446_ _1445_ sg13g2_a21oi_1
XFILLER_88_25 VPWR VGND sg13g2_fill_2
XFILLER_77_103 VPWR VGND sg13g2_fill_1
XFILLER_77_125 VPWR VGND sg13g2_decap_4
Xclkbuf_3_3_0_Tile_X0Y1_UserCLK_regs clknet_0_Tile_X0Y1_UserCLK_regs clknet_3_3_0_Tile_X0Y1_UserCLK_regs
+ VPWR VGND sg13g2_buf_8
XFILLER_110_200 VPWR VGND sg13g2_decap_8
X_5090_ Tile_X0Y0_DSP_top.Inst_DSP_top_ConfigMem.Inst_frame2_bit9.Q _0820_ _0821_
+ VPWR VGND sg13g2_nor2_1
X_4041_ _1510_ _2015_ Tile_X0Y0_DSP_top.Inst_DSP_top_ConfigMem.Inst_frame9_bit22.Q
+ _2323_ VPWR VGND sg13g2_mux2_1
X_4110_ Tile_X0Y1_DSP_bot.Inst_DSP_bot_ConfigMem.Inst_frame12_bit22.Q Tile_X0Y1_N1END[2]
+ Tile_X0Y1_E1END[2] Tile_X0Y1_W1END[2] Tile_X0Y1_DSP_bot.Inst_DSP_bot_switch_matrix.Q2
+ Tile_X0Y1_DSP_bot.Inst_DSP_bot_ConfigMem.Inst_frame12_bit23.Q _2368_ VPWR VGND sg13g2_mux4_1
XFILLER_110_277 VPWR VGND sg13g2_fill_1
X_4943_ _0680_ VPWR _0681_ VGND Tile_X0Y0_DSP_top.Inst_DSP_top_ConfigMem.Inst_frame9_bit30.Q
+ _0679_ sg13g2_o21ai_1
XFILLER_17_280 VPWR VGND sg13g2_fill_2
X_5992_ Tile_X0Y1_FrameData[19] Tile_X0Y1_FrameStrobe[10] Tile_X0Y1_DSP_bot.Inst_DSP_bot_ConfigMem.Inst_frame10_bit19.Q
+ VPWR VGND sg13g2_dlhq_1
X_3825_ VGND VPWR _0041_ _2145_ _2147_ _2146_ sg13g2_a21oi_1
X_3756_ Tile_X0Y0_DSP_top.Inst_DSP_top_ConfigMem.Inst_frame1_bit28.Q Tile_X0Y0_DSP_top.Inst_DSP_top_switch_matrix.bot2top0
+ _2086_ VPWR VGND sg13g2_nor2_1
X_4874_ Tile_X0Y0_DSP_top.Inst_DSP_top_ConfigMem.Inst_frame9_bit30.Q VPWR _0615_ VGND
+ Tile_X0Y0_DSP_top.Inst_DSP_top_ConfigMem.Inst_frame0_bit5.Q _0614_ sg13g2_o21ai_1
X_5357_ Tile_X0Y0_FrameData[0] Tile_X0Y1_FrameStrobe[4] Tile_X0Y0_DSP_top.Inst_DSP_top_ConfigMem.Inst_frame4_bit0.Q
+ VPWR VGND sg13g2_dlhq_1
X_5426_ Tile_X0Y0_FrameData[27] Tile_X0Y1_FrameStrobe[7] Tile_X0Y0_DSP_top.Inst_DSP_top_ConfigMem.Inst_frame7_bit27.Q
+ VPWR VGND sg13g2_dlhq_1
X_3687_ _2022_ _2000_ _2021_ VPWR VGND sg13g2_nand2_1
X_2569_ VGND VPWR Tile_X0Y0_DSP_top.Inst_DSP_top_ConfigMem.Inst_frame7_bit1.Q _0958_
+ _0959_ Tile_X0Y0_DSP_top.Inst_DSP_top_ConfigMem.Inst_frame9_bit26.Q sg13g2_a21oi_1
X_2638_ Tile_X0Y1_DSP_bot.Inst_DSP_bot_ConfigMem.Inst_frame3_bit12.Q Tile_X0Y1_DSP_bot.Inst_DSP_bot_switch_matrix.Q5
+ _1026_ VPWR VGND sg13g2_nor2_1
X_6475_ Tile_X0Y1_DSP_bot.Inst_DSP_bot_switch_matrix.JW2BEG6 Tile_X0Y1_W2BEG[6] VPWR
+ VGND sg13g2_buf_1
X_2707_ VGND VPWR Tile_X0Y1_DSP_bot.Inst_DSP_bot_ConfigMem.Inst_frame2_bit8.Q _0126_
+ _1092_ Tile_X0Y1_DSP_bot.Inst_DSP_bot_ConfigMem.Inst_frame2_bit9.Q sg13g2_a21oi_1
X_4308_ VPWR _0071_ Tile_X0Y0_DSP_top.Inst_DSP_top_ConfigMem.Inst_frame1_bit26.Q VGND
+ sg13g2_inv_1
X_5288_ Tile_X0Y0_FrameData[5] Tile_X0Y1_FrameStrobe[2] Tile_X0Y0_DSP_top.Inst_DSP_top_ConfigMem.Inst_frame2_bit5.Q
+ VPWR VGND sg13g2_dlhq_1
XFILLER_74_27 VPWR VGND sg13g2_fill_1
X_4239_ Tile_X0Y1_DSP_bot.Inst_DSP_bot_switch_matrix.clr _1944_ _0002_ VPWR VGND sg13g2_nor2_1
X_4590_ _0344_ Tile_X0Y0_DSP_top.Inst_DSP_top_ConfigMem.Inst_frame4_bit4.Q Tile_X0Y0_DSP_top.Inst_DSP_top_switch_matrix.bot2top8
+ VPWR VGND sg13g2_nand2_1
XFILLER_9_55 VPWR VGND sg13g2_fill_2
X_3610_ _1954_ Tile_X0Y1_DSP_bot.Inst_MULADD.ACC\[7\] Tile_X0Y1_DSP_bot.Inst_DSP_bot_ConfigMem.Inst_frame12_bit5.Q
+ Tile_X0Y1_DSP_bot.Inst_DSP_bot_switch_matrix.Q7 VPWR VGND sg13g2_mux2_1
X_6191_ Tile_X0Y0_FrameData[11] Tile_X0Y0_FrameData_O[11] VPWR VGND sg13g2_buf_1
X_5211_ Tile_X0Y0_FrameData[18] Tile_X0Y1_FrameStrobe[0] Tile_X0Y0_DSP_top.Inst_DSP_top_ConfigMem.Inst_frame0_bit18.Q
+ VPWR VGND sg13g2_dlhq_1
X_3472_ _1825_ _1828_ _1829_ VPWR VGND sg13g2_nor2_1
X_6260_ Tile_X0Y0_DSP_top.N4BEG_outbuf_8.A Tile_X0Y0_N4BEG[8] VPWR VGND sg13g2_buf_1
X_3541_ _1894_ _1892_ _1893_ VPWR VGND sg13g2_nand2_1
X_4024_ Tile_X0Y0_DSP_top.Inst_DSP_top_ConfigMem.Inst_frame9_bit14.Q VPWR _2309_ VGND
+ Tile_X0Y0_DSP_top.Inst_DSP_top_ConfigMem.Inst_frame9_bit13.Q _2308_ sg13g2_o21ai_1
X_5073_ VGND VPWR Tile_X0Y0_DSP_top.Inst_DSP_top_ConfigMem.Inst_frame0_bit15.Q _0801_
+ _0805_ _0804_ sg13g2_a21oi_1
X_5142_ _0870_ Tile_X0Y1_E2MID[4] Tile_X0Y1_DSP_bot.Inst_DSP_bot_ConfigMem.Inst_frame7_bit4.Q
+ VPWR VGND sg13g2_nand2_1
XFILLER_29_0 VPWR VGND sg13g2_fill_2
X_4926_ Tile_X0Y0_DSP_top.Inst_DSP_top_ConfigMem.Inst_frame3_bit3.Q _0665_ _0666_
+ VPWR VGND sg13g2_nor2_1
XFILLER_64_194 VPWR VGND sg13g2_fill_1
X_5975_ Tile_X0Y1_FrameData[4] Tile_X0Y1_FrameStrobe[9] Tile_X0Y1_DSP_bot.Inst_DSP_bot_ConfigMem.Inst_frame9_bit4.Q
+ VPWR VGND sg13g2_dlhq_1
X_3739_ _2069_ _2000_ _2067_ VPWR VGND sg13g2_xnor2_1
X_3808_ _2134_ Tile_X0Y1_DSP_bot.Inst_DSP_bot_ConfigMem.Inst_frame12_bit5.Q Tile_X0Y1_DSP_bot.Inst_MULADD.ACC\[13\]
+ VPWR VGND sg13g2_nand2_1
X_4857_ Tile_X0Y0_DSP_top.Inst_DSP_top_ConfigMem.Inst_frame0_bit6.Q Tile_X0Y1_N4END[4]
+ _0599_ VPWR VGND sg13g2_nor2b_1
X_4788_ _0532_ Tile_X0Y1_DSP_bot.Inst_DSP_bot_ConfigMem.Inst_frame12_bit1.Q Tile_X0Y1_DSP_bot.Inst_MULADD.B_reg\[4\]
+ VPWR VGND sg13g2_nand2b_1
XFILLER_107_7 VPWR VGND sg13g2_decap_8
XFILLER_69_38 VPWR VGND sg13g2_fill_2
X_5409_ Tile_X0Y0_FrameData[12] Tile_X0Y1_FrameStrobe[6] Tile_X0Y0_DSP_top.Inst_DSP_top_ConfigMem.Inst_frame6_bit12.Q
+ VPWR VGND sg13g2_dlhq_1
X_6389_ Tile_X0Y1_FrameData[8] Tile_X0Y1_FrameData_O[8] VPWR VGND sg13g2_buf_1
X_6458_ Tile_X0Y0_DSP_top.Inst_DSP_top_switch_matrix.SS4BEG1 Tile_X0Y1_SS4BEG[9] VPWR
+ VGND sg13g2_buf_1
XFILLER_85_37 VPWR VGND sg13g2_fill_2
XFILLER_55_161 VPWR VGND sg13g2_fill_2
XFILLER_70_131 VPWR VGND sg13g2_fill_2
XFILLER_109_185 VPWR VGND sg13g2_fill_1
XFILLER_78_253 VPWR VGND sg13g2_fill_2
XFILLER_93_278 VPWR VGND sg13g2_fill_1
X_5760_ Tile_X0Y1_FrameData[27] Tile_X0Y1_FrameStrobe[3] Tile_X0Y1_DSP_bot.Inst_DSP_bot_ConfigMem.Inst_frame3_bit27.Q
+ VPWR VGND sg13g2_dlhq_1
X_2972_ _1347_ _1348_ _1349_ VPWR VGND sg13g2_nor2_1
XFILLER_46_194 VPWR VGND sg13g2_fill_2
XFILLER_46_172 VPWR VGND sg13g2_decap_4
X_4642_ VGND VPWR Tile_X0Y0_DSP_top.Inst_DSP_top_ConfigMem.Inst_frame1_bit16.Q _0132_
+ _0394_ _0393_ sg13g2_a21oi_1
X_4573_ _0327_ VPWR _0328_ VGND Tile_X0Y0_DSP_top.Inst_DSP_top_ConfigMem.Inst_frame3_bit8.Q
+ _0237_ sg13g2_o21ai_1
X_4711_ Tile_X0Y0_DSP_top.Inst_DSP_top_ConfigMem.Inst_frame3_bit13.Q Tile_X0Y0_DSP_top.Inst_DSP_top_switch_matrix.N1END2
+ Tile_X0Y1_N4END[4] Tile_X0Y1_N2MID[4] Tile_X0Y0_E2END[4] Tile_X0Y0_DSP_top.Inst_DSP_top_ConfigMem.Inst_frame3_bit12.Q
+ _0460_ VPWR VGND sg13g2_mux4_1
X_5691_ Tile_X0Y1_FrameData[0] Tile_X0Y1_FrameStrobe[0] Tile_X0Y1_DSP_bot.Inst_DSP_bot_ConfigMem.Inst_frame0_bit0.Q
+ VPWR VGND sg13g2_dlhq_1
X_6243_ Tile_X0Y0_DSP_top.Inst_DSP_top_switch_matrix.JN2BEG7 Tile_X0Y0_N2BEG[7] VPWR
+ VGND sg13g2_buf_1
X_6174_ Tile_X0Y0_EE4END[14] Tile_X0Y0_EE4BEG[10] VPWR VGND sg13g2_buf_1
X_6312_ Tile_X0Y0_W6END[9] Tile_X0Y0_W6BEG[7] VPWR VGND sg13g2_buf_1
X_3386_ _1746_ _1747_ Tile_X0Y1_DSP_bot.Inst_DSP_bot_ConfigMem.Inst_frame2_bit26.Q
+ _1748_ VPWR VGND sg13g2_mux2_1
X_3455_ VGND VPWR Tile_X0Y1_DSP_bot.Inst_DSP_bot_ConfigMem.Inst_frame7_bit24.Q _0445_
+ _1812_ _1811_ sg13g2_a21oi_1
X_3524_ Tile_X0Y1_DSP_bot.Inst_DSP_bot_ConfigMem.Inst_frame8_bit8.Q _1877_ _1878_
+ VPWR VGND sg13g2_nor2b_1
X_5056_ _0789_ Tile_X0Y0_DSP_top.Inst_DSP_top_ConfigMem.Inst_frame1_bit8.Q Tile_X0Y0_DSP_top.Inst_DSP_top_switch_matrix.bot2top6
+ VPWR VGND sg13g2_nand2b_1
X_5125_ _0855_ Tile_X0Y0_DSP_top.Inst_DSP_top_ConfigMem.Inst_frame2_bit16.Q Tile_X0Y0_W1END[3]
+ VPWR VGND sg13g2_nand2b_1
X_4007_ VGND VPWR Tile_X0Y0_DSP_top.Inst_DSP_top_ConfigMem.Inst_frame9_bit10.Q _2292_
+ _2293_ Tile_X0Y0_DSP_top.Inst_DSP_top_ConfigMem.Inst_frame9_bit11.Q sg13g2_a21oi_1
X_4909_ Tile_X0Y0_DSP_top.Inst_DSP_top_ConfigMem.Inst_frame3_bit0.Q Tile_X0Y0_DSP_top.Inst_DSP_top_switch_matrix.bot2top5
+ _0649_ VPWR VGND sg13g2_nor2_1
XFILLER_40_359 VPWR VGND sg13g2_fill_2
XFILLER_37_194 VPWR VGND sg13g2_decap_4
X_5889_ Tile_X0Y1_FrameData[26] Tile_X0Y1_FrameStrobe[7] Tile_X0Y1_DSP_bot.Inst_DSP_bot_ConfigMem.Inst_frame7_bit26.Q
+ VPWR VGND sg13g2_dlhq_1
X_5958_ Tile_X0Y1_FrameData[21] Tile_X0Y1_FrameStrobe[9] Tile_X0Y1_DSP_bot.Inst_DSP_bot_ConfigMem.Inst_frame9_bit21.Q
+ VPWR VGND sg13g2_dlhq_1
XFILLER_75_267 VPWR VGND sg13g2_decap_4
XFILLER_31_359 VPWR VGND sg13g2_fill_2
XFILLER_98_359 VPWR VGND sg13g2_fill_2
XANTENNA_5 VPWR VGND Tile_X0Y0_E2MID[4] sg13g2_antennanp
X_3240_ VGND VPWR _1605_ _1608_ _1609_ _1599_ sg13g2_a21oi_1
XFILLER_3_282 VPWR VGND sg13g2_fill_1
X_3171_ Tile_X0Y0_DSP_top.Inst_DSP_top_ConfigMem.Inst_frame8_bit13.Q VPWR _1544_ VGND
+ Tile_X0Y0_DSP_top.Inst_DSP_top_ConfigMem.Inst_frame0_bit19.Q _1541_ sg13g2_o21ai_1
X_2955_ _1324_ _1331_ _1332_ VPWR VGND sg13g2_nor2_1
XFILLER_34_142 VPWR VGND sg13g2_decap_4
X_5812_ Tile_X0Y1_FrameData[7] Tile_X0Y1_FrameStrobe[4] Tile_X0Y1_DSP_bot.Inst_DSP_bot_ConfigMem.Inst_frame4_bit7.Q
+ VPWR VGND sg13g2_dlhq_1
X_5743_ Tile_X0Y1_FrameData[12] Tile_X0Y1_FrameStrobe[2] Tile_X0Y1_DSP_bot.Inst_DSP_bot_ConfigMem.Inst_frame2_bit12.Q
+ VPWR VGND sg13g2_dlhq_1
XFILLER_89_304 VPWR VGND sg13g2_decap_8
X_2886_ _1264_ _1227_ _1228_ VPWR VGND sg13g2_xnor2_1
X_4556_ _0310_ Tile_X0Y1_DSP_bot.Inst_DSP_bot_ConfigMem.Inst_frame4_bit26.Q _0311_
+ VPWR VGND sg13g2_nor2b_1
X_3507_ _1838_ VPWR _1862_ VGND Tile_X0Y1_DSP_bot.Inst_DSP_bot_ConfigMem.Inst_frame12_bit3.Q
+ _1861_ sg13g2_o21ai_1
X_4625_ _0377_ VPWR _0378_ VGND Tile_X0Y1_W2END[4] Tile_X0Y1_DSP_bot.Inst_DSP_bot_ConfigMem.Inst_frame4_bit12.Q
+ sg13g2_o21ai_1
X_5674_ Tile_X0Y1_FrameData[17] Tile_X0Y1_FrameStrobe[0] Tile_X0Y1_DSP_bot.Inst_DSP_bot_ConfigMem.Inst_frame0_bit17.Q
+ VPWR VGND sg13g2_dlhq_1
X_6226_ Tile_X0Y1_FrameStrobe[14] Tile_X0Y0_FrameStrobe_O[14] VPWR VGND sg13g2_buf_1
XFILLER_106_57 VPWR VGND sg13g2_fill_2
X_6157_ Tile_X0Y0_E6END[7] Tile_X0Y0_E6BEG[5] VPWR VGND sg13g2_buf_1
X_4487_ _0245_ VPWR _0246_ VGND Tile_X0Y0_W1END[1] Tile_X0Y0_DSP_top.Inst_DSP_top_ConfigMem.Inst_frame4_bit16.Q
+ sg13g2_o21ai_1
X_5108_ VGND VPWR Tile_X0Y0_EE4END[1] Tile_X0Y0_DSP_top.Inst_DSP_top_ConfigMem.Inst_frame0_bit12.Q
+ _0838_ Tile_X0Y0_DSP_top.Inst_DSP_top_ConfigMem.Inst_frame0_bit13.Q sg13g2_a21oi_1
X_3438_ _1795_ VPWR _1796_ VGND Tile_X0Y1_DSP_bot.Inst_DSP_bot_ConfigMem.Inst_frame8_bit16.Q
+ _1792_ sg13g2_o21ai_1
X_3369_ VPWR Tile_X0Y1_DSP_bot.Inst_DSP_bot_switch_matrix.JW2BEG6 _1731_ VGND sg13g2_inv_1
X_6088_ VPWR VGND _2486_ sg13g2_tiehi
X_5039_ VGND VPWR Tile_X0Y1_E6END[0] Tile_X0Y1_DSP_bot.Inst_DSP_bot_ConfigMem.Inst_frame1_bit4.Q
+ _0774_ _0773_ sg13g2_a21oi_1
XFILLER_80_281 VPWR VGND sg13g2_fill_1
XFILLER_15_98 VPWR VGND sg13g2_fill_2
XFILLER_56_61 VPWR VGND sg13g2_fill_2
X_5390_ Tile_X0Y0_FrameData[31] Tile_X0Y1_FrameStrobe[6] Tile_X0Y0_DSP_top.Inst_DSP_top_ConfigMem.Inst_frame6_bit31.Q
+ VPWR VGND sg13g2_dlhq_1
X_2671_ _1056_ _1057_ Tile_X0Y1_DSP_bot.Inst_DSP_bot_ConfigMem.Inst_frame3_bit6.Q
+ _1058_ VPWR VGND sg13g2_mux2_1
X_4410_ Tile_X0Y1_DSP_bot.Inst_DSP_bot_ConfigMem.Inst_frame0_bit10.Q Tile_X0Y1_N4END[2]
+ Tile_X0Y1_E2END[2] Tile_X0Y1_W2END[7] Tile_X0Y1_DSP_bot.Inst_DSP_bot_switch_matrix.E2BEG2
+ Tile_X0Y1_DSP_bot.Inst_DSP_bot_ConfigMem.Inst_frame0_bit11.Q _0171_ VPWR VGND sg13g2_mux4_1
X_2740_ Tile_X0Y1_DSP_bot.Inst_DSP_bot_ConfigMem.Inst_frame6_bit12.Q Tile_X0Y1_N2MID[5]
+ Tile_X0Y1_E2MID[5] Tile_X0Y0_DSP_top.Inst_DSP_top_switch_matrix.JS2BEG5 Tile_X0Y1_W2MID[5]
+ Tile_X0Y1_DSP_bot.Inst_DSP_bot_ConfigMem.Inst_frame6_bit13.Q _1123_ VPWR VGND sg13g2_mux4_1
X_4272_ VPWR _0035_ Tile_X0Y0_S2END[3] VGND sg13g2_inv_1
XFILLER_39_201 VPWR VGND sg13g2_decap_4
X_4341_ VPWR _0104_ Tile_X0Y1_DSP_bot.Inst_MULADD.C_reg\[5\] VGND sg13g2_inv_1
X_3223_ _0467_ _0422_ Tile_X0Y1_DSP_bot.Inst_DSP_bot_ConfigMem.Inst_frame3_bit28.Q
+ _1592_ VPWR VGND sg13g2_mux2_1
X_6011_ Tile_X0Y1_FrameData[0] Tile_X0Y1_FrameStrobe[10] Tile_X0Y1_DSP_bot.Inst_DSP_bot_ConfigMem.Inst_frame10_bit0.Q
+ VPWR VGND sg13g2_dlhq_1
X_3085_ _1462_ Tile_X0Y0_DSP_top.Inst_DSP_top_ConfigMem.Inst_frame1_bit20.Q Tile_X0Y0_DSP_top.Inst_DSP_top_switch_matrix.bot2top3
+ VPWR VGND sg13g2_nand2b_1
X_3154_ Tile_X0Y0_DSP_top.Inst_DSP_top_ConfigMem.Inst_frame3_bit22.Q VPWR _1528_ VGND
+ Tile_X0Y0_DSP_top.Inst_DSP_top_ConfigMem.Inst_frame3_bit21.Q _1525_ sg13g2_o21ai_1
XFILLER_39_245 VPWR VGND sg13g2_fill_1
X_3987_ VGND VPWR Tile_X0Y0_DSP_top.Inst_DSP_top_ConfigMem.Inst_frame10_bit25.Q _2275_
+ _2276_ Tile_X0Y0_DSP_top.Inst_DSP_top_ConfigMem.Inst_frame10_bit26.Q sg13g2_a21oi_1
X_2938_ _1282_ _1314_ _1315_ VPWR VGND sg13g2_nor2_1
X_5726_ Tile_X0Y1_FrameData[29] Tile_X0Y1_FrameStrobe[2] Tile_X0Y1_DSP_bot.Inst_DSP_bot_ConfigMem.Inst_frame2_bit29.Q
+ VPWR VGND sg13g2_dlhq_1
XFILLER_10_318 VPWR VGND sg13g2_fill_2
XFILLER_22_134 VPWR VGND sg13g2_fill_2
X_4539_ VGND VPWR Tile_X0Y1_N2MID[7] Tile_X0Y0_DSP_top.Inst_DSP_top_ConfigMem.Inst_frame4_bit24.Q
+ _0295_ Tile_X0Y0_DSP_top.Inst_DSP_top_ConfigMem.Inst_frame4_bit25.Q sg13g2_a21oi_1
X_5588_ Tile_X0Y0_FrameData[25] Tile_X0Y1_FrameStrobe[12] Tile_X0Y0_DSP_top.Inst_DSP_top_ConfigMem.Inst_frame12_bit25.Q
+ VPWR VGND sg13g2_dlhq_1
X_5657_ _2529_ VGND VPWR Tile_X0Y0_DSP_top.Inst_DSP_top_switch_matrix.inst_cus_mux41_buf_top2bot15.X
+ Tile_X0Y1_DSP_bot.Inst_MULADD.C_reg\[17\] clknet_3_7_0_Tile_X0Y1_UserCLK_regs sg13g2_dfrbpq_1
X_4608_ _0360_ VPWR _0361_ VGND Tile_X0Y1_DSP_bot.Inst_DSP_bot_ConfigMem.Inst_frame4_bit20.Q
+ Tile_X0Y1_DSP_bot.Inst_DSP_bot_switch_matrix.Q4 sg13g2_o21ai_1
X_2869_ _1249_ _1245_ _1248_ _1240_ _1239_ VPWR VGND sg13g2_a22oi_1
X_6209_ Tile_X0Y0_FrameData[29] Tile_X0Y0_FrameData_O[29] VPWR VGND sg13g2_buf_1
XFILLER_53_270 VPWR VGND sg13g2_fill_1
XFILLER_13_156 VPWR VGND sg13g2_fill_2
X_3772_ VGND VPWR Tile_X0Y0_DSP_top.Inst_DSP_top_ConfigMem.Inst_frame4_bit30.Q _2100_
+ _2102_ _2101_ sg13g2_a21oi_1
X_3910_ Tile_X0Y0_DSP_top.Inst_DSP_top_ConfigMem.Inst_frame12_bit31.Q _2209_ _2210_
+ VPWR VGND sg13g2_nor2_1
X_3841_ Tile_X0Y0_DSP_top.Inst_DSP_top_ConfigMem.Inst_frame1_bit1.Q VPWR _2162_ VGND
+ Tile_X0Y0_DSP_top.Inst_DSP_top_ConfigMem.Inst_frame1_bit0.Q Tile_X0Y0_W2END[1] sg13g2_o21ai_1
X_5511_ Tile_X0Y0_FrameData[6] Tile_X0Y1_FrameStrobe[9] Tile_X0Y0_DSP_top.Inst_DSP_top_ConfigMem.Inst_frame9_bit6.Q
+ VPWR VGND sg13g2_dlhq_1
X_4890_ Tile_X0Y0_DSP_top.Inst_DSP_top_ConfigMem.Inst_frame2_bit13.Q Tile_X0Y0_S2END[4]
+ Tile_X0Y0_W2END[4] Tile_X0Y0_S4END[0] Tile_X0Y0_WW4END[2] Tile_X0Y0_DSP_top.Inst_DSP_top_ConfigMem.Inst_frame2_bit12.Q
+ _0631_ VPWR VGND sg13g2_mux4_1
X_2723_ Tile_X0Y1_DSP_bot.Inst_DSP_bot_ConfigMem.Inst_frame2_bit17.Q VPWR _1107_ VGND
+ Tile_X0Y1_DSP_bot.Inst_DSP_bot_ConfigMem.Inst_frame2_bit16.Q Tile_X0Y1_DSP_bot.Inst_DSP_bot_switch_matrix.Q7
+ sg13g2_o21ai_1
XFILLER_44_292 VPWR VGND sg13g2_fill_1
XFILLER_44_270 VPWR VGND sg13g2_fill_2
X_5373_ Tile_X0Y0_FrameData[16] Tile_X0Y1_FrameStrobe[5] Tile_X0Y0_DSP_top.Inst_DSP_top_ConfigMem.Inst_frame5_bit16.Q
+ VPWR VGND sg13g2_dlhq_1
X_5442_ Tile_X0Y0_FrameData[11] Tile_X0Y1_FrameStrobe[7] Tile_X0Y0_DSP_top.Inst_DSP_top_ConfigMem.Inst_frame7_bit11.Q
+ VPWR VGND sg13g2_dlhq_1
XFILLER_59_0 VPWR VGND sg13g2_fill_2
X_2585_ _0904_ _0973_ _0974_ VPWR VGND sg13g2_nor2_1
X_4324_ VPWR _0087_ Tile_X0Y1_DSP_bot.Inst_DSP_bot_ConfigMem.Inst_frame3_bit17.Q VGND
+ sg13g2_inv_1
X_6491_ Tile_X0Y1_W6END[8] Tile_X0Y1_W6BEG[6] VPWR VGND sg13g2_buf_1
X_2654_ _0079_ VPWR _1042_ VGND Tile_X0Y1_DSP_bot.Inst_DSP_bot_ConfigMem.Inst_frame3_bit13.Q
+ _1041_ sg13g2_o21ai_1
X_3206_ Tile_X0Y0_DSP_top.Inst_DSP_top_switch_matrix.JN2BEG5 _1571_ _1577_ _1569_
+ Tile_X0Y0_DSP_top.Inst_DSP_top_ConfigMem.Inst_frame4_bit23.Q VPWR VGND sg13g2_a22oi_1
X_4255_ Tile_X0Y1_DSP_bot.Inst_DSP_bot_switch_matrix.clr _2135_ _0018_ VPWR VGND sg13g2_nor2_1
X_3137_ Tile_X0Y0_DSP_top.Inst_DSP_top_ConfigMem.Inst_frame5_bit21.Q Tile_X0Y1_N2MID[5]
+ Tile_X0Y0_SS4END[1] Tile_X0Y0_E2END[5] Tile_X0Y0_W2END[5] Tile_X0Y0_DSP_top.Inst_DSP_top_ConfigMem.Inst_frame5_bit20.Q
+ _1512_ VPWR VGND sg13g2_mux4_1
X_4186_ Tile_X0Y1_DSP_bot.Inst_DSP_bot_ConfigMem.Inst_frame9_bit6.Q Tile_X0Y1_N1END[3]
+ Tile_X0Y1_W1END[3] _0435_ Tile_X0Y1_DSP_bot.Inst_DSP_bot_switch_matrix.Q3 Tile_X0Y1_DSP_bot.Inst_DSP_bot_ConfigMem.Inst_frame9_bit5.Q
+ _2429_ VPWR VGND sg13g2_mux4_1
XFILLER_27_226 VPWR VGND sg13g2_fill_1
XFILLER_82_332 VPWR VGND sg13g2_fill_2
X_3068_ _1445_ _1437_ _1444_ VPWR VGND sg13g2_xnor2_1
XFILLER_10_159 VPWR VGND sg13g2_fill_2
X_5709_ Tile_X0Y1_FrameData[14] Tile_X0Y1_FrameStrobe[1] Tile_X0Y1_DSP_bot.Inst_DSP_bot_ConfigMem.Inst_frame1_bit14.Q
+ VPWR VGND sg13g2_dlhq_1
XFILLER_53_62 VPWR VGND sg13g2_fill_1
XFILLER_26_281 VPWR VGND sg13g2_fill_1
XFILLER_5_174 VPWR VGND sg13g2_fill_2
X_4040_ _2321_ VPWR _2322_ VGND Tile_X0Y0_DSP_top.Inst_DSP_top_ConfigMem.Inst_frame9_bit22.Q
+ _0679_ sg13g2_o21ai_1
XFILLER_68_137 VPWR VGND sg13g2_fill_1
XFILLER_91_151 VPWR VGND sg13g2_fill_2
X_4942_ VGND VPWR Tile_X0Y0_DSP_top.Inst_DSP_top_ConfigMem.Inst_frame9_bit30.Q _0434_
+ _0680_ Tile_X0Y0_DSP_top.Inst_DSP_top_ConfigMem.Inst_frame9_bit31.Q sg13g2_a21oi_1
X_5991_ Tile_X0Y1_FrameData[20] Tile_X0Y1_FrameStrobe[10] Tile_X0Y1_DSP_bot.Inst_DSP_bot_ConfigMem.Inst_frame10_bit20.Q
+ VPWR VGND sg13g2_dlhq_1
X_3824_ Tile_X0Y0_DSP_top.Inst_DSP_top_ConfigMem.Inst_frame2_bit23.Q VPWR _2146_ VGND
+ _2142_ _2144_ sg13g2_o21ai_1
X_3755_ _2084_ VPWR _2085_ VGND Tile_X0Y0_DSP_top.Inst_DSP_top_ConfigMem.Inst_frame1_bit28.Q
+ Tile_X0Y0_DSP_top.Inst_DSP_top_switch_matrix.bot2top2 sg13g2_o21ai_1
X_4873_ VGND VPWR Tile_X0Y0_E6END[1] Tile_X0Y0_DSP_top.Inst_DSP_top_ConfigMem.Inst_frame0_bit4.Q
+ _0614_ _0613_ sg13g2_a21oi_1
X_3686_ _2001_ VPWR _2021_ VGND Tile_X0Y1_DSP_bot.Inst_DSP_bot_ConfigMem.Inst_frame12_bit3.Q
+ _2020_ sg13g2_o21ai_1
X_6474_ Tile_X0Y1_DSP_bot.Inst_DSP_bot_switch_matrix.JW2BEG5 Tile_X0Y1_W2BEG[5] VPWR
+ VGND sg13g2_buf_1
X_2706_ VGND VPWR Tile_X0Y1_DSP_bot.Inst_DSP_bot_ConfigMem.Inst_frame2_bit8.Q _0130_
+ _1091_ _1090_ sg13g2_a21oi_1
X_5356_ Tile_X0Y0_FrameData[1] Tile_X0Y1_FrameStrobe[4] Tile_X0Y0_DSP_top.Inst_DSP_top_ConfigMem.Inst_frame4_bit1.Q
+ VPWR VGND sg13g2_dlhq_1
X_5287_ Tile_X0Y0_FrameData[6] Tile_X0Y1_FrameStrobe[2] Tile_X0Y0_DSP_top.Inst_DSP_top_ConfigMem.Inst_frame2_bit6.Q
+ VPWR VGND sg13g2_dlhq_1
X_4307_ VPWR _0070_ Tile_X0Y0_DSP_top.Inst_DSP_top_ConfigMem.Inst_frame6_bit29.Q VGND
+ sg13g2_inv_1
X_5425_ Tile_X0Y0_FrameData[28] Tile_X0Y1_FrameStrobe[7] Tile_X0Y0_DSP_top.Inst_DSP_top_ConfigMem.Inst_frame7_bit28.Q
+ VPWR VGND sg13g2_dlhq_1
X_2568_ VGND VPWR Tile_X0Y0_DSP_top.Inst_DSP_top_ConfigMem.Inst_frame7_bit0.Q Tile_X0Y0_DSP_top.Inst_DSP_top_switch_matrix.JN2BEG3
+ _0958_ _0957_ sg13g2_a21oi_1
X_2637_ VGND VPWR _1025_ _1024_ _1021_ sg13g2_or2_1
XFILLER_74_17 VPWR VGND sg13g2_fill_2
X_4169_ Tile_X0Y1_DSP_bot.Inst_DSP_bot_ConfigMem.Inst_frame10_bit17.Q Tile_X0Y1_N1END[3]
+ Tile_X0Y1_E1END[3] Tile_X0Y1_W1END[3] Tile_X0Y1_DSP_bot.Inst_DSP_bot_switch_matrix.Q3
+ Tile_X0Y1_DSP_bot.Inst_DSP_bot_ConfigMem.Inst_frame10_bit18.Q _2416_ VPWR VGND sg13g2_mux4_1
X_4238_ Tile_X0Y1_DSP_bot.Inst_DSP_bot_switch_matrix.clr _2137_ _0001_ VPWR VGND sg13g2_nor2_1
XFILLER_15_218 VPWR VGND sg13g2_decap_8
XFILLER_46_310 VPWR VGND sg13g2_fill_1
X_3540_ _1418_ _1405_ _1893_ VPWR VGND sg13g2_xor2_1
XFILLER_9_78 VPWR VGND sg13g2_fill_1
X_6190_ Tile_X0Y0_FrameData[10] Tile_X0Y0_FrameData_O[10] VPWR VGND sg13g2_buf_1
X_5210_ Tile_X0Y0_FrameData[19] Tile_X0Y1_FrameStrobe[0] Tile_X0Y0_DSP_top.Inst_DSP_top_ConfigMem.Inst_frame0_bit19.Q
+ VPWR VGND sg13g2_dlhq_1
X_5141_ VGND VPWR _0074_ _0867_ _0869_ _0868_ sg13g2_a21oi_1
X_3471_ Tile_X0Y1_DSP_bot.Inst_DSP_bot_ConfigMem.Inst_frame8_bit14.Q VPWR _1828_ VGND
+ Tile_X0Y1_DSP_bot.Inst_DSP_bot_ConfigMem.Inst_frame0_bit25.Q _1827_ sg13g2_o21ai_1
X_5072_ Tile_X0Y0_DSP_top.Inst_DSP_top_ConfigMem.Inst_frame8_bit8.Q VPWR _0804_ VGND
+ Tile_X0Y0_DSP_top.Inst_DSP_top_ConfigMem.Inst_frame0_bit15.Q _0803_ sg13g2_o21ai_1
X_4023_ _2307_ VPWR _2308_ VGND Tile_X0Y0_DSP_top.Inst_DSP_top_ConfigMem.Inst_frame9_bit12.Q
+ Tile_X0Y0_DSP_top.Inst_DSP_top_switch_matrix.bot2top8 sg13g2_o21ai_1
XFILLER_49_181 VPWR VGND sg13g2_fill_2
X_4925_ _0663_ _0664_ _0665_ VPWR VGND sg13g2_nor2_1
X_4856_ Tile_X0Y0_S4END[0] Tile_X0Y0_DSP_top.Inst_DSP_top_switch_matrix.JW2BEG1 Tile_X0Y0_DSP_top.Inst_DSP_top_ConfigMem.Inst_frame0_bit6.Q
+ _0598_ VPWR VGND sg13g2_mux2_1
X_5974_ Tile_X0Y1_FrameData[5] Tile_X0Y1_FrameStrobe[9] Tile_X0Y1_DSP_bot.Inst_DSP_bot_ConfigMem.Inst_frame9_bit5.Q
+ VPWR VGND sg13g2_dlhq_1
X_4787_ _0531_ VPWR Tile_X0Y0_DSP_top.Inst_DSP_top_switch_matrix.inst_cus_mux41_buf_top2bot4.X
+ VGND _0516_ _0518_ sg13g2_o21ai_1
X_3738_ _2068_ _2000_ _2067_ VPWR VGND sg13g2_nand2_1
X_3807_ _2132_ _1938_ _2133_ VPWR VGND sg13g2_xor2_1
X_3669_ _2004_ VPWR _2005_ VGND Tile_X0Y0_E6END[1] Tile_X0Y0_DSP_top.Inst_DSP_top_ConfigMem.Inst_frame0_bit28.Q
+ sg13g2_o21ai_1
X_6457_ Tile_X0Y0_DSP_top.Inst_DSP_top_switch_matrix.SS4BEG0 Tile_X0Y1_SS4BEG[8] VPWR
+ VGND sg13g2_buf_1
X_5339_ Tile_X0Y0_FrameData[18] Tile_X0Y1_FrameStrobe[4] Tile_X0Y0_DSP_top.Inst_DSP_top_ConfigMem.Inst_frame4_bit18.Q
+ VPWR VGND sg13g2_dlhq_1
XFILLER_106_359 VPWR VGND sg13g2_fill_2
X_5408_ Tile_X0Y0_FrameData[13] Tile_X0Y1_FrameStrobe[6] Tile_X0Y0_DSP_top.Inst_DSP_top_ConfigMem.Inst_frame6_bit13.Q
+ VPWR VGND sg13g2_dlhq_1
XFILLER_47_107 VPWR VGND sg13g2_fill_1
X_6388_ Tile_X0Y1_FrameData[7] Tile_X0Y1_FrameData_O[7] VPWR VGND sg13g2_buf_1
XFILLER_70_154 VPWR VGND sg13g2_fill_1
XFILLER_28_310 VPWR VGND sg13g2_fill_1
XFILLER_28_332 VPWR VGND sg13g2_fill_2
XFILLER_70_187 VPWR VGND sg13g2_decap_8
XFILLER_50_74 VPWR VGND sg13g2_fill_2
XFILLER_50_52 VPWR VGND sg13g2_fill_1
X_4710_ Tile_X0Y0_DSP_top.Inst_DSP_top_ConfigMem.Inst_frame3_bit15.Q _0458_ _0459_
+ VPWR VGND sg13g2_and2_1
XFILLER_61_198 VPWR VGND sg13g2_fill_2
X_2971_ _1319_ _1318_ _1348_ VPWR VGND sg13g2_xor2_1
X_5690_ Tile_X0Y1_FrameData[1] Tile_X0Y1_FrameStrobe[0] Tile_X0Y1_DSP_bot.Inst_DSP_bot_ConfigMem.Inst_frame0_bit1.Q
+ VPWR VGND sg13g2_dlhq_1
X_4641_ Tile_X0Y0_DSP_top.Inst_DSP_top_ConfigMem.Inst_frame1_bit17.Q VPWR _0393_ VGND
+ Tile_X0Y0_DSP_top.Inst_DSP_top_ConfigMem.Inst_frame1_bit16.Q Tile_X0Y0_DSP_top.Inst_DSP_top_switch_matrix.bot2top7
+ sg13g2_o21ai_1
X_4572_ VGND VPWR _0034_ Tile_X0Y0_DSP_top.Inst_DSP_top_ConfigMem.Inst_frame3_bit8.Q
+ _0327_ Tile_X0Y0_DSP_top.Inst_DSP_top_ConfigMem.Inst_frame3_bit9.Q sg13g2_a21oi_1
X_6311_ Tile_X0Y0_W6END[8] Tile_X0Y0_W6BEG[6] VPWR VGND sg13g2_buf_1
X_3523_ Tile_X0Y1_DSP_bot.Inst_DSP_bot_ConfigMem.Inst_frame5_bit18.Q Tile_X0Y1_N2END[3]
+ Tile_X0Y1_E2END[3] Tile_X0Y0_S2MID[3] Tile_X0Y1_WW4END[1] Tile_X0Y1_DSP_bot.Inst_DSP_bot_ConfigMem.Inst_frame5_bit19.Q
+ _1877_ VPWR VGND sg13g2_mux4_1
X_6242_ Tile_X0Y0_DSP_top.Inst_DSP_top_switch_matrix.JN2BEG6 Tile_X0Y0_N2BEG[6] VPWR
+ VGND sg13g2_buf_1
X_5124_ VGND VPWR Tile_X0Y0_S2END[5] Tile_X0Y0_DSP_top.Inst_DSP_top_ConfigMem.Inst_frame2_bit16.Q
+ _0854_ Tile_X0Y0_DSP_top.Inst_DSP_top_ConfigMem.Inst_frame2_bit17.Q sg13g2_a21oi_1
X_6173_ Tile_X0Y0_EE4END[13] Tile_X0Y0_EE4BEG[9] VPWR VGND sg13g2_buf_1
X_3454_ Tile_X0Y1_DSP_bot.Inst_DSP_bot_ConfigMem.Inst_frame7_bit25.Q VPWR _1811_ VGND
+ Tile_X0Y1_DSP_bot.Inst_DSP_bot_ConfigMem.Inst_frame7_bit24.Q Tile_X0Y0_DSP_top.Inst_DSP_top_switch_matrix.JS2BEG6
+ sg13g2_o21ai_1
X_3385_ Tile_X0Y1_DSP_bot.Inst_DSP_bot_ConfigMem.Inst_frame2_bit25.Q _0435_ Tile_X0Y1_W1END[1]
+ Tile_X0Y0_S2MID[7] Tile_X0Y1_W1END[3] Tile_X0Y1_DSP_bot.Inst_DSP_bot_ConfigMem.Inst_frame2_bit24.Q
+ _1747_ VPWR VGND sg13g2_mux4_1
XFILLER_41_0 VPWR VGND sg13g2_fill_1
X_5055_ Tile_X0Y0_DSP_top.Inst_DSP_top_ConfigMem.Inst_frame1_bit8.Q Tile_X0Y0_DSP_top.Inst_DSP_top_switch_matrix.bot2top0
+ Tile_X0Y0_DSP_top.Inst_DSP_top_switch_matrix.bot2top1 Tile_X0Y0_DSP_top.Inst_DSP_top_switch_matrix.bot2top3
+ Tile_X0Y0_DSP_top.Inst_DSP_top_switch_matrix.bot2top4 Tile_X0Y0_DSP_top.Inst_DSP_top_ConfigMem.Inst_frame1_bit9.Q
+ _0788_ VPWR VGND sg13g2_mux4_1
X_4006_ Tile_X0Y0_W1END[3] Tile_X0Y0_DSP_top.Inst_DSP_top_switch_matrix.bot2top3 Tile_X0Y0_DSP_top.Inst_DSP_top_ConfigMem.Inst_frame9_bit9.Q
+ _2292_ VPWR VGND sg13g2_mux2_1
X_4908_ Tile_X0Y0_DSP_top.Inst_DSP_top_switch_matrix.bot2top6 Tile_X0Y0_DSP_top.Inst_DSP_top_ConfigMem.Inst_frame3_bit0.Q
+ _0648_ VPWR VGND sg13g2_nor2b_1
X_4839_ _0581_ VPWR _0582_ VGND Tile_X0Y0_DSP_top.Inst_DSP_top_ConfigMem.Inst_frame1_bit4.Q
+ Tile_X0Y0_DSP_top.Inst_DSP_top_switch_matrix.bot2top5 sg13g2_o21ai_1
X_5888_ Tile_X0Y1_FrameData[27] Tile_X0Y1_FrameStrobe[7] Tile_X0Y1_DSP_bot.Inst_DSP_bot_ConfigMem.Inst_frame7_bit27.Q
+ VPWR VGND sg13g2_dlhq_1
X_5957_ Tile_X0Y1_FrameData[22] Tile_X0Y1_FrameStrobe[9] Tile_X0Y1_DSP_bot.Inst_DSP_bot_ConfigMem.Inst_frame9_bit22.Q
+ VPWR VGND sg13g2_dlhq_1
X_6509_ Tile_X0Y1_DSP_bot.Inst_DSP_bot_switch_matrix.WW4BEG0 Tile_X0Y1_WW4BEG[12]
+ VPWR VGND sg13g2_buf_1
XFILLER_20_99 VPWR VGND sg13g2_decap_8
XFILLER_102_351 VPWR VGND sg13g2_fill_1
XFILLER_43_110 VPWR VGND sg13g2_fill_1
XANTENNA_6 VPWR VGND Tile_X0Y0_E6END[10] sg13g2_antennanp
X_3170_ _1543_ _1537_ Tile_X0Y0_DSP_top.Inst_DSP_top_ConfigMem.Inst_frame8_bit13.Q
+ VPWR VGND sg13g2_nand2b_1
XFILLER_81_216 VPWR VGND sg13g2_fill_1
X_2885_ _1263_ _1230_ _1261_ VPWR VGND sg13g2_xnor2_1
X_2954_ _1331_ _1330_ _1215_ VPWR VGND sg13g2_nand2b_1
X_5742_ Tile_X0Y1_FrameData[13] Tile_X0Y1_FrameStrobe[2] Tile_X0Y1_DSP_bot.Inst_DSP_bot_ConfigMem.Inst_frame2_bit13.Q
+ VPWR VGND sg13g2_dlhq_1
X_5811_ Tile_X0Y1_FrameData[8] Tile_X0Y1_FrameStrobe[4] Tile_X0Y1_DSP_bot.Inst_DSP_bot_ConfigMem.Inst_frame4_bit8.Q
+ VPWR VGND sg13g2_dlhq_1
X_5673_ Tile_X0Y1_FrameData[18] Tile_X0Y1_FrameStrobe[0] Tile_X0Y1_DSP_bot.Inst_DSP_bot_ConfigMem.Inst_frame0_bit18.Q
+ VPWR VGND sg13g2_dlhq_1
X_4486_ _0245_ Tile_X0Y0_DSP_top.Inst_DSP_top_ConfigMem.Inst_frame4_bit16.Q Tile_X0Y0_W1END[3]
+ VPWR VGND sg13g2_nand2b_1
X_4555_ VGND VPWR Tile_X0Y1_DSP_bot.Inst_DSP_bot_ConfigMem.Inst_frame4_bit24.Q _0130_
+ _0310_ _0309_ sg13g2_a21oi_1
X_4624_ _0377_ Tile_X0Y1_DSP_bot.Inst_DSP_bot_ConfigMem.Inst_frame4_bit12.Q Tile_X0Y1_W6END[0]
+ VPWR VGND sg13g2_nand2b_1
X_3506_ VGND VPWR _0072_ Tile_X0Y1_DSP_bot.C3 _1861_ _1860_ sg13g2_a21oi_1
X_6225_ Tile_X0Y1_FrameStrobe[13] Tile_X0Y0_FrameStrobe_O[13] VPWR VGND sg13g2_buf_1
XFILLER_103_126 VPWR VGND sg13g2_fill_1
X_6156_ Tile_X0Y0_E6END[6] Tile_X0Y0_E6BEG[4] VPWR VGND sg13g2_buf_1
X_3368_ VGND VPWR _1727_ _1730_ _1731_ _1721_ sg13g2_a21oi_1
X_5107_ _0837_ Tile_X0Y0_DSP_top.Inst_DSP_top_ConfigMem.Inst_frame0_bit13.Q _0836_
+ VPWR VGND sg13g2_nand2_1
X_3299_ _0093_ _1659_ _1666_ VPWR VGND sg13g2_nor2_1
X_3437_ VGND VPWR Tile_X0Y1_DSP_bot.Inst_DSP_bot_ConfigMem.Inst_frame8_bit16.Q _1794_
+ _1795_ Tile_X0Y1_DSP_bot.Inst_DSP_bot_ConfigMem.Inst_frame8_bit17.Q sg13g2_a21oi_1
X_6087_ VPWR VGND _2485_ sg13g2_tiehi
XFILLER_65_290 VPWR VGND sg13g2_fill_1
X_5038_ Tile_X0Y1_DSP_bot.Inst_DSP_bot_ConfigMem.Inst_frame1_bit4.Q Tile_X0Y1_E2END[2]
+ _0773_ VPWR VGND sg13g2_nor2b_1
XFILLER_88_360 VPWR VGND sg13g2_fill_1
XFILLER_56_290 VPWR VGND sg13g2_fill_2
XFILLER_12_360 VPWR VGND sg13g2_fill_1
X_2670_ Tile_X0Y1_DSP_bot.Inst_DSP_bot_ConfigMem.Inst_frame3_bit4.Q Tile_X0Y1_E6END[0]
+ Tile_X0Y0_S2MID[2] Tile_X0Y1_W2END[2] Tile_X0Y1_WW4END[3] Tile_X0Y1_DSP_bot.Inst_DSP_bot_ConfigMem.Inst_frame3_bit5.Q
+ _1057_ VPWR VGND sg13g2_mux4_1
X_4340_ VPWR _0103_ Tile_X0Y1_DSP_bot.Inst_DSP_bot_ConfigMem.Inst_frame6_bit30.Q VGND
+ sg13g2_inv_1
X_3153_ _1526_ VPWR _1527_ VGND Tile_X0Y0_S2END[6] Tile_X0Y0_DSP_top.Inst_DSP_top_ConfigMem.Inst_frame3_bit20.Q
+ sg13g2_o21ai_1
X_4271_ VPWR _0034_ Tile_X0Y1_N2MID[3] VGND sg13g2_inv_1
X_3222_ Tile_X0Y1_DSP_bot.Inst_DSP_bot_ConfigMem.Inst_frame3_bit22.Q _1591_ _1590_
+ _1588_ _1589_ Tile_X0Y1_DSP_bot.Inst_DSP_bot_ConfigMem.Inst_frame3_bit23.Q Tile_X0Y1_DSP_bot.Inst_DSP_bot_switch_matrix.E2BEG5
+ VPWR VGND sg13g2_mux4_1
X_6010_ Tile_X0Y1_FrameData[1] Tile_X0Y1_FrameStrobe[10] Tile_X0Y1_DSP_bot.Inst_DSP_bot_ConfigMem.Inst_frame10_bit1.Q
+ VPWR VGND sg13g2_dlhq_1
X_3084_ _1458_ _1460_ _1461_ VPWR VGND sg13g2_nor2_1
XFILLER_62_293 VPWR VGND sg13g2_fill_1
XFILLER_108_207 VPWR VGND sg13g2_fill_2
X_3986_ Tile_X0Y0_W1END[0] Tile_X0Y0_DSP_top.Inst_DSP_top_switch_matrix.bot2top4 Tile_X0Y0_DSP_top.Inst_DSP_top_ConfigMem.Inst_frame10_bit24.Q
+ _2275_ VPWR VGND sg13g2_mux2_1
X_5656_ _2528_ VGND VPWR Tile_X0Y0_DSP_top.Inst_DSP_top_switch_matrix.inst_cus_mux41_buf_top2bot14.X
+ Tile_X0Y1_DSP_bot.Inst_MULADD.C_reg\[16\] clknet_3_5_0_Tile_X0Y1_UserCLK_regs sg13g2_dfrbpq_1
X_4607_ _0360_ Tile_X0Y1_DSP_bot.Inst_DSP_bot_ConfigMem.Inst_frame4_bit20.Q _0126_
+ VPWR VGND sg13g2_nand2_1
X_2937_ _1312_ _1313_ _1314_ VPWR VGND sg13g2_nor2b_1
X_2868_ Tile_X0Y1_DSP_bot.Inst_DSP_bot_ConfigMem.Inst_frame3_bit19.Q _1247_ _1248_
+ VPWR VGND sg13g2_nor2_1
X_5725_ Tile_X0Y1_FrameData[30] Tile_X0Y1_FrameStrobe[2] Tile_X0Y1_DSP_bot.Inst_DSP_bot_ConfigMem.Inst_frame2_bit30.Q
+ VPWR VGND sg13g2_dlhq_1
X_6208_ Tile_X0Y0_FrameData[28] Tile_X0Y0_FrameData_O[28] VPWR VGND sg13g2_buf_1
X_4538_ VPWR _0294_ _0293_ VGND sg13g2_inv_1
X_5587_ Tile_X0Y0_FrameData[26] Tile_X0Y1_FrameStrobe[12] Tile_X0Y0_DSP_top.Inst_DSP_top_ConfigMem.Inst_frame12_bit26.Q
+ VPWR VGND sg13g2_dlhq_1
X_2799_ Tile_X0Y1_DSP_bot.Inst_DSP_bot_ConfigMem.Inst_frame9_bit22.Q VPWR _1180_ VGND
+ Tile_X0Y1_DSP_bot.Inst_DSP_bot_ConfigMem.Inst_frame6_bit1.Q _1179_ sg13g2_o21ai_1
X_4469_ _0228_ _0028_ Tile_X0Y1_DSP_bot.Inst_DSP_bot_ConfigMem.Inst_frame1_bit0.Q
+ VPWR VGND sg13g2_nand2_1
X_6139_ Tile_X0Y0_DSP_top.Inst_DSP_top_switch_matrix.E2BEG3 Tile_X0Y0_E2BEG[3] VPWR
+ VGND sg13g2_buf_1
XFILLER_107_240 VPWR VGND sg13g2_fill_2
XFILLER_42_64 VPWR VGND sg13g2_fill_2
XFILLER_95_105 VPWR VGND sg13g2_fill_2
XFILLER_3_47 VPWR VGND sg13g2_fill_2
XFILLER_29_290 VPWR VGND sg13g2_fill_1
X_3771_ Tile_X0Y0_DSP_top.Inst_DSP_top_ConfigMem.Inst_frame4_bit31.Q VPWR _2101_ VGND
+ Tile_X0Y0_DSP_top.Inst_DSP_top_ConfigMem.Inst_frame4_bit30.Q _2099_ sg13g2_o21ai_1
X_3840_ _2160_ VPWR _2161_ VGND Tile_X0Y0_DSP_top.Inst_DSP_top_ConfigMem.Inst_frame1_bit0.Q
+ Tile_X0Y0_S2END[1] sg13g2_o21ai_1
X_5510_ Tile_X0Y0_FrameData[7] Tile_X0Y1_FrameStrobe[9] Tile_X0Y0_DSP_top.Inst_DSP_top_ConfigMem.Inst_frame9_bit7.Q
+ VPWR VGND sg13g2_dlhq_1
X_2722_ _0125_ _0126_ Tile_X0Y1_DSP_bot.Inst_DSP_bot_ConfigMem.Inst_frame2_bit16.Q
+ _1106_ VPWR VGND sg13g2_mux2_1
X_6490_ Tile_X0Y1_W6END[7] Tile_X0Y1_W6BEG[5] VPWR VGND sg13g2_buf_1
X_5372_ Tile_X0Y0_FrameData[17] Tile_X0Y1_FrameStrobe[5] Tile_X0Y0_DSP_top.Inst_DSP_top_ConfigMem.Inst_frame5_bit17.Q
+ VPWR VGND sg13g2_dlhq_1
X_2584_ _0971_ _0972_ _0973_ VPWR VGND sg13g2_nor2_1
X_5441_ Tile_X0Y0_FrameData[12] Tile_X0Y1_FrameStrobe[7] Tile_X0Y0_DSP_top.Inst_DSP_top_ConfigMem.Inst_frame7_bit12.Q
+ VPWR VGND sg13g2_dlhq_1
X_4323_ VPWR _0086_ Tile_X0Y1_DSP_bot.Inst_DSP_bot_ConfigMem.Inst_frame7_bit10.Q VGND
+ sg13g2_inv_1
X_2653_ Tile_X0Y1_N1END[2] Tile_X0Y1_N2END[4] Tile_X0Y1_DSP_bot.Inst_DSP_bot_ConfigMem.Inst_frame3_bit12.Q
+ _1041_ VPWR VGND sg13g2_mux2_1
X_3205_ Tile_X0Y0_DSP_top.Inst_DSP_top_ConfigMem.Inst_frame4_bit23.Q _1576_ _1577_
+ VPWR VGND sg13g2_nor2_1
X_4254_ Tile_X0Y1_DSP_bot.Inst_DSP_bot_switch_matrix.clr _2056_ _0017_ VPWR VGND sg13g2_nor2_1
X_3136_ Tile_X0Y0_DSP_top.Inst_DSP_top_ConfigMem.Inst_frame6_bit21.Q Tile_X0Y0_DSP_top.Inst_DSP_top_switch_matrix.N2BEGb5
+ Tile_X0Y0_S2MID[5] Tile_X0Y0_E2MID[5] Tile_X0Y0_W2MID[5] Tile_X0Y0_DSP_top.Inst_DSP_top_ConfigMem.Inst_frame6_bit20.Q
+ _1511_ VPWR VGND sg13g2_mux4_1
X_3067_ _1443_ _1149_ _1444_ VPWR VGND sg13g2_xor2_1
X_4185_ VGND VPWR Tile_X0Y1_DSP_bot.Inst_DSP_bot_ConfigMem.Inst_frame9_bit6.Q _2424_
+ _2428_ _2427_ sg13g2_a21oi_1
XFILLER_50_274 VPWR VGND sg13g2_fill_1
XFILLER_88_27 VPWR VGND sg13g2_fill_1
X_3969_ Tile_X0Y0_DSP_top.Inst_DSP_top_ConfigMem.Inst_frame10_bit19.Q Tile_X0Y0_DSP_top.Inst_DSP_top_switch_matrix.bot2top6
+ _0937_ _0980_ _2030_ Tile_X0Y0_DSP_top.Inst_DSP_top_ConfigMem.Inst_frame10_bit18.Q
+ _2260_ VPWR VGND sg13g2_mux4_1
X_5639_ _2511_ VGND VPWR Tile_X0Y0_DSP_top.Inst_DSP_top_switch_matrix.inst_cus_mux41_buf_top2bot7.X
+ Tile_X0Y1_DSP_bot.Inst_MULADD.B_reg\[7\] clknet_3_4_0_Tile_X0Y1_UserCLK_regs sg13g2_dfrbpq_1
XFILLER_10_149 VPWR VGND sg13g2_fill_2
X_5708_ Tile_X0Y1_FrameData[15] Tile_X0Y1_FrameStrobe[1] Tile_X0Y1_DSP_bot.Inst_DSP_bot_ConfigMem.Inst_frame1_bit15.Q
+ VPWR VGND sg13g2_dlhq_1
XFILLER_104_210 VPWR VGND sg13g2_fill_2
XFILLER_58_341 VPWR VGND sg13g2_fill_2
XFILLER_2_359 VPWR VGND sg13g2_fill_2
XFILLER_73_322 VPWR VGND sg13g2_fill_2
XFILLER_110_235 VPWR VGND sg13g2_fill_2
X_3823_ Tile_X0Y0_DSP_top.Inst_DSP_top_ConfigMem.Inst_frame2_bit20.Q Tile_X0Y0_DSP_top.Inst_DSP_top_switch_matrix.bot2top0
+ Tile_X0Y0_DSP_top.Inst_DSP_top_switch_matrix.bot2top1 Tile_X0Y0_DSP_top.Inst_DSP_top_switch_matrix.bot2top2
+ Tile_X0Y0_DSP_top.Inst_DSP_top_switch_matrix.bot2top3 Tile_X0Y0_DSP_top.Inst_DSP_top_ConfigMem.Inst_frame2_bit21.Q
+ _2145_ VPWR VGND sg13g2_mux4_1
X_4872_ Tile_X0Y0_DSP_top.Inst_DSP_top_ConfigMem.Inst_frame0_bit4.Q Tile_X0Y1_N4END[5]
+ _0613_ VPWR VGND sg13g2_nor2b_1
X_4941_ Tile_X0Y0_DSP_top.Inst_DSP_top_ConfigMem.Inst_frame7_bit5.Q Tile_X0Y0_DSP_top.Inst_DSP_top_switch_matrix.N2BEGb4
+ Tile_X0Y0_W2MID[4] Tile_X0Y0_E2MID[4] Tile_X0Y0_DSP_top.Inst_DSP_top_switch_matrix.JS2BEG3
+ Tile_X0Y0_DSP_top.Inst_DSP_top_ConfigMem.Inst_frame7_bit4.Q _0679_ VPWR VGND sg13g2_mux4_1
X_5990_ Tile_X0Y1_FrameData[21] Tile_X0Y1_FrameStrobe[10] Tile_X0Y1_DSP_bot.Inst_DSP_bot_ConfigMem.Inst_frame10_bit21.Q
+ VPWR VGND sg13g2_dlhq_1
XFILLER_17_282 VPWR VGND sg13g2_fill_1
X_3754_ _2084_ Tile_X0Y0_DSP_top.Inst_DSP_top_ConfigMem.Inst_frame1_bit28.Q Tile_X0Y0_DSP_top.Inst_DSP_top_switch_matrix.bot2top3
+ VPWR VGND sg13g2_nand2b_1
X_3685_ _2019_ VPWR _2020_ VGND Tile_X0Y1_DSP_bot.Inst_DSP_bot_ConfigMem.Inst_frame12_bit2.Q
+ Tile_X0Y0_DSP_top.Inst_DSP_top_switch_matrix.inst_cus_mux41_buf_top2bot14.X sg13g2_o21ai_1
XFILLER_71_0 VPWR VGND sg13g2_fill_1
X_5424_ Tile_X0Y0_FrameData[29] Tile_X0Y1_FrameStrobe[7] Tile_X0Y0_DSP_top.Inst_DSP_top_ConfigMem.Inst_frame7_bit29.Q
+ VPWR VGND sg13g2_dlhq_1
X_6473_ Tile_X0Y1_W2END[4] Tile_X0Y1_W2BEG[4] VPWR VGND sg13g2_buf_1
X_2636_ _0079_ VPWR _1024_ VGND Tile_X0Y1_DSP_bot.Inst_DSP_bot_ConfigMem.Inst_frame3_bit13.Q
+ _1023_ sg13g2_o21ai_1
X_2705_ Tile_X0Y1_DSP_bot.Inst_DSP_bot_ConfigMem.Inst_frame2_bit9.Q VPWR _1090_ VGND
+ Tile_X0Y1_DSP_bot.Inst_DSP_bot_ConfigMem.Inst_frame2_bit8.Q Tile_X0Y1_DSP_bot.Inst_DSP_bot_switch_matrix.Q7
+ sg13g2_o21ai_1
X_5355_ Tile_X0Y0_FrameData[2] Tile_X0Y1_FrameStrobe[4] Tile_X0Y0_DSP_top.Inst_DSP_top_ConfigMem.Inst_frame4_bit2.Q
+ VPWR VGND sg13g2_dlhq_1
X_5286_ Tile_X0Y0_FrameData[7] Tile_X0Y1_FrameStrobe[2] Tile_X0Y0_DSP_top.Inst_DSP_top_ConfigMem.Inst_frame2_bit7.Q
+ VPWR VGND sg13g2_dlhq_1
X_4306_ VPWR _0069_ Tile_X0Y0_DSP_top.Inst_DSP_top_ConfigMem.Inst_frame6_bit28.Q VGND
+ sg13g2_inv_1
XFILLER_58_19 VPWR VGND sg13g2_decap_4
X_2567_ Tile_X0Y0_DSP_top.Inst_DSP_top_ConfigMem.Inst_frame7_bit0.Q Tile_X0Y0_W2MID[6]
+ _0957_ VPWR VGND sg13g2_nor2b_1
X_4237_ Tile_X0Y1_DSP_bot.Inst_DSP_bot_switch_matrix.clr _1946_ _0000_ VPWR VGND sg13g2_nor2_1
X_3119_ Tile_X0Y0_WW4END[1] _0568_ Tile_X0Y0_DSP_top.Inst_DSP_top_ConfigMem.Inst_frame0_bit22.Q
+ _1495_ VPWR VGND sg13g2_mux2_1
X_4099_ Tile_X0Y1_DSP_bot.Inst_DSP_bot_ConfigMem.Inst_frame2_bit1.Q VPWR _2361_ VGND
+ Tile_X0Y1_W2END[1] Tile_X0Y1_DSP_bot.Inst_DSP_bot_ConfigMem.Inst_frame2_bit0.Q sg13g2_o21ai_1
X_4168_ Tile_X0Y1_DSP_bot.Inst_DSP_bot_ConfigMem.Inst_frame10_bit17.Q Tile_X0Y1_DSP_bot.Inst_DSP_bot_switch_matrix.Q7
+ _0875_ _1122_ _1844_ Tile_X0Y1_DSP_bot.Inst_DSP_bot_ConfigMem.Inst_frame10_bit18.Q
+ _2415_ VPWR VGND sg13g2_mux4_1
XFILLER_90_28 VPWR VGND sg13g2_fill_2
XFILLER_90_17 VPWR VGND sg13g2_fill_1
XFILLER_61_303 VPWR VGND sg13g2_fill_2
X_5071_ VGND VPWR Tile_X0Y0_SS4END[0] Tile_X0Y0_DSP_top.Inst_DSP_top_ConfigMem.Inst_frame0_bit14.Q
+ _0803_ _0802_ sg13g2_a21oi_1
X_5140_ _0074_ Tile_X0Y1_DSP_bot.Inst_MULADD.B_reg\[6\] _0868_ VPWR VGND sg13g2_nor2_1
X_3470_ VGND VPWR Tile_X0Y1_EE4END[0] Tile_X0Y1_DSP_bot.Inst_DSP_bot_ConfigMem.Inst_frame0_bit24.Q
+ _1827_ _1826_ sg13g2_a21oi_1
X_4022_ _2307_ Tile_X0Y0_DSP_top.Inst_DSP_top_ConfigMem.Inst_frame9_bit12.Q _1537_
+ VPWR VGND sg13g2_nand2_1
XFILLER_64_141 VPWR VGND sg13g2_fill_2
X_5973_ Tile_X0Y1_FrameData[6] Tile_X0Y1_FrameStrobe[9] Tile_X0Y1_DSP_bot.Inst_DSP_bot_ConfigMem.Inst_frame9_bit6.Q
+ VPWR VGND sg13g2_dlhq_1
X_4924_ Tile_X0Y0_DSP_top.Inst_DSP_top_ConfigMem.Inst_frame3_bit2.Q VPWR _0664_ VGND
+ Tile_X0Y0_DSP_top.Inst_DSP_top_ConfigMem.Inst_frame3_bit1.Q _0661_ sg13g2_o21ai_1
X_4786_ _0530_ VPWR _0531_ VGND _0521_ _0524_ sg13g2_o21ai_1
X_4855_ _0597_ VPWR Tile_X0Y0_DSP_top.Inst_DSP_top_switch_matrix.JW2BEG1 VGND _0580_
+ _0586_ sg13g2_o21ai_1
X_3806_ _2132_ _1504_ _1507_ VPWR VGND sg13g2_xnor2_1
XFILLER_20_233 VPWR VGND sg13g2_decap_8
XFILLER_109_14 VPWR VGND sg13g2_decap_4
X_6456_ Tile_X0Y0_SS4END[15] Tile_X0Y1_SS4BEG[7] VPWR VGND sg13g2_buf_1
X_3737_ _2067_ _2065_ _2066_ _0112_ Tile_X0Y1_DSP_bot.Inst_DSP_bot_ConfigMem.Inst_frame12_bit3.Q
+ VPWR VGND sg13g2_a22oi_1
X_5407_ Tile_X0Y0_FrameData[14] Tile_X0Y1_FrameStrobe[6] Tile_X0Y0_DSP_top.Inst_DSP_top_ConfigMem.Inst_frame6_bit14.Q
+ VPWR VGND sg13g2_dlhq_1
X_3668_ VGND VPWR _0043_ Tile_X0Y0_DSP_top.Inst_DSP_top_ConfigMem.Inst_frame0_bit28.Q
+ _2004_ Tile_X0Y0_DSP_top.Inst_DSP_top_ConfigMem.Inst_frame0_bit29.Q sg13g2_a21oi_1
X_2619_ _1007_ _0869_ _0991_ VPWR VGND sg13g2_nand2_1
X_6387_ Tile_X0Y1_FrameData[6] Tile_X0Y1_FrameData_O[6] VPWR VGND sg13g2_buf_1
X_3599_ _1948_ _1921_ _1922_ VPWR VGND sg13g2_xnor2_1
X_5338_ Tile_X0Y0_FrameData[19] Tile_X0Y1_FrameStrobe[4] Tile_X0Y0_DSP_top.Inst_DSP_top_ConfigMem.Inst_frame4_bit19.Q
+ VPWR VGND sg13g2_dlhq_1
X_5269_ Tile_X0Y0_FrameData[24] Tile_X0Y1_FrameStrobe[2] Tile_X0Y0_DSP_top.Inst_DSP_top_ConfigMem.Inst_frame2_bit24.Q
+ VPWR VGND sg13g2_dlhq_1
XFILLER_87_277 VPWR VGND sg13g2_fill_2
XFILLER_87_222 VPWR VGND sg13g2_fill_2
XFILLER_70_133 VPWR VGND sg13g2_fill_1
XFILLER_70_100 VPWR VGND sg13g2_decap_4
XFILLER_43_358 VPWR VGND sg13g2_fill_2
XFILLER_43_336 VPWR VGND sg13g2_fill_1
XFILLER_43_303 VPWR VGND sg13g2_fill_2
XFILLER_78_211 VPWR VGND sg13g2_fill_2
XFILLER_1_0 VPWR VGND sg13g2_fill_2
XFILLER_78_255 VPWR VGND sg13g2_fill_1
XFILLER_19_355 VPWR VGND sg13g2_fill_1
X_4640_ _0391_ VPWR _0392_ VGND Tile_X0Y0_DSP_top.Inst_DSP_top_ConfigMem.Inst_frame1_bit16.Q
+ Tile_X0Y0_DSP_top.Inst_DSP_top_switch_matrix.bot2top5 sg13g2_o21ai_1
X_2970_ VGND VPWR _1345_ _1346_ _1347_ _1344_ sg13g2_a21oi_1
X_6241_ Tile_X0Y0_DSP_top.Inst_DSP_top_switch_matrix.JN2BEG5 Tile_X0Y0_N2BEG[5] VPWR
+ VGND sg13g2_buf_1
X_4571_ _0325_ _0319_ _0326_ VPWR VGND sg13g2_nor2b_1
X_6310_ Tile_X0Y0_W6END[7] Tile_X0Y0_W6BEG[5] VPWR VGND sg13g2_buf_1
X_3453_ _1810_ Tile_X0Y1_DSP_bot.Inst_DSP_bot_ConfigMem.Inst_frame12_bit3.Q Tile_X0Y1_DSP_bot.Inst_MULADD.ACC\[4\]
+ VPWR VGND sg13g2_nand2_1
X_3522_ Tile_X0Y1_DSP_bot.Inst_DSP_bot_ConfigMem.Inst_frame0_bit19.Q Tile_X0Y1_NN4END[2]
+ Tile_X0Y0_S4END[6] Tile_X0Y1_E2END[2] Tile_X0Y1_DSP_bot.Inst_DSP_bot_switch_matrix.E2BEG3
+ Tile_X0Y1_DSP_bot.Inst_DSP_bot_ConfigMem.Inst_frame0_bit18.Q _1876_ VPWR VGND sg13g2_mux4_1
X_5123_ _0853_ Tile_X0Y0_S1END[1] Tile_X0Y0_DSP_top.Inst_DSP_top_ConfigMem.Inst_frame2_bit16.Q
+ VPWR VGND sg13g2_nand2b_1
X_6172_ Tile_X0Y0_EE4END[12] Tile_X0Y0_EE4BEG[8] VPWR VGND sg13g2_buf_1
XFILLER_69_277 VPWR VGND sg13g2_fill_2
X_3384_ Tile_X0Y1_DSP_bot.Inst_DSP_bot_ConfigMem.Inst_frame2_bit24.Q Tile_X0Y1_N1END[3]
+ Tile_X0Y1_N2END[7] Tile_X0Y1_E1END[3] Tile_X0Y1_E2END[7] Tile_X0Y1_DSP_bot.Inst_DSP_bot_ConfigMem.Inst_frame2_bit25.Q
+ _1746_ VPWR VGND sg13g2_mux4_1
X_5054_ VPWR _0787_ _0786_ VGND sg13g2_inv_1
XFILLER_34_0 VPWR VGND sg13g2_fill_1
X_4005_ VGND VPWR Tile_X0Y0_S1END[3] Tile_X0Y0_DSP_top.Inst_DSP_top_ConfigMem.Inst_frame9_bit9.Q
+ _2291_ _2290_ sg13g2_a21oi_1
X_5956_ Tile_X0Y1_FrameData[23] Tile_X0Y1_FrameStrobe[9] Tile_X0Y1_DSP_bot.Inst_DSP_bot_ConfigMem.Inst_frame9_bit23.Q
+ VPWR VGND sg13g2_dlhq_1
X_4769_ VGND VPWR Tile_X0Y0_SS4END[3] Tile_X0Y0_DSP_top.Inst_DSP_top_ConfigMem.Inst_frame0_bit8.Q
+ _0514_ _0513_ sg13g2_a21oi_1
X_4907_ Tile_X0Y0_DSP_top.Inst_DSP_top_ConfigMem.Inst_frame3_bit2.Q _0646_ _0647_
+ VPWR VGND sg13g2_nor2_1
X_4838_ _0581_ Tile_X0Y0_DSP_top.Inst_DSP_top_ConfigMem.Inst_frame1_bit4.Q Tile_X0Y0_DSP_top.Inst_DSP_top_switch_matrix.bot2top6
+ VPWR VGND sg13g2_nand2b_1
X_5887_ Tile_X0Y1_FrameData[28] Tile_X0Y1_FrameStrobe[7] Tile_X0Y1_DSP_bot.Inst_DSP_bot_ConfigMem.Inst_frame7_bit28.Q
+ VPWR VGND sg13g2_dlhq_1
X_6439_ Tile_X0Y0_S4END[14] Tile_X0Y1_S4BEG[6] VPWR VGND sg13g2_buf_1
X_6508_ Tile_X0Y1_WW4END[15] Tile_X0Y1_WW4BEG[11] VPWR VGND sg13g2_buf_1
XFILLER_45_20 VPWR VGND sg13g2_fill_1
XANTENNA_7 VPWR VGND Tile_X0Y0_E6END[3] sg13g2_antennanp
XFILLER_6_47 VPWR VGND sg13g2_fill_2
X_5810_ Tile_X0Y1_FrameData[9] Tile_X0Y1_FrameStrobe[4] Tile_X0Y1_DSP_bot.Inst_DSP_bot_ConfigMem.Inst_frame4_bit9.Q
+ VPWR VGND sg13g2_dlhq_1
XFILLER_19_185 VPWR VGND sg13g2_fill_2
XFILLER_22_306 VPWR VGND sg13g2_fill_2
X_2884_ _1262_ _1230_ _1261_ VPWR VGND sg13g2_nand2_1
X_2953_ _1329_ _1325_ _1330_ VPWR VGND sg13g2_xor2_1
XFILLER_34_188 VPWR VGND sg13g2_decap_4
X_5741_ Tile_X0Y1_FrameData[14] Tile_X0Y1_FrameStrobe[2] Tile_X0Y1_DSP_bot.Inst_DSP_bot_ConfigMem.Inst_frame2_bit14.Q
+ VPWR VGND sg13g2_dlhq_1
X_4623_ VGND VPWR _0024_ Tile_X0Y1_DSP_bot.Inst_DSP_bot_ConfigMem.Inst_frame4_bit12.Q
+ _0376_ _0375_ sg13g2_a21oi_1
X_5672_ Tile_X0Y1_FrameData[19] Tile_X0Y1_FrameStrobe[0] Tile_X0Y1_DSP_bot.Inst_DSP_bot_ConfigMem.Inst_frame0_bit19.Q
+ VPWR VGND sg13g2_dlhq_1
X_4485_ VGND VPWR Tile_X0Y0_S2END[5] Tile_X0Y0_DSP_top.Inst_DSP_top_ConfigMem.Inst_frame4_bit16.Q
+ _0244_ Tile_X0Y0_DSP_top.Inst_DSP_top_ConfigMem.Inst_frame4_bit17.Q sg13g2_a21oi_1
XFILLER_106_15 VPWR VGND sg13g2_fill_2
X_6224_ Tile_X0Y1_FrameStrobe[12] Tile_X0Y0_FrameStrobe_O[12] VPWR VGND sg13g2_buf_1
X_4554_ Tile_X0Y1_DSP_bot.Inst_DSP_bot_ConfigMem.Inst_frame4_bit25.Q VPWR _0309_ VGND
+ Tile_X0Y1_DSP_bot.Inst_DSP_bot_ConfigMem.Inst_frame4_bit24.Q Tile_X0Y1_DSP_bot.Inst_DSP_bot_switch_matrix.Q7
+ sg13g2_o21ai_1
X_3436_ VPWR _1794_ _1793_ VGND sg13g2_inv_1
X_3505_ Tile_X0Y1_DSP_bot.Inst_DSP_bot_ConfigMem.Inst_frame12_bit2.Q Tile_X0Y1_DSP_bot.Inst_MULADD.C_reg\[3\]
+ _1860_ VPWR VGND sg13g2_and2_1
X_6155_ Tile_X0Y0_E6END[5] Tile_X0Y0_E6BEG[3] VPWR VGND sg13g2_buf_1
XFILLER_72_206 VPWR VGND sg13g2_decap_4
X_5106_ VGND VPWR Tile_X0Y0_DSP_top.Inst_DSP_top_ConfigMem.Inst_frame0_bit12.Q Tile_X0Y0_DSP_top.Inst_DSP_top_switch_matrix.JS2BEG2
+ _0836_ _0835_ sg13g2_a21oi_1
X_3367_ _1729_ Tile_X0Y1_DSP_bot.Inst_DSP_bot_ConfigMem.Inst_frame1_bit27.Q _1730_
+ VPWR VGND sg13g2_nor2b_1
X_3298_ _1664_ VPWR _1665_ VGND Tile_X0Y1_DSP_bot.Inst_DSP_bot_ConfigMem.Inst_frame2_bit29.Q
+ _1661_ sg13g2_o21ai_1
X_5037_ VGND VPWR Tile_X0Y1_W6END[0] Tile_X0Y1_DSP_bot.Inst_DSP_bot_ConfigMem.Inst_frame1_bit4.Q
+ _0772_ _0771_ sg13g2_a21oi_1
X_6086_ VPWR VGND _2484_ sg13g2_tiehi
X_5939_ Tile_X0Y1_FrameData[8] Tile_X0Y1_FrameStrobe[8] Tile_X0Y1_DSP_bot.Inst_DSP_bot_ConfigMem.Inst_frame8_bit8.Q
+ VPWR VGND sg13g2_dlhq_1
XFILLER_25_177 VPWR VGND sg13g2_fill_2
XFILLER_48_214 VPWR VGND sg13g2_fill_2
XFILLER_0_243 VPWR VGND sg13g2_fill_1
XFILLER_0_265 VPWR VGND sg13g2_fill_1
X_4270_ VPWR _0033_ Tile_X0Y1_DSP_bot.Inst_DSP_bot_ConfigMem.Inst_frame1_bit3.Q VGND
+ sg13g2_inv_1
X_3152_ _1526_ Tile_X0Y0_DSP_top.Inst_DSP_top_ConfigMem.Inst_frame3_bit20.Q Tile_X0Y0_W1END[2]
+ VPWR VGND sg13g2_nand2b_1
X_3083_ VGND VPWR _1456_ _1457_ _1460_ _0496_ sg13g2_a21oi_1
X_3221_ Tile_X0Y1_DSP_bot.Inst_DSP_bot_ConfigMem.Inst_frame3_bit21.Q Tile_X0Y1_N1END[2]
+ Tile_X0Y1_E1END[2] Tile_X0Y1_N2END[6] Tile_X0Y1_E2END[6] Tile_X0Y1_DSP_bot.Inst_DSP_bot_ConfigMem.Inst_frame3_bit20.Q
+ _1591_ VPWR VGND sg13g2_mux4_1
X_3985_ _2273_ VPWR _2274_ VGND Tile_X0Y0_DSP_top.Inst_DSP_top_ConfigMem.Inst_frame10_bit24.Q
+ _0189_ sg13g2_o21ai_1
XFILLER_54_239 VPWR VGND sg13g2_decap_8
X_5586_ Tile_X0Y0_FrameData[27] Tile_X0Y1_FrameStrobe[12] Tile_X0Y0_DSP_top.Inst_DSP_top_ConfigMem.Inst_frame12_bit27.Q
+ VPWR VGND sg13g2_dlhq_1
X_5655_ _2527_ VGND VPWR Tile_X0Y0_DSP_top.Inst_DSP_top_switch_matrix.inst_cus_mux41_buf_top2bot13.X
+ Tile_X0Y1_DSP_bot.Inst_MULADD.C_reg\[15\] clknet_3_7_0_Tile_X0Y1_UserCLK_regs sg13g2_dfrbpq_1
X_4606_ Tile_X0Y1_DSP_bot.Inst_DSP_bot_ConfigMem.Inst_frame4_bit22.Q _0358_ _0359_
+ VPWR VGND sg13g2_nor2_1
X_2936_ _1281_ _1280_ _1313_ VPWR VGND sg13g2_xor2_1
X_2867_ Tile_X0Y1_DSP_bot.Inst_DSP_bot_ConfigMem.Inst_frame3_bit18.Q _1246_ _1247_
+ VPWR VGND sg13g2_nor2_1
X_2798_ _1178_ VPWR _1179_ VGND Tile_X0Y1_N2MID[7] Tile_X0Y1_DSP_bot.Inst_DSP_bot_ConfigMem.Inst_frame6_bit0.Q
+ sg13g2_o21ai_1
X_5724_ Tile_X0Y1_FrameData[31] Tile_X0Y1_FrameStrobe[2] Tile_X0Y1_DSP_bot.Inst_DSP_bot_ConfigMem.Inst_frame2_bit31.Q
+ VPWR VGND sg13g2_dlhq_1
X_6207_ Tile_X0Y0_FrameData[27] Tile_X0Y0_FrameData_O[27] VPWR VGND sg13g2_buf_1
X_6138_ Tile_X0Y0_DSP_top.Inst_DSP_top_switch_matrix.E2BEG2 Tile_X0Y0_E2BEG[2] VPWR
+ VGND sg13g2_buf_1
X_3419_ _1778_ _1370_ _1371_ VPWR VGND sg13g2_xnor2_1
X_4468_ VGND VPWR Tile_X0Y1_DSP_bot.Inst_DSP_bot_ConfigMem.Inst_frame1_bit2.Q _0224_
+ _0227_ _0033_ sg13g2_a21oi_1
X_4399_ Tile_X0Y1_DSP_bot.Inst_DSP_bot_switch_matrix.Q5 Tile_X0Y1_DSP_bot.Inst_DSP_bot_switch_matrix.Q6
+ Tile_X0Y1_DSP_bot.Inst_DSP_bot_ConfigMem.Inst_frame3_bit8.Q _0161_ VPWR VGND sg13g2_mux2_1
X_4537_ _0290_ VPWR _0293_ VGND Tile_X0Y1_DSP_bot.Inst_DSP_bot_ConfigMem.Inst_frame12_bit13.Q
+ _0292_ sg13g2_o21ai_1
X_6069_ Tile_X0Y1_FrameData[6] Tile_X0Y1_FrameStrobe[12] Tile_X0Y1_DSP_bot.Inst_DSP_bot_ConfigMem.Inst_frame12_bit6.Q
+ VPWR VGND sg13g2_dlhq_1
XFILLER_91_301 VPWR VGND sg13g2_fill_2
XFILLER_51_209 VPWR VGND sg13g2_fill_1
X_3770_ Tile_X0Y0_DSP_top.Inst_DSP_top_ConfigMem.Inst_frame4_bit29.Q Tile_X0Y0_DSP_top.Inst_DSP_top_switch_matrix.bot2top4
+ Tile_X0Y0_DSP_top.Inst_DSP_top_switch_matrix.bot2top6 Tile_X0Y0_DSP_top.Inst_DSP_top_switch_matrix.bot2top5
+ Tile_X0Y0_DSP_top.Inst_DSP_top_switch_matrix.bot2top8 Tile_X0Y0_DSP_top.Inst_DSP_top_ConfigMem.Inst_frame4_bit28.Q
+ _2100_ VPWR VGND sg13g2_mux4_1
X_5440_ Tile_X0Y0_FrameData[13] Tile_X0Y1_FrameStrobe[7] Tile_X0Y0_DSP_top.Inst_DSP_top_ConfigMem.Inst_frame7_bit13.Q
+ VPWR VGND sg13g2_dlhq_1
X_2721_ Tile_X0Y1_DSP_bot.Inst_DSP_bot_ConfigMem.Inst_frame2_bit18.Q _1104_ _1105_
+ VPWR VGND sg13g2_nor2_1
X_2652_ _1039_ VPWR _1040_ VGND Tile_X0Y1_N4END[0] Tile_X0Y1_DSP_bot.Inst_DSP_bot_ConfigMem.Inst_frame3_bit12.Q
+ sg13g2_o21ai_1
X_3204_ VGND VPWR Tile_X0Y0_DSP_top.Inst_DSP_top_ConfigMem.Inst_frame4_bit21.Q _1573_
+ _1576_ _1575_ sg13g2_a21oi_1
X_5371_ Tile_X0Y0_FrameData[18] Tile_X0Y1_FrameStrobe[5] Tile_X0Y0_DSP_top.Inst_DSP_top_ConfigMem.Inst_frame5_bit18.Q
+ VPWR VGND sg13g2_dlhq_1
X_4253_ Tile_X0Y1_DSP_bot.Inst_DSP_bot_switch_matrix.clr _2027_ _0016_ VPWR VGND sg13g2_nor2_1
X_2583_ _0903_ _0902_ _0972_ VPWR VGND sg13g2_xor2_1
X_4322_ VPWR _0085_ Tile_X0Y1_DSP_bot.Inst_DSP_bot_ConfigMem.Inst_frame9_bit22.Q VGND
+ sg13g2_inv_1
X_3066_ _1441_ _1440_ _1443_ VPWR VGND sg13g2_xor2_1
X_3135_ Tile_X0Y0_DSP_top.Inst_DSP_top_ConfigMem.Inst_frame7_bit21.Q Tile_X0Y0_DSP_top.Inst_DSP_top_switch_matrix.N2BEGb4
+ Tile_X0Y0_W2MID[4] Tile_X0Y0_S2MID[4] Tile_X0Y0_DSP_top.Inst_DSP_top_switch_matrix.JS2BEG5
+ Tile_X0Y0_DSP_top.Inst_DSP_top_ConfigMem.Inst_frame7_bit20.Q _1510_ VPWR VGND sg13g2_mux4_1
X_4184_ Tile_X0Y1_DSP_bot.Inst_DSP_bot_ConfigMem.Inst_frame9_bit7.Q VPWR _2427_ VGND
+ Tile_X0Y1_DSP_bot.Inst_DSP_bot_ConfigMem.Inst_frame9_bit6.Q _2426_ sg13g2_o21ai_1
X_3968_ _2259_ _2256_ Tile_X0Y0_DSP_top.Inst_DSP_top_ConfigMem.Inst_frame10_bit1.Q
+ Tile_X0Y0_DSP_top.Inst_DSP_top_switch_matrix.E6BEG1 VPWR VGND sg13g2_mux2_1
X_2919_ Tile_X0Y1_E2MID[6] Tile_X0Y0_DSP_top.Inst_DSP_top_switch_matrix.JS2BEG6 Tile_X0Y1_DSP_bot.Inst_DSP_bot_ConfigMem.Inst_frame7_bit8.Q
+ _1297_ VPWR VGND sg13g2_mux2_1
X_5707_ Tile_X0Y1_FrameData[16] Tile_X0Y1_FrameStrobe[1] Tile_X0Y1_DSP_bot.Inst_DSP_bot_ConfigMem.Inst_frame1_bit16.Q
+ VPWR VGND sg13g2_dlhq_1
XFILLER_88_17 VPWR VGND sg13g2_fill_2
X_5569_ Tile_X0Y0_FrameData[12] Tile_X0Y1_FrameStrobe[11] Tile_X0Y0_DSP_top.Inst_DSP_top_ConfigMem.Inst_frame11_bit12.Q
+ VPWR VGND sg13g2_dlhq_1
X_3899_ Tile_X0Y0_DSP_top.Inst_DSP_top_ConfigMem.Inst_frame9_bit4.Q Tile_X0Y0_DSP_top.Inst_DSP_top_switch_matrix.bot2top0
+ _0433_ Tile_X0Y0_DSP_top.Inst_DSP_top_switch_matrix.JS2BEG2 _0357_ Tile_X0Y0_DSP_top.Inst_DSP_top_ConfigMem.Inst_frame9_bit5.Q
+ Tile_X0Y0_DSP_top.Inst_DSP_top_switch_matrix.W1BEG3 VPWR VGND sg13g2_mux4_1
X_5638_ _2510_ VGND VPWR Tile_X0Y0_DSP_top.Inst_DSP_top_switch_matrix.inst_cus_mux41_buf_top2bot6.X
+ Tile_X0Y1_DSP_bot.Inst_MULADD.B_reg\[6\] clknet_3_4_0_Tile_X0Y1_UserCLK_regs sg13g2_dfrbpq_1
XFILLER_41_253 VPWR VGND sg13g2_fill_1
X_3822_ Tile_X0Y0_DSP_top.Inst_DSP_top_ConfigMem.Inst_frame2_bit22.Q VPWR _2144_ VGND
+ Tile_X0Y0_DSP_top.Inst_DSP_top_ConfigMem.Inst_frame2_bit21.Q _2143_ sg13g2_o21ai_1
X_4871_ VGND VPWR Tile_X0Y0_DSP_top.Inst_DSP_top_ConfigMem.Inst_frame0_bit4.Q _0150_
+ _0612_ _0611_ sg13g2_a21oi_1
X_4940_ VPWR Tile_X0Y0_DSP_top.Inst_DSP_top_switch_matrix.N2BEGb4 _0678_ VGND sg13g2_inv_1
X_3753_ VPWR VGND _2082_ Tile_X0Y0_DSP_top.Inst_DSP_top_ConfigMem.Inst_frame1_bit31.Q
+ _2079_ _2074_ _2083_ _2077_ sg13g2_a221oi_1
X_5354_ Tile_X0Y0_FrameData[3] Tile_X0Y1_FrameStrobe[4] Tile_X0Y0_DSP_top.Inst_DSP_top_ConfigMem.Inst_frame4_bit3.Q
+ VPWR VGND sg13g2_dlhq_1
X_5423_ Tile_X0Y0_FrameData[30] Tile_X0Y1_FrameStrobe[7] Tile_X0Y0_DSP_top.Inst_DSP_top_ConfigMem.Inst_frame7_bit30.Q
+ VPWR VGND sg13g2_dlhq_1
X_3684_ _2019_ Tile_X0Y1_DSP_bot.Inst_DSP_bot_ConfigMem.Inst_frame12_bit2.Q Tile_X0Y1_DSP_bot.Inst_MULADD.C_reg\[16\]
+ VPWR VGND sg13g2_nand2b_1
X_6472_ Tile_X0Y1_W2END[3] Tile_X0Y1_W2BEG[3] VPWR VGND sg13g2_buf_1
X_2635_ VGND VPWR Tile_X0Y1_DSP_bot.Inst_DSP_bot_ConfigMem.Inst_frame3_bit12.Q _0128_
+ _1023_ _1022_ sg13g2_a21oi_1
X_2704_ VPWR VGND _1088_ Tile_X0Y1_DSP_bot.Inst_DSP_bot_ConfigMem.Inst_frame2_bit10.Q
+ _1087_ Tile_X0Y1_DSP_bot.Inst_DSP_bot_ConfigMem.Inst_frame2_bit9.Q _1089_ _1086_
+ sg13g2_a221oi_1
X_4305_ VPWR _0068_ Tile_X0Y0_DSP_top.Inst_DSP_top_ConfigMem.Inst_frame2_bit26.Q VGND
+ sg13g2_inv_1
X_5285_ Tile_X0Y0_FrameData[8] Tile_X0Y1_FrameStrobe[2] Tile_X0Y0_DSP_top.Inst_DSP_top_ConfigMem.Inst_frame2_bit8.Q
+ VPWR VGND sg13g2_dlhq_1
X_2566_ _0956_ VPWR Tile_X0Y0_DSP_top.Inst_DSP_top_switch_matrix.JN2BEG3 VGND _0945_
+ _0951_ sg13g2_o21ai_1
X_4236_ _2469_ VPWR Tile_X0Y1_DSP_bot.Inst_DSP_bot_switch_matrix.clr VGND Tile_X0Y1_DSP_bot.Inst_DSP_bot_ConfigMem.Inst_frame8_bit31.Q
+ _2473_ sg13g2_o21ai_1
X_4167_ _2414_ _2413_ Tile_X0Y1_DSP_bot.Inst_DSP_bot_ConfigMem.Inst_frame10_bit16.Q
+ Tile_X0Y1_DSP_bot.Inst_DSP_bot_switch_matrix.SS4BEG0 VPWR VGND sg13g2_mux2_1
XFILLER_82_186 VPWR VGND sg13g2_fill_1
XFILLER_74_19 VPWR VGND sg13g2_fill_1
X_3118_ _1494_ _1487_ _1493_ VPWR VGND sg13g2_nand2_1
X_3049_ VGND VPWR _1424_ _1425_ _1426_ _1390_ sg13g2_a21oi_1
X_4098_ _2359_ VPWR _2360_ VGND Tile_X0Y1_DSP_bot.Inst_DSP_bot_ConfigMem.Inst_frame2_bit1.Q
+ _2358_ sg13g2_o21ai_1
XFILLER_109_336 VPWR VGND sg13g2_fill_1
XFILLER_64_74 VPWR VGND sg13g2_fill_1
XFILLER_96_256 VPWR VGND sg13g2_fill_2
XFILLER_96_201 VPWR VGND sg13g2_fill_2
X_4021_ _2305_ VPWR _2306_ VGND Tile_X0Y0_DSP_top.Inst_DSP_top_ConfigMem.Inst_frame9_bit12.Q
+ _0388_ sg13g2_o21ai_1
X_5070_ Tile_X0Y0_DSP_top.Inst_DSP_top_ConfigMem.Inst_frame0_bit14.Q Tile_X0Y1_N4END[4]
+ _0802_ VPWR VGND sg13g2_nor2b_1
XFILLER_96_289 VPWR VGND sg13g2_fill_1
X_4923_ VGND VPWR _0036_ Tile_X0Y0_DSP_top.Inst_DSP_top_ConfigMem.Inst_frame3_bit0.Q
+ _0663_ _0662_ sg13g2_a21oi_1
XFILLER_52_359 VPWR VGND sg13g2_fill_2
XFILLER_49_183 VPWR VGND sg13g2_fill_1
X_5972_ Tile_X0Y1_FrameData[7] Tile_X0Y1_FrameStrobe[9] Tile_X0Y1_DSP_bot.Inst_DSP_bot_ConfigMem.Inst_frame9_bit7.Q
+ VPWR VGND sg13g2_dlhq_1
X_4785_ Tile_X0Y0_DSP_top.Inst_DSP_top_ConfigMem.Inst_frame8_bit3.Q _0529_ _0530_
+ VPWR VGND sg13g2_nor2_1
X_3736_ VGND VPWR Tile_X0Y1_DSP_bot.Inst_DSP_bot_ConfigMem.Inst_frame12_bit2.Q Tile_X0Y1_DSP_bot.Inst_MULADD.C_reg\[18\]
+ _2066_ Tile_X0Y1_DSP_bot.Inst_DSP_bot_ConfigMem.Inst_frame12_bit3.Q sg13g2_a21oi_1
X_3805_ _2131_ VPWR Tile_X0Y0_DSP_top.Inst_DSP_top_switch_matrix.bot2top9 VGND Tile_X0Y1_DSP_bot.Inst_DSP_bot_ConfigMem.Inst_frame12_bit5.Q
+ _2130_ sg13g2_o21ai_1
X_4854_ _0591_ _0596_ _0597_ VPWR VGND Tile_X0Y0_DSP_top.Inst_DSP_top_ConfigMem.Inst_frame1_bit7.Q
+ sg13g2_nand3b_1
XFILLER_20_212 VPWR VGND sg13g2_fill_1
X_5337_ Tile_X0Y0_FrameData[20] Tile_X0Y1_FrameStrobe[4] Tile_X0Y0_DSP_top.Inst_DSP_top_ConfigMem.Inst_frame4_bit20.Q
+ VPWR VGND sg13g2_dlhq_1
X_6455_ Tile_X0Y0_SS4END[14] Tile_X0Y1_SS4BEG[6] VPWR VGND sg13g2_buf_1
X_5406_ Tile_X0Y0_FrameData[15] Tile_X0Y1_FrameStrobe[6] Tile_X0Y0_DSP_top.Inst_DSP_top_ConfigMem.Inst_frame6_bit15.Q
+ VPWR VGND sg13g2_dlhq_1
X_2618_ _0816_ _0992_ _1006_ VPWR VGND sg13g2_nor2_1
X_3667_ VGND VPWR Tile_X0Y0_DSP_top.Inst_DSP_top_ConfigMem.Inst_frame0_bit28.Q _0859_
+ _2003_ _2002_ sg13g2_a21oi_1
X_2549_ VGND VPWR _0314_ _0444_ _0940_ Tile_X0Y0_DSP_top.Inst_DSP_top_ConfigMem.Inst_frame7_bit0.Q
+ sg13g2_a21oi_1
X_6386_ Tile_X0Y1_FrameData[5] Tile_X0Y1_FrameData_O[5] VPWR VGND sg13g2_buf_1
X_3598_ _1947_ VPWR Tile_X0Y1_DSP_bot.Inst_DSP_bot_switch_matrix.Q0 VGND Tile_X0Y1_DSP_bot.Inst_DSP_bot_ConfigMem.Inst_frame12_bit5.Q
+ _1946_ sg13g2_o21ai_1
X_5268_ Tile_X0Y0_FrameData[25] Tile_X0Y1_FrameStrobe[2] Tile_X0Y0_DSP_top.Inst_DSP_top_ConfigMem.Inst_frame2_bit25.Q
+ VPWR VGND sg13g2_dlhq_1
X_5199_ Tile_X0Y0_FrameData[30] Tile_X0Y1_FrameStrobe[0] Tile_X0Y0_DSP_top.Inst_DSP_top_ConfigMem.Inst_frame0_bit30.Q
+ VPWR VGND sg13g2_dlhq_1
X_4219_ Tile_X0Y1_DSP_bot.Inst_DSP_bot_ConfigMem.Inst_frame9_bit18.Q Tile_X0Y1_E1END[2]
+ Tile_X0Y1_W1END[2] Tile_X0Y1_DSP_bot.Inst_DSP_bot_switch_matrix.Q0 Tile_X0Y1_DSP_bot.Inst_DSP_bot_switch_matrix.Q1
+ Tile_X0Y1_DSP_bot.Inst_DSP_bot_ConfigMem.Inst_frame9_bit19.Q _2458_ VPWR VGND sg13g2_mux4_1
XFILLER_18_89 VPWR VGND sg13g2_decap_4
XFILLER_11_234 VPWR VGND sg13g2_fill_2
XFILLER_34_359 VPWR VGND sg13g2_fill_2
XFILLER_19_312 VPWR VGND sg13g2_fill_2
X_4570_ Tile_X0Y0_DSP_top.Inst_DSP_top_ConfigMem.Inst_frame3_bit11.Q VPWR _0325_ VGND
+ _0323_ _0324_ sg13g2_o21ai_1
XFILLER_61_156 VPWR VGND sg13g2_fill_1
X_6240_ Tile_X0Y0_DSP_top.Inst_DSP_top_switch_matrix.JN2BEG4 Tile_X0Y0_N2BEG[4] VPWR
+ VGND sg13g2_buf_1
X_6171_ Tile_X0Y0_EE4END[11] Tile_X0Y0_EE4BEG[7] VPWR VGND sg13g2_buf_1
X_3383_ VPWR _1745_ _1744_ VGND sg13g2_inv_1
X_3452_ _1809_ _1808_ _1807_ VPWR VGND sg13g2_nand2b_1
X_3521_ _1872_ _1874_ _1875_ VPWR VGND sg13g2_nor2_1
X_5122_ VPWR VGND Tile_X0Y0_DSP_top.Inst_DSP_top_ConfigMem.Inst_frame2_bit17.Q Tile_X0Y0_DSP_top.Inst_DSP_top_ConfigMem.Inst_frame2_bit18.Q
+ _0851_ _0848_ _0852_ _0849_ sg13g2_a221oi_1
X_4004_ Tile_X0Y0_DSP_top.Inst_DSP_top_ConfigMem.Inst_frame9_bit9.Q _0293_ _2290_
+ VPWR VGND sg13g2_nor2_1
XFILLER_69_289 VPWR VGND sg13g2_fill_1
X_5053_ Tile_X0Y1_DSP_bot.Inst_MULADD.A_reg\[3\] Tile_X0Y1_DSP_bot.A3 _0073_ _0786_
+ VPWR VGND sg13g2_mux2_1
XFILLER_27_0 VPWR VGND sg13g2_fill_2
X_4906_ Tile_X0Y0_DSP_top.Inst_DSP_top_ConfigMem.Inst_frame3_bit0.Q Tile_X0Y0_DSP_top.Inst_DSP_top_switch_matrix.bot2top1
+ Tile_X0Y0_DSP_top.Inst_DSP_top_switch_matrix.bot2top2 Tile_X0Y0_DSP_top.Inst_DSP_top_switch_matrix.bot2top3
+ Tile_X0Y0_DSP_top.Inst_DSP_top_switch_matrix.bot2top4 Tile_X0Y0_DSP_top.Inst_DSP_top_ConfigMem.Inst_frame3_bit1.Q
+ _0646_ VPWR VGND sg13g2_mux4_1
X_5955_ Tile_X0Y1_FrameData[24] Tile_X0Y1_FrameStrobe[9] Tile_X0Y1_DSP_bot.Inst_DSP_bot_ConfigMem.Inst_frame9_bit24.Q
+ VPWR VGND sg13g2_dlhq_1
X_5886_ Tile_X0Y1_FrameData[29] Tile_X0Y1_FrameStrobe[7] Tile_X0Y1_DSP_bot.Inst_DSP_bot_ConfigMem.Inst_frame7_bit29.Q
+ VPWR VGND sg13g2_dlhq_1
X_4768_ Tile_X0Y0_DSP_top.Inst_DSP_top_ConfigMem.Inst_frame0_bit8.Q Tile_X0Y0_E2END[3]
+ _0513_ VPWR VGND sg13g2_nor2b_1
X_4699_ Tile_X0Y0_DSP_top.Inst_DSP_top_ConfigMem.Inst_frame3_bit13.Q VPWR _0448_ VGND
+ Tile_X0Y0_DSP_top.Inst_DSP_top_ConfigMem.Inst_frame3_bit12.Q _0129_ sg13g2_o21ai_1
X_3719_ _2051_ _2049_ _2050_ _0110_ Tile_X0Y1_DSP_bot.Inst_DSP_bot_ConfigMem.Inst_frame12_bit3.Q
+ VPWR VGND sg13g2_a22oi_1
X_4837_ Tile_X0Y0_DSP_top.Inst_DSP_top_ConfigMem.Inst_frame1_bit6.Q _0579_ _0580_
+ VPWR VGND sg13g2_nor2_1
X_6507_ Tile_X0Y1_WW4END[14] Tile_X0Y1_WW4BEG[10] VPWR VGND sg13g2_buf_1
X_6438_ Tile_X0Y0_S4END[13] Tile_X0Y1_S4BEG[5] VPWR VGND sg13g2_buf_1
XFILLER_96_17 VPWR VGND sg13g2_fill_1
XFILLER_20_35 VPWR VGND sg13g2_fill_1
X_6369_ Tile_X0Y1_EE4END[8] Tile_X0Y1_EE4BEG[4] VPWR VGND sg13g2_buf_1
XFILLER_28_186 VPWR VGND sg13g2_fill_1
XFILLER_16_359 VPWR VGND sg13g2_fill_2
XANTENNA_8 VPWR VGND Tile_X0Y0_EE4END[11] sg13g2_antennanp
X_2952_ _1329_ _1275_ _1327_ VPWR VGND sg13g2_xnor2_1
X_5740_ Tile_X0Y1_FrameData[15] Tile_X0Y1_FrameStrobe[2] Tile_X0Y1_DSP_bot.Inst_DSP_bot_ConfigMem.Inst_frame2_bit15.Q
+ VPWR VGND sg13g2_dlhq_1
X_4553_ _0307_ VPWR _0308_ VGND Tile_X0Y1_DSP_bot.Inst_DSP_bot_ConfigMem.Inst_frame4_bit24.Q
+ Tile_X0Y1_DSP_bot.Inst_DSP_bot_switch_matrix.Q4 sg13g2_o21ai_1
X_2883_ _0608_ _1260_ _1261_ VPWR VGND sg13g2_nor2_1
X_5671_ Tile_X0Y1_FrameData[20] Tile_X0Y1_FrameStrobe[0] Tile_X0Y1_DSP_bot.Inst_DSP_bot_ConfigMem.Inst_frame0_bit20.Q
+ VPWR VGND sg13g2_dlhq_1
X_4622_ Tile_X0Y1_E6END[0] Tile_X0Y1_DSP_bot.Inst_DSP_bot_ConfigMem.Inst_frame4_bit12.Q
+ _0375_ VPWR VGND sg13g2_nor2_1
X_4484_ _0243_ Tile_X0Y0_S1END[1] Tile_X0Y0_DSP_top.Inst_DSP_top_ConfigMem.Inst_frame4_bit16.Q
+ VPWR VGND sg13g2_nand2b_1
XFILLER_103_106 VPWR VGND sg13g2_fill_1
X_6154_ Tile_X0Y0_E6END[4] Tile_X0Y0_E6BEG[2] VPWR VGND sg13g2_buf_1
X_6223_ Tile_X0Y1_FrameStrobe[11] Tile_X0Y0_FrameStrobe_O[11] VPWR VGND sg13g2_buf_1
X_3366_ Tile_X0Y1_DSP_bot.Inst_DSP_bot_ConfigMem.Inst_frame1_bit26.Q _1728_ _1729_
+ VPWR VGND sg13g2_nor2_1
X_3504_ _1859_ VPWR Tile_X0Y1_DSP_bot.C3 VGND _1845_ _1846_ sg13g2_o21ai_1
X_3435_ Tile_X0Y1_DSP_bot.Inst_DSP_bot_ConfigMem.Inst_frame6_bit26.Q Tile_X0Y1_N2MID[3]
+ Tile_X0Y1_E2MID[3] Tile_X0Y0_DSP_top.Inst_DSP_top_switch_matrix.JS2BEG3 Tile_X0Y1_W2MID[3]
+ Tile_X0Y1_DSP_bot.Inst_DSP_bot_ConfigMem.Inst_frame6_bit27.Q _1793_ VPWR VGND sg13g2_mux4_1
X_5105_ _0043_ Tile_X0Y0_DSP_top.Inst_DSP_top_ConfigMem.Inst_frame0_bit12.Q _0835_
+ VPWR VGND sg13g2_nor2_1
X_6085_ VPWR VGND _2483_ sg13g2_tiehi
X_3297_ _1663_ Tile_X0Y1_DSP_bot.Inst_DSP_bot_ConfigMem.Inst_frame2_bit30.Q _1664_
+ VPWR VGND sg13g2_nor2b_1
X_5036_ Tile_X0Y1_DSP_bot.Inst_DSP_bot_ConfigMem.Inst_frame1_bit4.Q Tile_X0Y1_W2END[2]
+ _0771_ VPWR VGND sg13g2_nor2b_1
X_5869_ Tile_X0Y1_FrameData[14] Tile_X0Y1_FrameStrobe[6] Tile_X0Y1_DSP_bot.Inst_DSP_bot_ConfigMem.Inst_frame6_bit14.Q
+ VPWR VGND sg13g2_dlhq_1
X_5938_ Tile_X0Y1_FrameData[9] Tile_X0Y1_FrameStrobe[8] Tile_X0Y1_DSP_bot.Inst_DSP_bot_ConfigMem.Inst_frame8_bit9.Q
+ VPWR VGND sg13g2_dlhq_1
XFILLER_48_248 VPWR VGND sg13g2_decap_8
XFILLER_56_86 VPWR VGND sg13g2_fill_1
XFILLER_98_104 VPWR VGND sg13g2_decap_4
X_3220_ Tile_X0Y1_DSP_bot.Inst_DSP_bot_ConfigMem.Inst_frame3_bit20.Q _0467_ _0422_
+ Tile_X0Y0_S2MID[6] Tile_X0Y1_W1END[2] Tile_X0Y1_DSP_bot.Inst_DSP_bot_ConfigMem.Inst_frame3_bit21.Q
+ _1590_ VPWR VGND sg13g2_mux4_1
X_3151_ _1524_ VPWR _1525_ VGND _0032_ Tile_X0Y0_DSP_top.Inst_DSP_top_ConfigMem.Inst_frame3_bit20.Q
+ sg13g2_o21ai_1
X_3082_ _1456_ _1457_ _0496_ _1459_ VPWR VGND sg13g2_nand3_1
XFILLER_39_226 VPWR VGND sg13g2_decap_4
XFILLER_94_0 VPWR VGND sg13g2_fill_2
X_3984_ VGND VPWR _0021_ Tile_X0Y0_DSP_top.Inst_DSP_top_ConfigMem.Inst_frame10_bit24.Q
+ _2273_ Tile_X0Y0_DSP_top.Inst_DSP_top_ConfigMem.Inst_frame10_bit25.Q sg13g2_a21oi_1
X_2935_ _1312_ _1283_ _1311_ VPWR VGND sg13g2_xnor2_1
X_5723_ Tile_X0Y1_FrameData[0] Tile_X0Y1_FrameStrobe[1] Tile_X0Y1_DSP_bot.Inst_DSP_bot_ConfigMem.Inst_frame1_bit0.Q
+ VPWR VGND sg13g2_dlhq_1
XFILLER_22_126 VPWR VGND sg13g2_fill_1
X_5585_ Tile_X0Y0_FrameData[28] Tile_X0Y1_FrameStrobe[12] Tile_X0Y0_DSP_top.Inst_DSP_top_ConfigMem.Inst_frame12_bit28.Q
+ VPWR VGND sg13g2_dlhq_1
X_5654_ _2526_ VGND VPWR Tile_X0Y0_DSP_top.Inst_DSP_top_switch_matrix.inst_cus_mux41_buf_top2bot12.X
+ Tile_X0Y1_DSP_bot.Inst_MULADD.C_reg\[14\] clknet_3_7_0_Tile_X0Y1_UserCLK_regs sg13g2_dfrbpq_1
X_4605_ Tile_X0Y1_DSP_bot.Inst_DSP_bot_ConfigMem.Inst_frame4_bit20.Q Tile_X0Y1_DSP_bot.Inst_DSP_bot_switch_matrix.Q0
+ Tile_X0Y1_DSP_bot.Inst_DSP_bot_switch_matrix.Q1 Tile_X0Y1_DSP_bot.Inst_DSP_bot_switch_matrix.Q2
+ Tile_X0Y1_DSP_bot.Inst_DSP_bot_switch_matrix.Q3 Tile_X0Y1_DSP_bot.Inst_DSP_bot_ConfigMem.Inst_frame4_bit21.Q
+ _0358_ VPWR VGND sg13g2_mux4_1
X_2866_ Tile_X0Y1_DSP_bot.Inst_DSP_bot_ConfigMem.Inst_frame3_bit16.Q Tile_X0Y1_N1END[1]
+ Tile_X0Y1_N2END[5] Tile_X0Y1_E1END[1] Tile_X0Y1_E2END[5] Tile_X0Y1_DSP_bot.Inst_DSP_bot_ConfigMem.Inst_frame3_bit17.Q
+ _1246_ VPWR VGND sg13g2_mux4_1
X_2797_ _1178_ Tile_X0Y1_DSP_bot.Inst_DSP_bot_ConfigMem.Inst_frame6_bit0.Q Tile_X0Y1_E2MID[7]
+ VPWR VGND sg13g2_nand2b_1
X_4536_ _0291_ VPWR _0292_ VGND Tile_X0Y1_DSP_bot.Inst_DSP_bot_ConfigMem.Inst_frame12_bit12.Q
+ _0125_ sg13g2_o21ai_1
X_6206_ Tile_X0Y0_FrameData[26] Tile_X0Y0_FrameData_O[26] VPWR VGND sg13g2_buf_1
X_6137_ Tile_X0Y0_DSP_top.Inst_DSP_top_switch_matrix.E2BEG1 Tile_X0Y0_E2BEG[1] VPWR
+ VGND sg13g2_buf_1
X_3349_ VPWR Tile_X0Y1_DSP_bot.Inst_DSP_bot_switch_matrix.E2BEG6 _1712_ VGND sg13g2_inv_1
X_3418_ _1776_ Tile_X0Y1_DSP_bot.Inst_MULADD.ACC\[7\] Tile_X0Y1_DSP_bot.Inst_DSP_bot_ConfigMem.Inst_frame12_bit3.Q
+ _1777_ VPWR VGND sg13g2_mux2_1
X_4398_ _0131_ Tile_X0Y1_DSP_bot.Inst_DSP_bot_ConfigMem.Inst_frame3_bit8.Q _0159_
+ _0160_ VPWR VGND sg13g2_a21o_1
X_4467_ _0226_ _0225_ Tile_X0Y1_DSP_bot.Inst_DSP_bot_ConfigMem.Inst_frame1_bit2.Q
+ VPWR VGND sg13g2_nand2b_1
XFILLER_45_229 VPWR VGND sg13g2_fill_2
X_6068_ Tile_X0Y1_FrameData[7] Tile_X0Y1_FrameStrobe[12] Tile_X0Y1_DSP_bot.Inst_DSP_bot_ConfigMem.Inst_frame12_bit7.Q
+ VPWR VGND sg13g2_dlhq_1
X_5019_ _0754_ Tile_X0Y1_DSP_bot.Inst_DSP_bot_ConfigMem.Inst_frame6_bit6.Q Tile_X0Y1_E2MID[1]
+ VPWR VGND sg13g2_nand2b_1
XFILLER_13_126 VPWR VGND sg13g2_fill_2
XFILLER_3_49 VPWR VGND sg13g2_fill_1
X_5370_ Tile_X0Y0_FrameData[19] Tile_X0Y1_FrameStrobe[5] Tile_X0Y0_DSP_top.Inst_DSP_top_ConfigMem.Inst_frame5_bit19.Q
+ VPWR VGND sg13g2_dlhq_1
X_2582_ _0971_ _0939_ _0970_ VPWR VGND sg13g2_nand2_1
X_2720_ Tile_X0Y1_DSP_bot.Inst_DSP_bot_ConfigMem.Inst_frame2_bit16.Q Tile_X0Y1_DSP_bot.Inst_DSP_bot_switch_matrix.Q0
+ Tile_X0Y1_DSP_bot.Inst_DSP_bot_switch_matrix.Q1 Tile_X0Y1_DSP_bot.Inst_DSP_bot_switch_matrix.Q2
+ Tile_X0Y1_DSP_bot.Inst_DSP_bot_switch_matrix.Q3 Tile_X0Y1_DSP_bot.Inst_DSP_bot_ConfigMem.Inst_frame2_bit17.Q
+ _1104_ VPWR VGND sg13g2_mux4_1
XFILLER_12_181 VPWR VGND sg13g2_fill_1
X_2651_ _1039_ Tile_X0Y1_DSP_bot.Inst_DSP_bot_ConfigMem.Inst_frame3_bit12.Q Tile_X0Y1_E2END[4]
+ VPWR VGND sg13g2_nand2b_1
X_3203_ Tile_X0Y0_DSP_top.Inst_DSP_top_ConfigMem.Inst_frame4_bit22.Q VPWR _1575_ VGND
+ Tile_X0Y0_DSP_top.Inst_DSP_top_ConfigMem.Inst_frame4_bit21.Q _1574_ sg13g2_o21ai_1
X_4252_ Tile_X0Y1_DSP_bot.Inst_DSP_bot_switch_matrix.clr _1998_ _0015_ VPWR VGND sg13g2_nor2_1
X_4321_ VPWR _0084_ Tile_X0Y1_DSP_bot.Inst_DSP_bot_ConfigMem.Inst_frame2_bit19.Q VGND
+ sg13g2_inv_1
X_4183_ _2425_ VPWR _2426_ VGND Tile_X0Y1_DSP_bot.Inst_DSP_bot_ConfigMem.Inst_frame9_bit5.Q
+ Tile_X0Y1_DSP_bot.Inst_DSP_bot_switch_matrix.Q7 sg13g2_o21ai_1
XFILLER_94_140 VPWR VGND sg13g2_decap_4
X_3134_ _1509_ Tile_X0Y1_DSP_bot.Inst_MULADD.ACC\[12\] Tile_X0Y1_DSP_bot.Inst_DSP_bot_ConfigMem.Inst_frame12_bit3.Q
+ VPWR VGND sg13g2_nand2_1
X_3065_ _1442_ _1441_ _1440_ VPWR VGND sg13g2_nand2b_1
X_3967_ _2257_ _2258_ Tile_X0Y0_DSP_top.Inst_DSP_top_ConfigMem.Inst_frame10_bit0.Q
+ _2259_ VPWR VGND sg13g2_mux2_1
Xclkbuf_3_6_0_Tile_X0Y1_UserCLK_regs clknet_0_Tile_X0Y1_UserCLK_regs clknet_3_6_0_Tile_X0Y1_UserCLK_regs
+ VPWR VGND sg13g2_buf_8
X_3898_ Tile_X0Y0_DSP_top.Inst_DSP_top_ConfigMem.Inst_frame9_bit3.Q Tile_X0Y0_DSP_top.Inst_DSP_top_switch_matrix.bot2top7
+ Tile_X0Y0_DSP_top.Inst_DSP_top_switch_matrix.JS2BEG1 _0387_ _0407_ Tile_X0Y0_DSP_top.Inst_DSP_top_ConfigMem.Inst_frame9_bit2.Q
+ Tile_X0Y0_DSP_top.Inst_DSP_top_switch_matrix.W1BEG2 VPWR VGND sg13g2_mux4_1
X_2918_ VPWR _1296_ _1295_ VGND sg13g2_inv_1
X_5706_ Tile_X0Y1_FrameData[17] Tile_X0Y1_FrameStrobe[1] Tile_X0Y1_DSP_bot.Inst_DSP_bot_ConfigMem.Inst_frame1_bit17.Q
+ VPWR VGND sg13g2_dlhq_1
XFILLER_104_245 VPWR VGND sg13g2_fill_1
X_5499_ Tile_X0Y0_FrameData[18] Tile_X0Y1_FrameStrobe[9] Tile_X0Y0_DSP_top.Inst_DSP_top_ConfigMem.Inst_frame9_bit18.Q
+ VPWR VGND sg13g2_dlhq_1
X_5568_ Tile_X0Y0_FrameData[13] Tile_X0Y1_FrameStrobe[11] Tile_X0Y0_DSP_top.Inst_DSP_top_ConfigMem.Inst_frame11_bit13.Q
+ VPWR VGND sg13g2_dlhq_1
X_5637_ _2509_ VGND VPWR Tile_X0Y0_DSP_top.Inst_DSP_top_switch_matrix.inst_cus_mux41_buf_top2bot5.X
+ Tile_X0Y1_DSP_bot.Inst_MULADD.B_reg\[5\] clknet_3_5_0_Tile_X0Y1_UserCLK_regs sg13g2_dfrbpq_1
X_2849_ _1228_ _1227_ _1229_ VPWR VGND sg13g2_nor2b_1
X_4519_ Tile_X0Y1_DSP_bot.Inst_DSP_bot_ConfigMem.Inst_frame1_bit8.Q Tile_X0Y1_DSP_bot.Inst_DSP_bot_switch_matrix.Q5
+ Tile_X0Y1_DSP_bot.Inst_DSP_bot_switch_matrix.Q6 Tile_X0Y1_DSP_bot.Inst_DSP_bot_switch_matrix.Q7
+ Tile_X0Y1_DSP_bot.Inst_DSP_bot_switch_matrix.Q9 Tile_X0Y1_DSP_bot.Inst_DSP_bot_ConfigMem.Inst_frame1_bit9.Q
+ _0276_ VPWR VGND sg13g2_mux4_1
XFILLER_104_289 VPWR VGND sg13g2_fill_1
XFILLER_78_40 VPWR VGND sg13g2_fill_2
XFILLER_49_332 VPWR VGND sg13g2_fill_2
XFILLER_91_165 VPWR VGND sg13g2_fill_2
XFILLER_76_195 VPWR VGND sg13g2_fill_1
XFILLER_49_354 VPWR VGND sg13g2_fill_1
X_3821_ Tile_X0Y0_DSP_top.Inst_DSP_top_switch_matrix.bot2top4 Tile_X0Y0_DSP_top.Inst_DSP_top_switch_matrix.bot2top6
+ Tile_X0Y0_DSP_top.Inst_DSP_top_ConfigMem.Inst_frame2_bit20.Q _2143_ VPWR VGND sg13g2_mux2_1
X_3752_ VGND VPWR Tile_X0Y0_DSP_top.Inst_DSP_top_ConfigMem.Inst_frame1_bit29.Q _2081_
+ _2082_ _0118_ sg13g2_a21oi_1
X_4870_ Tile_X0Y0_DSP_top.Inst_DSP_top_ConfigMem.Inst_frame0_bit5.Q VPWR _0611_ VGND
+ Tile_X0Y0_W6END[1] Tile_X0Y0_DSP_top.Inst_DSP_top_ConfigMem.Inst_frame0_bit4.Q sg13g2_o21ai_1
XFILLER_32_276 VPWR VGND sg13g2_fill_2
X_4304_ VPWR _0067_ Tile_X0Y0_DSP_top.Inst_DSP_top_ConfigMem.Inst_frame3_bit26.Q VGND
+ sg13g2_inv_1
X_2565_ _0955_ VPWR _0956_ VGND Tile_X0Y0_DSP_top.Inst_DSP_top_ConfigMem.Inst_frame4_bit14.Q
+ _0952_ sg13g2_o21ai_1
X_5353_ Tile_X0Y0_FrameData[4] Tile_X0Y1_FrameStrobe[4] Tile_X0Y0_DSP_top.Inst_DSP_top_ConfigMem.Inst_frame4_bit4.Q
+ VPWR VGND sg13g2_dlhq_1
X_5422_ Tile_X0Y0_FrameData[31] Tile_X0Y1_FrameStrobe[7] Tile_X0Y0_DSP_top.Inst_DSP_top_ConfigMem.Inst_frame7_bit31.Q
+ VPWR VGND sg13g2_dlhq_1
X_3683_ _2018_ VPWR Tile_X0Y0_DSP_top.Inst_DSP_top_switch_matrix.inst_cus_mux41_buf_top2bot14.X
+ VGND _2007_ _2009_ sg13g2_o21ai_1
XFILLER_57_0 VPWR VGND sg13g2_fill_2
X_6471_ Tile_X0Y1_DSP_bot.Inst_DSP_bot_switch_matrix.JW2BEG2 Tile_X0Y1_W2BEG[2] VPWR
+ VGND sg13g2_buf_1
X_2634_ Tile_X0Y1_DSP_bot.Inst_DSP_bot_ConfigMem.Inst_frame3_bit12.Q Tile_X0Y1_DSP_bot.Inst_DSP_bot_switch_matrix.Q0
+ _1022_ VPWR VGND sg13g2_nor2_1
X_2703_ VGND VPWR Tile_X0Y1_DSP_bot.Inst_DSP_bot_ConfigMem.Inst_frame2_bit8.Q _0128_
+ _1088_ Tile_X0Y1_DSP_bot.Inst_DSP_bot_ConfigMem.Inst_frame2_bit9.Q sg13g2_a21oi_1
XFILLER_101_237 VPWR VGND sg13g2_fill_1
XFILLER_99_265 VPWR VGND sg13g2_fill_2
X_5284_ Tile_X0Y0_FrameData[9] Tile_X0Y1_FrameStrobe[2] Tile_X0Y0_DSP_top.Inst_DSP_top_ConfigMem.Inst_frame2_bit9.Q
+ VPWR VGND sg13g2_dlhq_1
X_3117_ Tile_X0Y0_DSP_top.Inst_DSP_top_ConfigMem.Inst_frame8_bit17.Q _1492_ _1493_
+ VPWR VGND sg13g2_nor2_1
X_4235_ VGND VPWR Tile_X0Y1_DSP_bot.Inst_DSP_bot_ConfigMem.Inst_frame8_bit30.Q _2470_
+ _2473_ _2472_ sg13g2_a21oi_1
X_4166_ Tile_X0Y1_DSP_bot.Inst_DSP_bot_ConfigMem.Inst_frame10_bit14.Q Tile_X0Y1_N1END[2]
+ Tile_X0Y1_E1END[2] Tile_X0Y1_W1END[2] Tile_X0Y1_DSP_bot.Inst_DSP_bot_switch_matrix.Q2
+ Tile_X0Y1_DSP_bot.Inst_DSP_bot_ConfigMem.Inst_frame10_bit15.Q _2414_ VPWR VGND sg13g2_mux4_1
X_3048_ _1425_ _1388_ _1389_ VPWR VGND sg13g2_xnor2_1
X_4097_ VGND VPWR Tile_X0Y1_DSP_bot.Inst_DSP_bot_ConfigMem.Inst_frame2_bit1.Q _2356_
+ _2359_ Tile_X0Y1_DSP_bot.Inst_DSP_bot_ConfigMem.Inst_frame2_bit2.Q sg13g2_a21oi_1
XFILLER_109_359 VPWR VGND sg13g2_fill_2
X_4999_ Tile_X0Y1_DSP_bot.Inst_DSP_bot_ConfigMem.Inst_frame8_bit4.Q _0734_ _0735_
+ VPWR VGND sg13g2_nor2_1
XFILLER_73_121 VPWR VGND sg13g2_fill_1
XFILLER_61_305 VPWR VGND sg13g2_fill_1
XFILLER_80_52 VPWR VGND sg13g2_fill_1
XFILLER_80_41 VPWR VGND sg13g2_fill_1
XFILLER_9_26 VPWR VGND sg13g2_fill_1
XFILLER_14_254 VPWR VGND sg13g2_fill_2
XFILLER_89_94 VPWR VGND sg13g2_fill_2
X_4020_ _2305_ Tile_X0Y0_DSP_top.Inst_DSP_top_ConfigMem.Inst_frame9_bit12.Q _0841_
+ VPWR VGND sg13g2_nand2_1
X_4922_ Tile_X0Y0_DSP_top.Inst_DSP_top_ConfigMem.Inst_frame3_bit1.Q VPWR _0662_ VGND
+ Tile_X0Y0_W2END[1] Tile_X0Y0_DSP_top.Inst_DSP_top_ConfigMem.Inst_frame3_bit0.Q sg13g2_o21ai_1
XFILLER_64_187 VPWR VGND sg13g2_decap_8
X_5971_ Tile_X0Y1_FrameData[8] Tile_X0Y1_FrameStrobe[9] Tile_X0Y1_DSP_bot.Inst_DSP_bot_ConfigMem.Inst_frame9_bit8.Q
+ VPWR VGND sg13g2_dlhq_1
X_6454_ Tile_X0Y0_SS4END[13] Tile_X0Y1_SS4BEG[5] VPWR VGND sg13g2_buf_1
X_4784_ VPWR VGND _0528_ Tile_X0Y0_DSP_top.Inst_DSP_top_ConfigMem.Inst_frame8_bit2.Q
+ _0526_ Tile_X0Y0_DSP_top.Inst_DSP_top_ConfigMem.Inst_frame7_bit9.Q _0529_ _0525_
+ sg13g2_a221oi_1
X_3804_ _2131_ Tile_X0Y1_DSP_bot.Inst_DSP_bot_ConfigMem.Inst_frame12_bit5.Q Tile_X0Y1_DSP_bot.Inst_MULADD.ACC\[19\]
+ VPWR VGND sg13g2_nand2_1
X_3735_ _2065_ _0072_ Tile_X0Y0_DSP_top.Inst_DSP_top_switch_matrix.inst_cus_mux81_buf_top2bot16.X
+ VPWR VGND sg13g2_nand2_1
X_4853_ _0593_ _0595_ Tile_X0Y0_DSP_top.Inst_DSP_top_ConfigMem.Inst_frame1_bit6.Q
+ _0596_ VPWR VGND sg13g2_nand3_1
X_5336_ Tile_X0Y0_FrameData[21] Tile_X0Y1_FrameStrobe[4] Tile_X0Y0_DSP_top.Inst_DSP_top_ConfigMem.Inst_frame4_bit21.Q
+ VPWR VGND sg13g2_dlhq_1
XFILLER_106_318 VPWR VGND sg13g2_fill_1
X_5267_ Tile_X0Y0_FrameData[26] Tile_X0Y1_FrameStrobe[2] Tile_X0Y0_DSP_top.Inst_DSP_top_ConfigMem.Inst_frame2_bit26.Q
+ VPWR VGND sg13g2_dlhq_1
X_5405_ Tile_X0Y0_FrameData[16] Tile_X0Y1_FrameStrobe[6] Tile_X0Y0_DSP_top.Inst_DSP_top_ConfigMem.Inst_frame6_bit16.Q
+ VPWR VGND sg13g2_dlhq_1
X_2548_ Tile_X0Y1_DSP_bot.Inst_MULADD.B_reg\[5\] Tile_X0Y0_DSP_top.Inst_DSP_top_switch_matrix.inst_cus_mux41_buf_top2bot5.X
+ _0074_ _0939_ VPWR VGND sg13g2_mux2_1
X_3666_ Tile_X0Y0_DSP_top.Inst_DSP_top_ConfigMem.Inst_frame0_bit29.Q VPWR _2002_ VGND
+ Tile_X0Y0_WW4END[3] Tile_X0Y0_DSP_top.Inst_DSP_top_ConfigMem.Inst_frame0_bit28.Q
+ sg13g2_o21ai_1
X_2617_ _1005_ _0682_ _0939_ VPWR VGND sg13g2_nand2_1
X_6385_ Tile_X0Y1_FrameData[4] Tile_X0Y1_FrameData_O[4] VPWR VGND sg13g2_buf_1
X_3597_ _1947_ Tile_X0Y1_DSP_bot.Inst_MULADD.ACC\[0\] Tile_X0Y1_DSP_bot.Inst_DSP_bot_ConfigMem.Inst_frame12_bit5.Q
+ VPWR VGND sg13g2_nand2_1
X_5198_ Tile_X0Y0_FrameData[31] Tile_X0Y1_FrameStrobe[0] Tile_X0Y0_DSP_top.Inst_DSP_top_ConfigMem.Inst_frame0_bit31.Q
+ VPWR VGND sg13g2_dlhq_1
XFILLER_55_176 VPWR VGND sg13g2_fill_2
X_4149_ Tile_X0Y1_DSP_bot.Inst_DSP_bot_ConfigMem.Inst_frame11_bit23.Q Tile_X0Y1_DSP_bot.Inst_DSP_bot_switch_matrix.Q2
+ Tile_X0Y1_DSP_bot.Inst_DSP_bot_switch_matrix.Q4 Tile_X0Y1_DSP_bot.Inst_DSP_bot_switch_matrix.Q3
+ Tile_X0Y1_DSP_bot.Inst_DSP_bot_switch_matrix.Q5 Tile_X0Y1_DSP_bot.Inst_DSP_bot_ConfigMem.Inst_frame11_bit22.Q
+ _2399_ VPWR VGND sg13g2_mux4_1
X_4218_ Tile_X0Y1_DSP_bot.Inst_DSP_bot_ConfigMem.Inst_frame9_bit21.Q VPWR _2457_ VGND
+ Tile_X0Y1_DSP_bot.Inst_DSP_bot_ConfigMem.Inst_frame9_bit20.Q _2456_ sg13g2_o21ai_1
XFILLER_51_360 VPWR VGND sg13g2_fill_1
XFILLER_109_156 VPWR VGND sg13g2_fill_2
XFILLER_109_101 VPWR VGND sg13g2_fill_1
XFILLER_93_227 VPWR VGND sg13g2_fill_2
XFILLER_93_205 VPWR VGND sg13g2_decap_4
XFILLER_61_124 VPWR VGND sg13g2_fill_2
XFILLER_46_176 VPWR VGND sg13g2_fill_1
X_3520_ _1874_ _1419_ _1873_ VPWR VGND sg13g2_nand2_1
X_5121_ VGND VPWR Tile_X0Y0_E2END[5] Tile_X0Y0_DSP_top.Inst_DSP_top_ConfigMem.Inst_frame2_bit16.Q
+ _0851_ _0850_ sg13g2_a21oi_1
X_6170_ Tile_X0Y0_EE4END[10] Tile_X0Y0_EE4BEG[6] VPWR VGND sg13g2_buf_1
X_3382_ Tile_X0Y1_DSP_bot.Inst_DSP_bot_ConfigMem.Inst_frame2_bit27.Q VPWR _1744_ VGND
+ Tile_X0Y1_DSP_bot.Inst_DSP_bot_ConfigMem.Inst_frame2_bit26.Q _1737_ sg13g2_o21ai_1
X_3451_ _1423_ _1422_ _1808_ VPWR VGND sg13g2_xor2_1
X_4003_ Tile_X0Y0_DSP_top.Inst_DSP_top_ConfigMem.Inst_frame9_bit7.Q _2285_ _2286_
+ _2288_ _2289_ Tile_X0Y0_DSP_top.Inst_DSP_top_ConfigMem.Inst_frame9_bit8.Q Tile_X0Y0_DSP_top.Inst_DSP_top_switch_matrix.WW4BEG0
+ VPWR VGND sg13g2_mux4_1
X_5052_ _0758_ VPWR Tile_X0Y1_DSP_bot.A3 VGND _0783_ _0785_ sg13g2_o21ai_1
X_4905_ VPWR _0645_ _0644_ VGND sg13g2_inv_1
X_4836_ Tile_X0Y0_DSP_top.Inst_DSP_top_ConfigMem.Inst_frame1_bit4.Q Tile_X0Y0_DSP_top.Inst_DSP_top_switch_matrix.bot2top0
+ Tile_X0Y0_DSP_top.Inst_DSP_top_switch_matrix.bot2top2 Tile_X0Y0_DSP_top.Inst_DSP_top_switch_matrix.bot2top3
+ Tile_X0Y0_DSP_top.Inst_DSP_top_switch_matrix.bot2top4 Tile_X0Y0_DSP_top.Inst_DSP_top_ConfigMem.Inst_frame1_bit5.Q
+ _0579_ VPWR VGND sg13g2_mux4_1
XFILLER_60_190 VPWR VGND sg13g2_fill_2
XFILLER_37_198 VPWR VGND sg13g2_fill_2
X_5954_ Tile_X0Y1_FrameData[25] Tile_X0Y1_FrameStrobe[9] Tile_X0Y1_DSP_bot.Inst_DSP_bot_ConfigMem.Inst_frame9_bit25.Q
+ VPWR VGND sg13g2_dlhq_1
X_5885_ Tile_X0Y1_FrameData[30] Tile_X0Y1_FrameStrobe[7] Tile_X0Y1_DSP_bot.Inst_DSP_bot_ConfigMem.Inst_frame7_bit30.Q
+ VPWR VGND sg13g2_dlhq_1
X_6437_ Tile_X0Y0_S4END[12] Tile_X0Y1_S4BEG[4] VPWR VGND sg13g2_buf_1
X_3649_ VGND VPWR Tile_X0Y0_SS4END[2] Tile_X0Y0_DSP_top.Inst_DSP_top_ConfigMem.Inst_frame0_bit26.Q
+ _1987_ _1986_ sg13g2_a21oi_1
X_4767_ Tile_X0Y0_WW4END[2] Tile_X0Y0_DSP_top.Inst_DSP_top_switch_matrix.JN2BEG2 Tile_X0Y0_DSP_top.Inst_DSP_top_ConfigMem.Inst_frame0_bit8.Q
+ _0512_ VPWR VGND sg13g2_mux2_1
X_4698_ Tile_X0Y0_DSP_top.Inst_DSP_top_ConfigMem.Inst_frame0_bit10.Q Tile_X0Y1_N4END[6]
+ Tile_X0Y0_E2END[2] Tile_X0Y0_W2END[7] Tile_X0Y0_DSP_top.Inst_DSP_top_switch_matrix.E2BEG2
+ Tile_X0Y0_DSP_top.Inst_DSP_top_ConfigMem.Inst_frame0_bit11.Q _0447_ VPWR VGND sg13g2_mux4_1
X_3718_ VGND VPWR Tile_X0Y1_DSP_bot.Inst_DSP_bot_ConfigMem.Inst_frame12_bit2.Q Tile_X0Y1_DSP_bot.Inst_MULADD.C_reg\[17\]
+ _2050_ Tile_X0Y1_DSP_bot.Inst_DSP_bot_ConfigMem.Inst_frame12_bit3.Q sg13g2_a21oi_1
X_6506_ Tile_X0Y1_WW4END[13] Tile_X0Y1_WW4BEG[9] VPWR VGND sg13g2_buf_1
X_5319_ Tile_X0Y0_FrameData[6] Tile_X0Y1_FrameStrobe[3] Tile_X0Y0_DSP_top.Inst_DSP_top_ConfigMem.Inst_frame3_bit6.Q
+ VPWR VGND sg13g2_dlhq_1
X_6299_ Tile_X0Y0_W2MID[2] Tile_X0Y0_W2BEGb[2] VPWR VGND sg13g2_buf_1
X_6368_ Tile_X0Y1_EE4END[7] Tile_X0Y1_EE4BEG[3] VPWR VGND sg13g2_buf_1
XFILLER_29_23 VPWR VGND sg13g2_fill_2
XFILLER_61_65 VPWR VGND sg13g2_fill_2
XANTENNA_9 VPWR VGND Tile_X0Y0_EE4END[12] sg13g2_antennanp
XFILLER_6_49 VPWR VGND sg13g2_fill_1
XFILLER_3_275 VPWR VGND sg13g2_decap_8
X_2951_ _1328_ _1275_ _1327_ VPWR VGND sg13g2_nand2_1
X_5670_ Tile_X0Y1_FrameData[21] Tile_X0Y1_FrameStrobe[0] Tile_X0Y1_DSP_bot.Inst_DSP_bot_ConfigMem.Inst_frame0_bit21.Q
+ VPWR VGND sg13g2_dlhq_1
X_4483_ VPWR VGND Tile_X0Y0_DSP_top.Inst_DSP_top_ConfigMem.Inst_frame4_bit17.Q Tile_X0Y0_DSP_top.Inst_DSP_top_ConfigMem.Inst_frame4_bit18.Q
+ _0241_ _0238_ _0242_ _0239_ sg13g2_a221oi_1
X_4552_ _0307_ Tile_X0Y1_DSP_bot.Inst_DSP_bot_ConfigMem.Inst_frame4_bit24.Q _0125_
+ VPWR VGND sg13g2_nand2_1
X_2882_ _1259_ VPWR _1260_ VGND _0074_ Tile_X0Y1_DSP_bot.Inst_MULADD.B_reg\[1\] sg13g2_o21ai_1
X_4621_ VGND VPWR _0045_ _0373_ _0374_ _0046_ sg13g2_a21oi_1
X_3503_ Tile_X0Y1_DSP_bot.Inst_DSP_bot_ConfigMem.Inst_frame8_bit13.Q _1852_ _1858_
+ _1859_ VPWR VGND sg13g2_or3_1
X_6222_ Tile_X0Y1_FrameStrobe[10] Tile_X0Y0_FrameStrobe_O[10] VPWR VGND sg13g2_buf_1
XFILLER_106_17 VPWR VGND sg13g2_fill_1
X_6153_ Tile_X0Y0_E6END[3] Tile_X0Y0_E6BEG[1] VPWR VGND sg13g2_buf_1
X_5104_ VGND VPWR _0832_ _0834_ Tile_X0Y0_DSP_top.Inst_DSP_top_switch_matrix.JS2BEG2
+ _0826_ sg13g2_a21oi_1
X_3365_ Tile_X0Y1_DSP_bot.Inst_DSP_bot_ConfigMem.Inst_frame1_bit24.Q Tile_X0Y1_DSP_bot.Inst_DSP_bot_switch_matrix.Q0
+ Tile_X0Y1_DSP_bot.Inst_DSP_bot_switch_matrix.Q1 Tile_X0Y1_DSP_bot.Inst_DSP_bot_switch_matrix.Q2
+ Tile_X0Y1_DSP_bot.Inst_DSP_bot_switch_matrix.Q3 Tile_X0Y1_DSP_bot.Inst_DSP_bot_ConfigMem.Inst_frame1_bit25.Q
+ _1728_ VPWR VGND sg13g2_mux4_1
X_3434_ Tile_X0Y1_DSP_bot.Inst_DSP_bot_ConfigMem.Inst_frame7_bit27.Q Tile_X0Y1_N2MID[2]
+ Tile_X0Y1_W2MID[2] Tile_X0Y0_DSP_top.Inst_DSP_top_switch_matrix.JS2BEG2 Tile_X0Y1_DSP_bot.Inst_DSP_bot_switch_matrix.E2BEG6
+ Tile_X0Y1_DSP_bot.Inst_DSP_bot_ConfigMem.Inst_frame7_bit26.Q _1792_ VPWR VGND sg13g2_mux4_1
X_3296_ VGND VPWR Tile_X0Y1_DSP_bot.Inst_DSP_bot_ConfigMem.Inst_frame2_bit28.Q _0131_
+ _1663_ _1662_ sg13g2_a21oi_1
X_6084_ VPWR VGND _2482_ sg13g2_tiehi
X_5035_ VGND VPWR Tile_X0Y1_DSP_bot.Inst_DSP_bot_ConfigMem.Inst_frame1_bit4.Q Tile_X0Y0_S4END[6]
+ _0770_ _0769_ sg13g2_a21oi_1
X_4819_ Tile_X0Y0_DSP_top.Inst_DSP_top_ConfigMem.Inst_frame1_bit15.Q VPWR _0562_ VGND
+ _0558_ _0561_ sg13g2_o21ai_1
X_5799_ Tile_X0Y1_FrameData[20] Tile_X0Y1_FrameStrobe[4] Tile_X0Y1_DSP_bot.Inst_DSP_bot_ConfigMem.Inst_frame4_bit20.Q
+ VPWR VGND sg13g2_dlhq_1
X_5937_ Tile_X0Y1_FrameData[10] Tile_X0Y1_FrameStrobe[8] Tile_X0Y1_DSP_bot.Inst_DSP_bot_ConfigMem.Inst_frame8_bit10.Q
+ VPWR VGND sg13g2_dlhq_1
X_5868_ Tile_X0Y1_FrameData[15] Tile_X0Y1_FrameStrobe[6] Tile_X0Y1_DSP_bot.Inst_DSP_bot_ConfigMem.Inst_frame6_bit15.Q
+ VPWR VGND sg13g2_dlhq_1
XFILLER_12_330 VPWR VGND sg13g2_fill_2
XFILLER_8_334 VPWR VGND sg13g2_fill_2
X_3150_ _1524_ Tile_X0Y0_S1END[2] Tile_X0Y0_DSP_top.Inst_DSP_top_ConfigMem.Inst_frame3_bit20.Q
+ VPWR VGND sg13g2_nand2_1
XFILLER_98_127 VPWR VGND sg13g2_fill_2
XFILLER_97_94 VPWR VGND sg13g2_fill_1
XFILLER_21_90 VPWR VGND sg13g2_fill_1
X_3081_ _1458_ _0496_ _1456_ _1457_ VPWR VGND sg13g2_and3_1
X_5653_ _2525_ VGND VPWR Tile_X0Y0_DSP_top.Inst_DSP_top_switch_matrix.inst_cus_mux41_buf_top2bot11.X
+ Tile_X0Y1_DSP_bot.Inst_MULADD.C_reg\[13\] clknet_3_5_0_Tile_X0Y1_UserCLK_regs sg13g2_dfrbpq_1
X_3983_ VPWR Tile_X0Y0_DSP_top.Inst_DSP_top_switch_matrix.SS4BEG1 _2272_ VGND sg13g2_inv_1
X_2934_ _1309_ _1284_ _1311_ VPWR VGND sg13g2_xor2_1
X_2865_ _1241_ _0087_ _1244_ _1245_ VPWR VGND sg13g2_a21o_1
X_5722_ Tile_X0Y1_FrameData[1] Tile_X0Y1_FrameStrobe[1] Tile_X0Y1_DSP_bot.Inst_DSP_bot_ConfigMem.Inst_frame1_bit1.Q
+ VPWR VGND sg13g2_dlhq_1
X_5584_ Tile_X0Y0_FrameData[29] Tile_X0Y1_FrameStrobe[12] Tile_X0Y0_DSP_top.Inst_DSP_top_ConfigMem.Inst_frame12_bit29.Q
+ VPWR VGND sg13g2_dlhq_1
X_4604_ Tile_X0Y0_DSP_top.Inst_DSP_top_ConfigMem.Inst_frame0_bit1.Q Tile_X0Y1_NN4END[7]
+ Tile_X0Y0_WW4END[0] Tile_X0Y0_S4END[3] Tile_X0Y0_DSP_top.Inst_DSP_top_switch_matrix.JN2BEG1
+ Tile_X0Y0_DSP_top.Inst_DSP_top_ConfigMem.Inst_frame0_bit0.Q _0357_ VPWR VGND sg13g2_mux4_1
X_2796_ _1176_ VPWR _1177_ VGND Tile_X0Y1_DSP_bot.Inst_DSP_bot_ConfigMem.Inst_frame6_bit0.Q
+ _0208_ sg13g2_o21ai_1
X_4466_ Tile_X0Y1_DSP_bot.Inst_DSP_bot_ConfigMem.Inst_frame1_bit0.Q Tile_X0Y1_DSP_bot.Inst_DSP_bot_switch_matrix.Q1
+ Tile_X0Y1_DSP_bot.Inst_DSP_bot_switch_matrix.Q2 Tile_X0Y1_DSP_bot.Inst_DSP_bot_switch_matrix.Q3
+ Tile_X0Y1_DSP_bot.Inst_DSP_bot_switch_matrix.Q4 Tile_X0Y1_DSP_bot.Inst_DSP_bot_ConfigMem.Inst_frame1_bit1.Q
+ _0225_ VPWR VGND sg13g2_mux4_1
X_4535_ _0291_ Tile_X0Y1_DSP_bot.Inst_DSP_bot_ConfigMem.Inst_frame12_bit12.Q _0288_
+ VPWR VGND sg13g2_nand2_1
XFILLER_30_193 VPWR VGND sg13g2_decap_8
X_6205_ Tile_X0Y0_FrameData[25] Tile_X0Y0_FrameData_O[25] VPWR VGND sg13g2_buf_1
X_6136_ Tile_X0Y0_DSP_top.Inst_DSP_top_switch_matrix.E2BEG0 Tile_X0Y0_E2BEG[0] VPWR
+ VGND sg13g2_buf_1
X_3348_ VGND VPWR _1699_ _1702_ _1712_ _1711_ sg13g2_a21oi_1
X_3279_ _1645_ VPWR _1646_ VGND Tile_X0Y1_DSP_bot.Inst_DSP_bot_ConfigMem.Inst_frame1_bit28.Q
+ _0126_ sg13g2_o21ai_1
X_4397_ Tile_X0Y1_DSP_bot.Inst_DSP_bot_ConfigMem.Inst_frame3_bit9.Q VPWR _0159_ VGND
+ Tile_X0Y1_DSP_bot.Inst_DSP_bot_ConfigMem.Inst_frame3_bit8.Q Tile_X0Y1_DSP_bot.Inst_DSP_bot_switch_matrix.Q7
+ sg13g2_o21ai_1
X_6067_ Tile_X0Y1_FrameData[8] Tile_X0Y1_FrameStrobe[12] Tile_X0Y1_DSP_bot.Inst_DSP_bot_ConfigMem.Inst_frame12_bit8.Q
+ VPWR VGND sg13g2_dlhq_1
X_3417_ Tile_X0Y1_DSP_bot.Inst_MULADD.C_reg\[7\] Tile_X0Y1_DSP_bot.C7 _0072_ _1776_
+ VPWR VGND sg13g2_mux2_1
XFILLER_38_260 VPWR VGND sg13g2_fill_1
X_5018_ _0752_ VPWR _0753_ VGND Tile_X0Y1_DSP_bot.Inst_DSP_bot_ConfigMem.Inst_frame6_bit6.Q
+ _0150_ sg13g2_o21ai_1
XFILLER_5_359 VPWR VGND sg13g2_fill_2
XFILLER_12_171 VPWR VGND sg13g2_decap_4
X_2581_ VPWR _0970_ _0969_ VGND sg13g2_inv_1
X_4320_ VPWR _0083_ Tile_X0Y1_DSP_bot.Inst_DSP_bot_ConfigMem.Inst_frame3_bit7.Q VGND
+ sg13g2_inv_1
XFILLER_8_175 VPWR VGND sg13g2_fill_2
X_2650_ _1037_ VPWR _1038_ VGND Tile_X0Y1_DSP_bot.Inst_DSP_bot_ConfigMem.Inst_frame3_bit13.Q
+ _1034_ sg13g2_o21ai_1
X_3202_ Tile_X0Y0_S1END[2] Tile_X0Y0_S2END[6] Tile_X0Y0_DSP_top.Inst_DSP_top_ConfigMem.Inst_frame4_bit20.Q
+ _1574_ VPWR VGND sg13g2_mux2_1
X_4251_ Tile_X0Y1_DSP_bot.Inst_DSP_bot_switch_matrix.clr _1942_ _0014_ VPWR VGND sg13g2_nor2_1
X_3133_ _1505_ _1507_ _1508_ VPWR VGND sg13g2_nor2_1
X_4182_ _2425_ Tile_X0Y1_DSP_bot.Inst_DSP_bot_ConfigMem.Inst_frame9_bit5.Q _0874_
+ VPWR VGND sg13g2_nand2_1
X_3064_ _1146_ VPWR _1441_ VGND _1143_ _1147_ sg13g2_o21ai_1
X_3966_ Tile_X0Y0_DSP_top.Inst_DSP_top_ConfigMem.Inst_frame11_bit30.Q Tile_X0Y0_DSP_top.Inst_DSP_top_switch_matrix.bot2top2
+ Tile_X0Y0_DSP_top.Inst_DSP_top_switch_matrix.bot2top3 Tile_X0Y0_DSP_top.Inst_DSP_top_switch_matrix.bot2top4
+ Tile_X0Y0_DSP_top.Inst_DSP_top_switch_matrix.bot2top5 Tile_X0Y0_DSP_top.Inst_DSP_top_ConfigMem.Inst_frame11_bit31.Q
+ _2258_ VPWR VGND sg13g2_mux4_1
X_3897_ Tile_X0Y0_DSP_top.Inst_DSP_top_ConfigMem.Inst_frame9_bit0.Q Tile_X0Y0_DSP_top.Inst_DSP_top_switch_matrix.bot2top6
+ _0644_ Tile_X0Y0_DSP_top.Inst_DSP_top_switch_matrix.JS2BEG0 _0668_ Tile_X0Y0_DSP_top.Inst_DSP_top_ConfigMem.Inst_frame9_bit1.Q
+ Tile_X0Y0_DSP_top.Inst_DSP_top_switch_matrix.W1BEG1 VPWR VGND sg13g2_mux4_1
X_5636_ _2508_ VGND VPWR Tile_X0Y0_DSP_top.Inst_DSP_top_switch_matrix.inst_cus_mux41_buf_top2bot4.X
+ Tile_X0Y1_DSP_bot.Inst_MULADD.B_reg\[4\] clknet_3_4_0_Tile_X0Y1_UserCLK_regs sg13g2_dfrbpq_1
X_2848_ _1202_ _1196_ _1228_ VPWR VGND sg13g2_xor2_1
XFILLER_50_288 VPWR VGND sg13g2_fill_1
X_2917_ Tile_X0Y1_DSP_bot.Inst_DSP_bot_ConfigMem.Inst_frame7_bit9.Q VPWR _1295_ VGND
+ Tile_X0Y1_W2MID[6] Tile_X0Y1_DSP_bot.Inst_DSP_bot_ConfigMem.Inst_frame7_bit8.Q sg13g2_o21ai_1
X_5705_ Tile_X0Y1_FrameData[18] Tile_X0Y1_FrameStrobe[1] Tile_X0Y1_DSP_bot.Inst_DSP_bot_ConfigMem.Inst_frame1_bit18.Q
+ VPWR VGND sg13g2_dlhq_1
X_2779_ Tile_X0Y0_DSP_top.Inst_DSP_top_ConfigMem.Inst_frame2_bit25.Q Tile_X0Y0_DSP_top.Inst_DSP_top_switch_matrix.bot2top4
+ Tile_X0Y0_DSP_top.Inst_DSP_top_switch_matrix.bot2top7 Tile_X0Y0_DSP_top.Inst_DSP_top_switch_matrix.bot2top5
+ Tile_X0Y0_DSP_top.Inst_DSP_top_switch_matrix.bot2top9 Tile_X0Y0_DSP_top.Inst_DSP_top_ConfigMem.Inst_frame2_bit24.Q
+ _1161_ VPWR VGND sg13g2_mux4_1
X_5567_ Tile_X0Y0_FrameData[14] Tile_X0Y1_FrameStrobe[11] Tile_X0Y0_DSP_top.Inst_DSP_top_ConfigMem.Inst_frame11_bit14.Q
+ VPWR VGND sg13g2_dlhq_1
XFILLER_88_19 VPWR VGND sg13g2_fill_1
X_5498_ Tile_X0Y0_FrameData[19] Tile_X0Y1_FrameStrobe[9] Tile_X0Y0_DSP_top.Inst_DSP_top_ConfigMem.Inst_frame9_bit19.Q
+ VPWR VGND sg13g2_dlhq_1
X_4518_ Tile_X0Y1_DSP_bot.Inst_DSP_bot_ConfigMem.Inst_frame1_bit8.Q Tile_X0Y1_DSP_bot.Inst_DSP_bot_switch_matrix.Q0
+ Tile_X0Y1_DSP_bot.Inst_DSP_bot_switch_matrix.Q1 Tile_X0Y1_DSP_bot.Inst_DSP_bot_switch_matrix.Q3
+ Tile_X0Y1_DSP_bot.Inst_DSP_bot_switch_matrix.Q4 Tile_X0Y1_DSP_bot.Inst_DSP_bot_ConfigMem.Inst_frame1_bit9.Q
+ _0275_ VPWR VGND sg13g2_mux4_1
X_4449_ Tile_X0Y1_DSP_bot.Inst_DSP_bot_ConfigMem.Inst_frame6_bit16.Q Tile_X0Y1_N2MID[7]
+ Tile_X0Y1_E2MID[7] Tile_X0Y0_DSP_top.Inst_DSP_top_switch_matrix.JS2BEG7 Tile_X0Y1_W2MID[7]
+ Tile_X0Y1_DSP_bot.Inst_DSP_bot_ConfigMem.Inst_frame6_bit17.Q _0209_ VPWR VGND sg13g2_mux4_1
XFILLER_85_141 VPWR VGND sg13g2_fill_1
XFILLER_58_322 VPWR VGND sg13g2_fill_2
X_6119_ VPWR VGND _2517_ sg13g2_tiehi
XFILLER_110_249 VPWR VGND sg13g2_fill_2
XFILLER_68_119 VPWR VGND sg13g2_fill_1
XFILLER_17_230 VPWR VGND sg13g2_fill_2
XFILLER_17_296 VPWR VGND sg13g2_fill_1
X_3820_ VGND VPWR Tile_X0Y0_DSP_top.Inst_DSP_top_ConfigMem.Inst_frame2_bit20.Q Tile_X0Y0_DSP_top.Inst_DSP_top_switch_matrix.bot2top8
+ _2142_ _2141_ sg13g2_a21oi_1
X_3751_ VGND VPWR Tile_X0Y0_W1END[0] Tile_X0Y0_DSP_top.Inst_DSP_top_ConfigMem.Inst_frame1_bit28.Q
+ _2081_ _2080_ sg13g2_a21oi_1
X_3682_ _2017_ VPWR _2018_ VGND _2011_ _2014_ sg13g2_o21ai_1
X_6470_ Tile_X0Y1_DSP_bot.Inst_DSP_bot_switch_matrix.JW2BEG1 Tile_X0Y1_W2BEG[1] VPWR
+ VGND sg13g2_buf_1
X_2702_ VGND VPWR _1087_ Tile_X0Y1_DSP_bot.Inst_DSP_bot_switch_matrix.Q0 Tile_X0Y1_DSP_bot.Inst_DSP_bot_ConfigMem.Inst_frame2_bit8.Q
+ sg13g2_or2_1
X_4303_ VPWR _0066_ Tile_X0Y0_DSP_top.Inst_DSP_top_ConfigMem.Inst_frame4_bit26.Q VGND
+ sg13g2_inv_1
X_5283_ Tile_X0Y0_FrameData[10] Tile_X0Y1_FrameStrobe[2] Tile_X0Y0_DSP_top.Inst_DSP_top_ConfigMem.Inst_frame2_bit10.Q
+ VPWR VGND sg13g2_dlhq_1
X_2564_ VGND VPWR Tile_X0Y0_DSP_top.Inst_DSP_top_ConfigMem.Inst_frame4_bit14.Q _0954_
+ _0955_ Tile_X0Y0_DSP_top.Inst_DSP_top_ConfigMem.Inst_frame4_bit15.Q sg13g2_a21oi_1
X_5421_ Tile_X0Y0_FrameData[0] Tile_X0Y1_FrameStrobe[6] Tile_X0Y0_DSP_top.Inst_DSP_top_ConfigMem.Inst_frame6_bit0.Q
+ VPWR VGND sg13g2_dlhq_1
X_5352_ Tile_X0Y0_FrameData[5] Tile_X0Y1_FrameStrobe[4] Tile_X0Y0_DSP_top.Inst_DSP_top_ConfigMem.Inst_frame4_bit5.Q
+ VPWR VGND sg13g2_dlhq_1
X_2633_ VGND VPWR Tile_X0Y1_DSP_bot.Inst_DSP_bot_ConfigMem.Inst_frame3_bit12.Q Tile_X0Y1_DSP_bot.Inst_DSP_bot_switch_matrix.Q4
+ _1021_ _1020_ sg13g2_a21oi_1
X_3116_ VGND VPWR Tile_X0Y0_DSP_top.Inst_DSP_top_ConfigMem.Inst_frame6_bit23.Q _1490_
+ _1492_ _1491_ sg13g2_a21oi_1
X_4096_ VGND VPWR Tile_X0Y1_E1END[3] Tile_X0Y1_DSP_bot.Inst_DSP_bot_ConfigMem.Inst_frame2_bit0.Q
+ _2358_ _2357_ sg13g2_a21oi_1
XFILLER_4_71 VPWR VGND sg13g2_fill_2
X_4234_ Tile_X0Y1_DSP_bot.Inst_DSP_bot_ConfigMem.Inst_frame8_bit30.Q _2471_ _2472_
+ VPWR VGND sg13g2_nor2b_1
X_4165_ Tile_X0Y1_DSP_bot.Inst_DSP_bot_ConfigMem.Inst_frame10_bit14.Q Tile_X0Y1_DSP_bot.Inst_DSP_bot_switch_matrix.Q6
+ _1019_ _1256_ _1762_ Tile_X0Y1_DSP_bot.Inst_DSP_bot_ConfigMem.Inst_frame10_bit15.Q
+ _2413_ VPWR VGND sg13g2_mux4_1
X_3047_ _1403_ VPWR _1424_ VGND _1422_ _1423_ sg13g2_o21ai_1
X_4998_ Tile_X0Y1_DSP_bot.Inst_DSP_bot_ConfigMem.Inst_frame5_bit15.Q Tile_X0Y1_N2END[0]
+ Tile_X0Y0_S2MID[0] Tile_X0Y1_EE4END[1] Tile_X0Y1_W2END[0] Tile_X0Y1_DSP_bot.Inst_DSP_bot_ConfigMem.Inst_frame5_bit14.Q
+ _0734_ VPWR VGND sg13g2_mux4_1
X_3949_ VGND VPWR _2235_ _2237_ Tile_X0Y0_DSP_top.Inst_DSP_top_switch_matrix.EE4BEG2
+ _2243_ sg13g2_a21oi_1
X_5619_ _2476_ VGND VPWR _0015_ Tile_X0Y1_DSP_bot.Inst_MULADD.ACC\[15\] clknet_3_6_0_Tile_X0Y1_UserCLK_regs
+ sg13g2_dfrbpq_1
XFILLER_2_104 VPWR VGND sg13g2_fill_2
XFILLER_61_328 VPWR VGND sg13g2_fill_1
XFILLER_58_196 VPWR VGND sg13g2_fill_1
XFILLER_48_77 VPWR VGND sg13g2_fill_1
XFILLER_14_277 VPWR VGND sg13g2_fill_1
XFILLER_96_203 VPWR VGND sg13g2_fill_1
XFILLER_89_73 VPWR VGND sg13g2_fill_1
XFILLER_43_7 VPWR VGND sg13g2_fill_2
X_4921_ _0660_ VPWR _0661_ VGND Tile_X0Y0_E6END[1] Tile_X0Y0_DSP_top.Inst_DSP_top_ConfigMem.Inst_frame3_bit0.Q
+ sg13g2_o21ai_1
X_3803_ _2130_ _2071_ _2129_ VPWR VGND sg13g2_xnor2_1
X_4852_ _0595_ Tile_X0Y0_DSP_top.Inst_DSP_top_ConfigMem.Inst_frame1_bit5.Q _0594_
+ VPWR VGND sg13g2_nand2_1
X_5970_ Tile_X0Y1_FrameData[9] Tile_X0Y1_FrameStrobe[9] Tile_X0Y1_DSP_bot.Inst_DSP_bot_ConfigMem.Inst_frame9_bit9.Q
+ VPWR VGND sg13g2_dlhq_1
X_6453_ Tile_X0Y0_SS4END[12] Tile_X0Y1_SS4BEG[4] VPWR VGND sg13g2_buf_1
X_3734_ _2064_ VPWR Tile_X0Y0_DSP_top.Inst_DSP_top_switch_matrix.inst_cus_mux81_buf_top2bot16.X
+ VGND _2059_ _2062_ sg13g2_o21ai_1
X_4783_ Tile_X0Y0_DSP_top.Inst_DSP_top_ConfigMem.Inst_frame7_bit9.Q _0527_ _0528_
+ VPWR VGND sg13g2_nor2_1
X_5404_ Tile_X0Y0_FrameData[17] Tile_X0Y1_FrameStrobe[6] Tile_X0Y0_DSP_top.Inst_DSP_top_ConfigMem.Inst_frame6_bit17.Q
+ VPWR VGND sg13g2_dlhq_1
X_3665_ _2001_ Tile_X0Y1_DSP_bot.Inst_DSP_bot_ConfigMem.Inst_frame12_bit3.Q Tile_X0Y1_DSP_bot.Inst_MULADD.ACC\[16\]
+ VPWR VGND sg13g2_nand2_1
X_2616_ _0996_ VPWR _1004_ VGND _0993_ _0997_ sg13g2_o21ai_1
XFILLER_20_247 VPWR VGND sg13g2_decap_8
X_5266_ Tile_X0Y0_FrameData[27] Tile_X0Y1_FrameStrobe[2] Tile_X0Y0_DSP_top.Inst_DSP_top_ConfigMem.Inst_frame2_bit27.Q
+ VPWR VGND sg13g2_dlhq_1
X_5335_ Tile_X0Y0_FrameData[22] Tile_X0Y1_FrameStrobe[4] Tile_X0Y0_DSP_top.Inst_DSP_top_ConfigMem.Inst_frame4_bit22.Q
+ VPWR VGND sg13g2_dlhq_1
XFILLER_87_203 VPWR VGND sg13g2_fill_2
X_2547_ Tile_X0Y0_DSP_top.Inst_DSP_top_ConfigMem.Inst_frame8_bit4.Q _0936_ _0937_
+ _0938_ _0447_ Tile_X0Y0_DSP_top.Inst_DSP_top_ConfigMem.Inst_frame8_bit5.Q Tile_X0Y0_DSP_top.Inst_DSP_top_switch_matrix.inst_cus_mux41_buf_top2bot5.X
+ VPWR VGND sg13g2_mux4_1
X_6384_ Tile_X0Y1_FrameData[3] Tile_X0Y1_FrameData_O[3] VPWR VGND sg13g2_buf_1
X_3596_ _1946_ _1417_ _1913_ VPWR VGND sg13g2_xnor2_1
X_4217_ Tile_X0Y1_DSP_bot.Inst_DSP_bot_ConfigMem.Inst_frame9_bit18.Q Tile_X0Y1_DSP_bot.Inst_DSP_bot_switch_matrix.Q6
+ Tile_X0Y1_DSP_bot.Inst_DSP_bot_switch_matrix.Q7 Tile_X0Y1_DSP_bot.Inst_DSP_bot_switch_matrix.Q8
+ Tile_X0Y1_DSP_bot.Inst_DSP_bot_switch_matrix.Q9 Tile_X0Y1_DSP_bot.Inst_DSP_bot_ConfigMem.Inst_frame9_bit19.Q
+ _2456_ VPWR VGND sg13g2_mux4_1
X_4148_ Tile_X0Y1_DSP_bot.Inst_DSP_bot_ConfigMem.Inst_frame11_bit22.Q Tile_X0Y1_E1END[3]
+ Tile_X0Y1_W1END[3] Tile_X0Y1_DSP_bot.Inst_DSP_bot_switch_matrix.Q0 Tile_X0Y1_DSP_bot.Inst_DSP_bot_switch_matrix.Q1
+ Tile_X0Y1_DSP_bot.Inst_DSP_bot_ConfigMem.Inst_frame11_bit23.Q _2398_ VPWR VGND sg13g2_mux4_1
X_4079_ Tile_X0Y1_DSP_bot.Inst_DSP_bot_ConfigMem.Inst_frame10_bit5.Q Tile_X0Y1_DSP_bot.Inst_DSP_bot_switch_matrix.Q7
+ Tile_X0Y1_DSP_bot.Inst_DSP_bot_switch_matrix.E2BEG2 _0288_ _0274_ Tile_X0Y1_DSP_bot.Inst_DSP_bot_ConfigMem.Inst_frame10_bit4.Q
+ Tile_X0Y1_DSP_bot.Inst_DSP_bot_switch_matrix.S1BEG3 VPWR VGND sg13g2_mux4_1
X_5197_ _0921_ VPWR _0922_ VGND Tile_X0Y1_DSP_bot.Inst_DSP_bot_ConfigMem.Inst_frame4_bit8.Q
+ Tile_X0Y1_DSP_bot.Inst_DSP_bot_switch_matrix.Q5 sg13g2_o21ai_1
XFILLER_109_113 VPWR VGND sg13g2_fill_1
XFILLER_51_350 VPWR VGND sg13g2_fill_1
XFILLER_7_229 VPWR VGND sg13g2_decap_4
XFILLER_11_236 VPWR VGND sg13g2_fill_1
XFILLER_59_65 VPWR VGND sg13g2_fill_2
XFILLER_34_328 VPWR VGND sg13g2_fill_2
XFILLER_24_90 VPWR VGND sg13g2_fill_1
X_5120_ Tile_X0Y0_DSP_top.Inst_DSP_top_ConfigMem.Inst_frame2_bit16.Q Tile_X0Y0_E1END[1]
+ _0850_ VPWR VGND sg13g2_nor2b_1
X_3381_ _1742_ VPWR _1743_ VGND Tile_X0Y1_DSP_bot.Inst_DSP_bot_ConfigMem.Inst_frame2_bit25.Q
+ _1739_ sg13g2_o21ai_1
X_3450_ _1807_ _1805_ _1806_ Tile_X0Y1_DSP_bot.Inst_MULADD.ACC\[5\] Tile_X0Y1_DSP_bot.Inst_DSP_bot_ConfigMem.Inst_frame12_bit3.Q
+ VPWR VGND sg13g2_a22oi_1
XFILLER_6_273 VPWR VGND sg13g2_fill_2
X_5051_ Tile_X0Y1_DSP_bot.Inst_DSP_bot_ConfigMem.Inst_frame9_bit29.Q VPWR _0785_ VGND
+ Tile_X0Y1_DSP_bot.Inst_DSP_bot_ConfigMem.Inst_frame9_bit28.Q _0784_ sg13g2_o21ai_1
XFILLER_27_2 VPWR VGND sg13g2_fill_1
X_4002_ _0937_ _2008_ Tile_X0Y0_DSP_top.Inst_DSP_top_ConfigMem.Inst_frame9_bit6.Q
+ _2289_ VPWR VGND sg13g2_mux2_1
XFILLER_37_122 VPWR VGND sg13g2_fill_2
X_4766_ _0511_ VPWR Tile_X0Y0_DSP_top.Inst_DSP_top_switch_matrix.JN2BEG2 VGND _0500_
+ _0506_ sg13g2_o21ai_1
X_4904_ Tile_X0Y0_DSP_top.Inst_DSP_top_ConfigMem.Inst_frame6_bit17.Q Tile_X0Y0_DSP_top.Inst_DSP_top_switch_matrix.N2BEGb7
+ Tile_X0Y0_S2MID[7] Tile_X0Y0_E2MID[7] Tile_X0Y0_W2MID[7] Tile_X0Y0_DSP_top.Inst_DSP_top_ConfigMem.Inst_frame6_bit16.Q
+ _0644_ VPWR VGND sg13g2_mux4_1
X_4835_ Tile_X0Y0_DSP_top.Inst_DSP_top_ConfigMem.Inst_frame8_bit1.Q _0577_ _0578_
+ VPWR VGND sg13g2_nor2_1
X_5953_ Tile_X0Y1_FrameData[26] Tile_X0Y1_FrameStrobe[9] Tile_X0Y1_DSP_bot.Inst_DSP_bot_ConfigMem.Inst_frame9_bit26.Q
+ VPWR VGND sg13g2_dlhq_1
X_5884_ Tile_X0Y1_FrameData[31] Tile_X0Y1_FrameStrobe[7] Tile_X0Y1_DSP_bot.Inst_DSP_bot_ConfigMem.Inst_frame7_bit31.Q
+ VPWR VGND sg13g2_dlhq_1
X_6436_ Tile_X0Y0_S4END[11] Tile_X0Y1_S4BEG[3] VPWR VGND sg13g2_buf_1
X_4697_ Tile_X0Y0_DSP_top.Inst_DSP_top_ConfigMem.Inst_frame7_bit24.Q Tile_X0Y0_DSP_top.Inst_DSP_top_switch_matrix.N2BEGb6
+ Tile_X0Y0_E2MID[6] Tile_X0Y0_S2MID[6] Tile_X0Y0_DSP_top.Inst_DSP_top_switch_matrix.JN2BEG6
+ Tile_X0Y0_DSP_top.Inst_DSP_top_ConfigMem.Inst_frame7_bit25.Q _0446_ VPWR VGND sg13g2_mux4_1
X_3648_ Tile_X0Y0_DSP_top.Inst_DSP_top_ConfigMem.Inst_frame0_bit26.Q Tile_X0Y1_N4END[6]
+ _1986_ VPWR VGND sg13g2_nor2b_1
X_3717_ _2049_ _0072_ Tile_X0Y0_DSP_top.Inst_DSP_top_switch_matrix.inst_cus_mux41_buf_top2bot15.X
+ VPWR VGND sg13g2_nand2_1
X_3579_ _1759_ _1757_ _1931_ VPWR VGND sg13g2_xor2_1
X_6505_ Tile_X0Y1_WW4END[12] Tile_X0Y1_WW4BEG[8] VPWR VGND sg13g2_buf_1
X_6367_ Tile_X0Y1_EE4END[6] Tile_X0Y1_EE4BEG[2] VPWR VGND sg13g2_buf_1
XFILLER_75_239 VPWR VGND sg13g2_fill_2
X_5249_ Tile_X0Y0_FrameData[12] Tile_X0Y1_FrameStrobe[1] Tile_X0Y0_DSP_top.Inst_DSP_top_ConfigMem.Inst_frame1_bit12.Q
+ VPWR VGND sg13g2_dlhq_1
X_5318_ Tile_X0Y0_FrameData[7] Tile_X0Y1_FrameStrobe[3] Tile_X0Y0_DSP_top.Inst_DSP_top_ConfigMem.Inst_frame3_bit7.Q
+ VPWR VGND sg13g2_dlhq_1
X_6298_ Tile_X0Y0_W2MID[1] Tile_X0Y0_W2BEGb[1] VPWR VGND sg13g2_buf_1
XFILLER_29_46 VPWR VGND sg13g2_fill_1
XFILLER_83_250 VPWR VGND sg13g2_fill_1
XFILLER_28_144 VPWR VGND sg13g2_fill_1
XFILLER_105_171 VPWR VGND sg13g2_fill_2
XFILLER_81_209 VPWR VGND sg13g2_fill_2
X_2950_ _0533_ _1076_ _1327_ VPWR VGND sg13g2_nor2b_1
X_2881_ _1259_ _0074_ _1258_ VPWR VGND sg13g2_nand2_1
X_4620_ Tile_X0Y1_DSP_bot.Inst_DSP_bot_ConfigMem.Inst_frame4_bit12.Q Tile_X0Y1_DSP_bot.Inst_DSP_bot_switch_matrix.Q0
+ Tile_X0Y1_DSP_bot.Inst_DSP_bot_switch_matrix.Q1 Tile_X0Y1_DSP_bot.Inst_DSP_bot_switch_matrix.Q2
+ Tile_X0Y1_DSP_bot.Inst_DSP_bot_switch_matrix.Q4 Tile_X0Y1_DSP_bot.Inst_DSP_bot_ConfigMem.Inst_frame4_bit13.Q
+ _0373_ VPWR VGND sg13g2_mux4_1
X_4482_ VGND VPWR Tile_X0Y0_E2END[5] Tile_X0Y0_DSP_top.Inst_DSP_top_ConfigMem.Inst_frame4_bit16.Q
+ _0241_ _0240_ sg13g2_a21oi_1
X_6221_ Tile_X0Y1_FrameStrobe[9] Tile_X0Y0_FrameStrobe_O[9] VPWR VGND sg13g2_buf_1
X_4551_ Tile_X0Y1_DSP_bot.Inst_DSP_bot_ConfigMem.Inst_frame4_bit24.Q Tile_X0Y1_DSP_bot.Inst_DSP_bot_switch_matrix.Q0
+ Tile_X0Y1_DSP_bot.Inst_DSP_bot_switch_matrix.Q1 Tile_X0Y1_DSP_bot.Inst_DSP_bot_switch_matrix.Q2
+ Tile_X0Y1_DSP_bot.Inst_DSP_bot_switch_matrix.Q3 Tile_X0Y1_DSP_bot.Inst_DSP_bot_ConfigMem.Inst_frame4_bit25.Q
+ _0306_ VPWR VGND sg13g2_mux4_1
X_3433_ _1790_ _1789_ _1791_ VPWR VGND sg13g2_nor2b_1
X_3502_ VGND VPWR Tile_X0Y1_DSP_bot.Inst_DSP_bot_ConfigMem.Inst_frame6_bit23.Q _1854_
+ _1858_ _1857_ sg13g2_a21oi_1
X_6152_ Tile_X0Y0_E6END[2] Tile_X0Y0_E6BEG[0] VPWR VGND sg13g2_buf_1
X_5103_ VGND VPWR _0054_ _0833_ _0834_ Tile_X0Y0_DSP_top.Inst_DSP_top_ConfigMem.Inst_frame2_bit11.Q
+ sg13g2_a21oi_1
X_6083_ VPWR VGND _2481_ sg13g2_tiehi
X_3364_ _1726_ VPWR _1727_ VGND Tile_X0Y1_DSP_bot.Inst_DSP_bot_ConfigMem.Inst_frame1_bit25.Q
+ _1723_ sg13g2_o21ai_1
X_3295_ Tile_X0Y1_DSP_bot.Inst_DSP_bot_ConfigMem.Inst_frame2_bit29.Q VPWR _1662_ VGND
+ Tile_X0Y1_DSP_bot.Inst_DSP_bot_ConfigMem.Inst_frame2_bit28.Q Tile_X0Y1_DSP_bot.Inst_DSP_bot_switch_matrix.Q6
+ sg13g2_o21ai_1
X_5034_ Tile_X0Y1_DSP_bot.Inst_DSP_bot_ConfigMem.Inst_frame1_bit4.Q Tile_X0Y0_S2MID[2]
+ _0769_ VPWR VGND sg13g2_nor2b_1
XFILLER_40_117 VPWR VGND sg13g2_fill_1
X_5936_ Tile_X0Y1_FrameData[11] Tile_X0Y1_FrameStrobe[8] Tile_X0Y1_DSP_bot.Inst_DSP_bot_ConfigMem.Inst_frame8_bit11.Q
+ VPWR VGND sg13g2_dlhq_1
X_4818_ Tile_X0Y0_DSP_top.Inst_DSP_top_ConfigMem.Inst_frame1_bit14.Q VPWR _0561_ VGND
+ Tile_X0Y0_DSP_top.Inst_DSP_top_ConfigMem.Inst_frame1_bit13.Q _0560_ sg13g2_o21ai_1
X_4749_ _0495_ _0493_ _0494_ Tile_X0Y1_DSP_bot.Inst_MULADD.ACC\[14\] Tile_X0Y1_DSP_bot.Inst_DSP_bot_ConfigMem.Inst_frame12_bit3.Q
+ VPWR VGND sg13g2_a22oi_1
X_5798_ Tile_X0Y1_FrameData[21] Tile_X0Y1_FrameStrobe[4] Tile_X0Y1_DSP_bot.Inst_DSP_bot_ConfigMem.Inst_frame4_bit21.Q
+ VPWR VGND sg13g2_dlhq_1
X_5867_ Tile_X0Y1_FrameData[16] Tile_X0Y1_FrameStrobe[6] Tile_X0Y1_DSP_bot.Inst_DSP_bot_ConfigMem.Inst_frame6_bit16.Q
+ VPWR VGND sg13g2_dlhq_1
XFILLER_110_7 VPWR VGND sg13g2_decap_8
X_6419_ Tile_X0Y1_DSP_bot.Inst_DSP_bot_switch_matrix.JS2BEG2 Tile_X0Y1_S2BEG[2] VPWR
+ VGND sg13g2_buf_1
XFILLER_102_174 VPWR VGND sg13g2_fill_1
XFILLER_56_261 VPWR VGND sg13g2_fill_2
XFILLER_56_44 VPWR VGND sg13g2_fill_1
X_3080_ _1455_ VPWR _1457_ VGND _1446_ _1448_ sg13g2_o21ai_1
X_3982_ _2266_ VPWR _2272_ VGND _2268_ _2271_ sg13g2_o21ai_1
XFILLER_62_275 VPWR VGND sg13g2_fill_2
X_5583_ Tile_X0Y0_FrameData[30] Tile_X0Y1_FrameStrobe[12] Tile_X0Y0_DSP_top.Inst_DSP_top_ConfigMem.Inst_frame12_bit30.Q
+ VPWR VGND sg13g2_dlhq_1
X_4603_ _0356_ VPWR Tile_X0Y0_DSP_top.Inst_DSP_top_switch_matrix.JN2BEG1 VGND _0347_
+ _0348_ sg13g2_o21ai_1
X_5652_ _2524_ VGND VPWR Tile_X0Y0_DSP_top.Inst_DSP_top_switch_matrix.inst_cus_mux41_buf_top2bot10.X
+ Tile_X0Y1_DSP_bot.Inst_MULADD.C_reg\[12\] clknet_3_5_0_Tile_X0Y1_UserCLK_regs sg13g2_dfrbpq_1
X_2933_ _1284_ _1309_ _1310_ VPWR VGND sg13g2_and2_1
X_2864_ Tile_X0Y1_DSP_bot.Inst_DSP_bot_ConfigMem.Inst_frame3_bit18.Q VPWR _1244_ VGND
+ _1242_ _1243_ sg13g2_o21ai_1
X_2795_ _1176_ Tile_X0Y1_W2MID[7] Tile_X0Y1_DSP_bot.Inst_DSP_bot_ConfigMem.Inst_frame6_bit0.Q
+ VPWR VGND sg13g2_nand2_1
X_5721_ Tile_X0Y1_FrameData[2] Tile_X0Y1_FrameStrobe[1] Tile_X0Y1_DSP_bot.Inst_DSP_bot_ConfigMem.Inst_frame1_bit2.Q
+ VPWR VGND sg13g2_dlhq_1
X_6204_ Tile_X0Y0_FrameData[24] Tile_X0Y0_FrameData_O[24] VPWR VGND sg13g2_buf_1
X_4396_ VGND VPWR _0027_ _0157_ _0158_ Tile_X0Y1_DSP_bot.Inst_DSP_bot_ConfigMem.Inst_frame3_bit10.Q
+ sg13g2_a21oi_1
X_4465_ Tile_X0Y1_DSP_bot.Inst_DSP_bot_ConfigMem.Inst_frame1_bit0.Q Tile_X0Y1_DSP_bot.Inst_DSP_bot_switch_matrix.Q5
+ Tile_X0Y1_DSP_bot.Inst_DSP_bot_switch_matrix.Q6 Tile_X0Y1_DSP_bot.Inst_DSP_bot_switch_matrix.Q7
+ Tile_X0Y1_DSP_bot.Inst_DSP_bot_switch_matrix.Q9 Tile_X0Y1_DSP_bot.Inst_DSP_bot_ConfigMem.Inst_frame1_bit1.Q
+ _0224_ VPWR VGND sg13g2_mux4_1
XFILLER_7_93 VPWR VGND sg13g2_fill_1
X_4534_ _0289_ VPWR _0290_ VGND Tile_X0Y1_DSP_bot.Inst_DSP_bot_ConfigMem.Inst_frame12_bit12.Q
+ _0287_ sg13g2_o21ai_1
X_3416_ _1775_ _1763_ Tile_X0Y1_DSP_bot.Inst_DSP_bot_ConfigMem.Inst_frame8_bit21.Q
+ Tile_X0Y1_DSP_bot.C7 VPWR VGND sg13g2_mux2_1
X_6135_ Tile_X0Y0_DSP_top.Inst_DSP_top_switch_matrix.E1BEG3 Tile_X0Y0_E1BEG[3] VPWR
+ VGND sg13g2_buf_1
X_3347_ _1709_ _1710_ _1711_ VPWR VGND sg13g2_nor2_1
X_3278_ _1645_ Tile_X0Y1_DSP_bot.Inst_DSP_bot_ConfigMem.Inst_frame1_bit28.Q Tile_X0Y1_DSP_bot.Inst_DSP_bot_switch_matrix.Q8
+ VPWR VGND sg13g2_nand2_1
X_6066_ Tile_X0Y1_FrameData[9] Tile_X0Y1_FrameStrobe[12] Tile_X0Y1_DSP_bot.Inst_DSP_bot_ConfigMem.Inst_frame12_bit9.Q
+ VPWR VGND sg13g2_dlhq_1
X_5017_ _0752_ Tile_X0Y1_W2MID[1] Tile_X0Y1_DSP_bot.Inst_DSP_bot_ConfigMem.Inst_frame6_bit6.Q
+ VPWR VGND sg13g2_nand2_1
XFILLER_13_106 VPWR VGND sg13g2_fill_2
XFILLER_13_128 VPWR VGND sg13g2_fill_1
X_5919_ Tile_X0Y1_FrameData[28] Tile_X0Y1_FrameStrobe[8] Tile_X0Y1_DSP_bot.Inst_DSP_bot_ConfigMem.Inst_frame8_bit28.Q
+ VPWR VGND sg13g2_dlhq_1
XFILLER_107_299 VPWR VGND sg13g2_fill_2
X_4250_ Tile_X0Y1_DSP_bot.Inst_DSP_bot_switch_matrix.clr _2133_ _0013_ VPWR VGND sg13g2_nor2_1
X_2580_ _0967_ _0968_ _0969_ VPWR VGND sg13g2_and2_1
X_3201_ _1572_ VPWR _1573_ VGND Tile_X0Y0_W1END[0] Tile_X0Y0_DSP_top.Inst_DSP_top_ConfigMem.Inst_frame4_bit20.Q
+ sg13g2_o21ai_1
X_3132_ _1446_ _1506_ _1507_ VPWR VGND sg13g2_nor2b_1
X_3063_ _1440_ _1144_ _1439_ VPWR VGND sg13g2_xnor2_1
X_4181_ _2423_ VPWR _2424_ VGND Tile_X0Y1_DSP_bot.Inst_DSP_bot_ConfigMem.Inst_frame9_bit5.Q
+ _1121_ sg13g2_o21ai_1
X_3965_ Tile_X0Y0_DSP_top.Inst_DSP_top_ConfigMem.Inst_frame11_bit31.Q Tile_X0Y0_E1END[2]
+ Tile_X0Y0_DSP_top.Inst_DSP_top_switch_matrix.bot2top0 Tile_X0Y0_W1END[2] Tile_X0Y0_DSP_top.Inst_DSP_top_switch_matrix.bot2top1
+ Tile_X0Y0_DSP_top.Inst_DSP_top_ConfigMem.Inst_frame11_bit30.Q _2257_ VPWR VGND sg13g2_mux4_1
XFILLER_35_231 VPWR VGND sg13g2_decap_4
X_2778_ VPWR _1160_ _1159_ VGND sg13g2_inv_1
X_5566_ Tile_X0Y0_FrameData[15] Tile_X0Y1_FrameStrobe[11] Tile_X0Y0_DSP_top.Inst_DSP_top_ConfigMem.Inst_frame11_bit15.Q
+ VPWR VGND sg13g2_dlhq_1
X_3896_ Tile_X0Y0_DSP_top.Inst_DSP_top_ConfigMem.Inst_frame10_bit30.Q Tile_X0Y0_DSP_top.Inst_DSP_top_switch_matrix.bot2top5
+ _0465_ Tile_X0Y0_DSP_top.Inst_DSP_top_switch_matrix.JS2BEG3 _0447_ Tile_X0Y0_DSP_top.Inst_DSP_top_ConfigMem.Inst_frame10_bit31.Q
+ Tile_X0Y0_DSP_top.Inst_DSP_top_switch_matrix.W1BEG0 VPWR VGND sg13g2_mux4_1
X_2847_ _1226_ VPWR _1227_ VGND _1217_ _1218_ sg13g2_o21ai_1
X_2916_ Tile_X0Y1_DSP_bot.Inst_DSP_bot_ConfigMem.Inst_frame7_bit8.Q _0643_ _1294_
+ VPWR VGND _0677_ sg13g2_nand3b_1
X_5635_ _2507_ VGND VPWR Tile_X0Y1_DSP_bot.B3 Tile_X0Y1_DSP_bot.Inst_MULADD.B_reg\[3\]
+ clknet_3_1_0_Tile_X0Y1_UserCLK_regs sg13g2_dfrbpq_1
X_5704_ Tile_X0Y1_FrameData[19] Tile_X0Y1_FrameStrobe[1] Tile_X0Y1_DSP_bot.Inst_DSP_bot_ConfigMem.Inst_frame1_bit19.Q
+ VPWR VGND sg13g2_dlhq_1
X_4448_ VPWR Tile_X0Y0_DSP_top.Inst_DSP_top_switch_matrix.JS2BEG7 _0208_ VGND sg13g2_inv_1
X_5497_ Tile_X0Y0_FrameData[20] Tile_X0Y1_FrameStrobe[9] Tile_X0Y0_DSP_top.Inst_DSP_top_ConfigMem.Inst_frame9_bit20.Q
+ VPWR VGND sg13g2_dlhq_1
X_4379_ _0140_ _0141_ _0023_ _0142_ VPWR VGND sg13g2_mux2_1
X_4517_ Tile_X0Y1_DSP_bot.Inst_DSP_bot_ConfigMem.Inst_frame0_bit1.Q Tile_X0Y1_NN4END[3]
+ Tile_X0Y1_WW4END[0] Tile_X0Y0_S4END[7] Tile_X0Y0_DSP_top.Inst_DSP_top_switch_matrix.N2BEGb1
+ Tile_X0Y1_DSP_bot.Inst_DSP_bot_ConfigMem.Inst_frame0_bit0.Q _0274_ VPWR VGND sg13g2_mux4_1
XFILLER_73_359 VPWR VGND sg13g2_fill_2
XFILLER_58_334 VPWR VGND sg13g2_fill_2
X_6118_ VPWR VGND _2516_ sg13g2_tiehi
X_6049_ Tile_X0Y1_FrameData[26] Tile_X0Y1_FrameStrobe[12] Tile_X0Y1_DSP_bot.Inst_DSP_bot_ConfigMem.Inst_frame12_bit26.Q
+ VPWR VGND sg13g2_dlhq_1
XFILLER_78_42 VPWR VGND sg13g2_fill_1
XFILLER_76_175 VPWR VGND sg13g2_fill_2
XFILLER_94_74 VPWR VGND sg13g2_fill_2
XFILLER_91_167 VPWR VGND sg13g2_fill_1
X_3750_ Tile_X0Y0_DSP_top.Inst_DSP_top_ConfigMem.Inst_frame1_bit28.Q Tile_X0Y0_S2END[0]
+ _2080_ VPWR VGND sg13g2_nor2b_1
X_5420_ Tile_X0Y0_FrameData[1] Tile_X0Y1_FrameStrobe[6] Tile_X0Y0_DSP_top.Inst_DSP_top_ConfigMem.Inst_frame6_bit1.Q
+ VPWR VGND sg13g2_dlhq_1
X_3681_ Tile_X0Y0_DSP_top.Inst_DSP_top_ConfigMem.Inst_frame8_bit23.Q _2016_ _2017_
+ VPWR VGND sg13g2_nor2_1
X_2632_ Tile_X0Y1_DSP_bot.Inst_DSP_bot_ConfigMem.Inst_frame3_bit13.Q VPWR _1020_ VGND
+ Tile_X0Y1_DSP_bot.Inst_DSP_bot_ConfigMem.Inst_frame3_bit12.Q _0127_ sg13g2_o21ai_1
X_2701_ Tile_X0Y1_DSP_bot.Inst_DSP_bot_switch_matrix.Q3 Tile_X0Y1_DSP_bot.Inst_DSP_bot_switch_matrix.Q4
+ Tile_X0Y1_DSP_bot.Inst_DSP_bot_ConfigMem.Inst_frame2_bit8.Q _1086_ VPWR VGND sg13g2_mux2_1
XFILLER_99_267 VPWR VGND sg13g2_fill_1
X_5282_ Tile_X0Y0_FrameData[11] Tile_X0Y1_FrameStrobe[2] Tile_X0Y0_DSP_top.Inst_DSP_top_ConfigMem.Inst_frame2_bit11.Q
+ VPWR VGND sg13g2_dlhq_1
X_2563_ VPWR _0954_ _0953_ VGND sg13g2_inv_1
X_5351_ Tile_X0Y0_FrameData[6] Tile_X0Y1_FrameStrobe[4] Tile_X0Y0_DSP_top.Inst_DSP_top_ConfigMem.Inst_frame4_bit6.Q
+ VPWR VGND sg13g2_dlhq_1
X_4302_ VPWR _0065_ Tile_X0Y0_DSP_top.Inst_DSP_top_ConfigMem.Inst_frame8_bit8.Q VGND
+ sg13g2_inv_1
X_4233_ Tile_X0Y1_DSP_bot.Inst_DSP_bot_ConfigMem.Inst_frame8_bit28.Q Tile_X0Y1_N2MID[6]
+ Tile_X0Y1_E2MID[0] Tile_X0Y1_E2MID[6] Tile_X0Y0_DSP_top.Inst_DSP_top_switch_matrix.JS2BEG0
+ Tile_X0Y1_DSP_bot.Inst_DSP_bot_ConfigMem.Inst_frame8_bit29.Q _2471_ VPWR VGND sg13g2_mux4_1
X_3115_ Tile_X0Y0_DSP_top.Inst_DSP_top_ConfigMem.Inst_frame8_bit16.Q VPWR _1491_ VGND
+ Tile_X0Y0_DSP_top.Inst_DSP_top_ConfigMem.Inst_frame6_bit23.Q _1489_ sg13g2_o21ai_1
X_3046_ _1402_ _1401_ _1423_ VPWR VGND sg13g2_xor2_1
X_4095_ Tile_X0Y1_DSP_bot.Inst_DSP_bot_ConfigMem.Inst_frame2_bit0.Q Tile_X0Y1_NN4END[1]
+ _2357_ VPWR VGND sg13g2_nor2b_1
X_4164_ _2404_ VPWR Tile_X0Y1_DSP_bot.Inst_DSP_bot_switch_matrix.E6BEG1 VGND _2411_
+ _2412_ sg13g2_o21ai_1
X_3948_ VGND VPWR Tile_X0Y0_DSP_top.Inst_DSP_top_ConfigMem.Inst_frame11_bit21.Q _2239_
+ _2243_ _2242_ sg13g2_a21oi_1
X_4997_ _0729_ _0732_ _0733_ VPWR VGND sg13g2_nor2_1
XFILLER_109_328 VPWR VGND sg13g2_decap_4
X_5549_ Tile_X0Y0_FrameData[0] Tile_X0Y1_FrameStrobe[10] Tile_X0Y0_DSP_top.Inst_DSP_top_ConfigMem.Inst_frame10_bit0.Q
+ VPWR VGND sg13g2_dlhq_1
X_3879_ VGND VPWR Tile_X0Y1_N4END[5] Tile_X0Y0_DSP_top.Inst_DSP_top_ConfigMem.Inst_frame4_bit0.Q
+ _2192_ _2191_ sg13g2_a21oi_1
X_5618_ _2477_ VGND VPWR _0014_ Tile_X0Y1_DSP_bot.Inst_MULADD.ACC\[14\] clknet_3_6_0_Tile_X0Y1_UserCLK_regs
+ sg13g2_dfrbpq_1
XFILLER_100_294 VPWR VGND sg13g2_fill_2
XFILLER_73_189 VPWR VGND sg13g2_decap_8
XFILLER_14_256 VPWR VGND sg13g2_fill_1
XFILLER_89_96 VPWR VGND sg13g2_fill_1
XFILLER_64_134 VPWR VGND sg13g2_decap_8
XFILLER_37_359 VPWR VGND sg13g2_fill_2
X_4920_ _0660_ Tile_X0Y0_DSP_top.Inst_DSP_top_ConfigMem.Inst_frame3_bit0.Q Tile_X0Y0_S2END[1]
+ VPWR VGND sg13g2_nand2b_1
X_4782_ Tile_X0Y0_E2MID[6] Tile_X0Y0_DSP_top.Inst_DSP_top_ConfigMem.Inst_frame7_bit8.Q
+ _0527_ VPWR VGND sg13g2_nor2_1
X_3802_ _2128_ _2000_ _2129_ VPWR VGND sg13g2_xor2_1
X_4851_ Tile_X0Y0_W2END[2] Tile_X0Y0_W6END[0] Tile_X0Y0_DSP_top.Inst_DSP_top_ConfigMem.Inst_frame1_bit4.Q
+ _0594_ VPWR VGND sg13g2_mux2_1
X_6452_ Tile_X0Y0_SS4END[11] Tile_X0Y1_SS4BEG[3] VPWR VGND sg13g2_buf_1
XFILLER_109_18 VPWR VGND sg13g2_fill_2
X_3733_ _2064_ Tile_X0Y0_DSP_top.Inst_DSP_top_ConfigMem.Inst_frame8_bit28.Q _2063_
+ VPWR VGND sg13g2_nand2_1
X_5403_ Tile_X0Y0_FrameData[18] Tile_X0Y1_FrameStrobe[6] Tile_X0Y0_DSP_top.Inst_DSP_top_ConfigMem.Inst_frame6_bit18.Q
+ VPWR VGND sg13g2_dlhq_1
X_3664_ Tile_X0Y1_DSP_bot.Inst_DSP_bot_ConfigMem.Inst_frame12_bit4.Q _1964_ _2000_
+ VPWR VGND sg13g2_and2_1
XFILLER_62_0 VPWR VGND sg13g2_fill_2
X_2615_ _1002_ _1001_ _0999_ _1003_ VPWR VGND sg13g2_a21o_1
X_6383_ Tile_X0Y1_FrameData[2] Tile_X0Y1_FrameData_O[2] VPWR VGND sg13g2_buf_1
X_3595_ _1945_ VPWR Tile_X0Y1_DSP_bot.Inst_DSP_bot_switch_matrix.Q2 VGND Tile_X0Y1_DSP_bot.Inst_DSP_bot_ConfigMem.Inst_frame12_bit5.Q
+ _1944_ sg13g2_o21ai_1
X_5334_ Tile_X0Y0_FrameData[23] Tile_X0Y1_FrameStrobe[4] Tile_X0Y0_DSP_top.Inst_DSP_top_ConfigMem.Inst_frame4_bit23.Q
+ VPWR VGND sg13g2_dlhq_1
X_5265_ Tile_X0Y0_FrameData[28] Tile_X0Y1_FrameStrobe[2] Tile_X0Y0_DSP_top.Inst_DSP_top_ConfigMem.Inst_frame2_bit28.Q
+ VPWR VGND sg13g2_dlhq_1
X_2546_ Tile_X0Y0_DSP_top.Inst_DSP_top_ConfigMem.Inst_frame5_bit11.Q Tile_X0Y1_N2MID[2]
+ Tile_X0Y0_S2END[2] Tile_X0Y0_E2END[2] Tile_X0Y0_WW4END[2] Tile_X0Y0_DSP_top.Inst_DSP_top_ConfigMem.Inst_frame5_bit10.Q
+ _0938_ VPWR VGND sg13g2_mux4_1
X_4147_ Tile_X0Y1_DSP_bot.Inst_DSP_bot_ConfigMem.Inst_frame11_bit22.Q Tile_X0Y1_DSP_bot.Inst_DSP_bot_switch_matrix.Q6
+ Tile_X0Y1_DSP_bot.Inst_DSP_bot_switch_matrix.Q7 Tile_X0Y1_DSP_bot.Inst_DSP_bot_switch_matrix.Q8
+ Tile_X0Y1_DSP_bot.Inst_DSP_bot_switch_matrix.Q9 Tile_X0Y1_DSP_bot.Inst_DSP_bot_ConfigMem.Inst_frame11_bit23.Q
+ _2397_ VPWR VGND sg13g2_mux4_1
X_5196_ VGND VPWR Tile_X0Y1_DSP_bot.Inst_DSP_bot_ConfigMem.Inst_frame4_bit8.Q _0126_
+ _0921_ Tile_X0Y1_DSP_bot.Inst_DSP_bot_ConfigMem.Inst_frame4_bit9.Q sg13g2_a21oi_1
X_4216_ _0124_ _2452_ _2454_ _2455_ VPWR VGND sg13g2_nor3_1
XFILLER_55_112 VPWR VGND sg13g2_fill_1
X_3029_ VGND VPWR _1074_ _1075_ _1406_ _1260_ sg13g2_a21oi_1
X_4078_ Tile_X0Y1_DSP_bot.Inst_DSP_bot_ConfigMem.Inst_frame10_bit3.Q Tile_X0Y1_DSP_bot.Inst_DSP_bot_switch_matrix.Q6
+ Tile_X0Y1_DSP_bot.Inst_DSP_bot_switch_matrix.E2BEG1 _1793_ _1761_ Tile_X0Y1_DSP_bot.Inst_DSP_bot_ConfigMem.Inst_frame10_bit2.Q
+ Tile_X0Y1_DSP_bot.Inst_DSP_bot_switch_matrix.S1BEG2 VPWR VGND sg13g2_mux4_1
XFILLER_34_58 VPWR VGND sg13g2_decap_8
XFILLER_105_353 VPWR VGND sg13g2_fill_2
XFILLER_59_33 VPWR VGND sg13g2_fill_2
XFILLER_93_229 VPWR VGND sg13g2_fill_1
XFILLER_98_9 VPWR VGND sg13g2_fill_1
XFILLER_91_42 VPWR VGND sg13g2_fill_2
XFILLER_91_20 VPWR VGND sg13g2_fill_1
X_4001_ VGND VPWR Tile_X0Y0_DSP_top.Inst_DSP_top_ConfigMem.Inst_frame9_bit6.Q _0979_
+ _2288_ _2287_ sg13g2_a21oi_1
X_3380_ _1741_ Tile_X0Y1_DSP_bot.Inst_DSP_bot_ConfigMem.Inst_frame2_bit26.Q _1742_
+ VPWR VGND sg13g2_nor2b_1
X_5050_ Tile_X0Y1_DSP_bot.Inst_DSP_bot_ConfigMem.Inst_frame5_bit7.Q Tile_X0Y1_N2END[0]
+ Tile_X0Y0_S2MID[0] Tile_X0Y1_E2END[0] Tile_X0Y1_WW4END[3] Tile_X0Y1_DSP_bot.Inst_DSP_bot_ConfigMem.Inst_frame5_bit6.Q
+ _0784_ VPWR VGND sg13g2_mux4_1
X_4903_ _0643_ _0641_ _0642_ VPWR VGND sg13g2_nand2_1
XFILLER_37_145 VPWR VGND sg13g2_fill_2
XFILLER_1_84 VPWR VGND sg13g2_fill_1
X_5952_ Tile_X0Y1_FrameData[27] Tile_X0Y1_FrameStrobe[9] Tile_X0Y1_DSP_bot.Inst_DSP_bot_ConfigMem.Inst_frame9_bit27.Q
+ VPWR VGND sg13g2_dlhq_1
X_4765_ _0510_ VPWR _0511_ VGND Tile_X0Y0_DSP_top.Inst_DSP_top_ConfigMem.Inst_frame4_bit10.Q
+ _0507_ sg13g2_o21ai_1
X_3716_ Tile_X0Y0_DSP_top.Inst_DSP_top_ConfigMem.Inst_frame8_bit24.Q _2047_ _2048_
+ _2030_ _0407_ Tile_X0Y0_DSP_top.Inst_DSP_top_ConfigMem.Inst_frame8_bit25.Q Tile_X0Y0_DSP_top.Inst_DSP_top_switch_matrix.inst_cus_mux41_buf_top2bot15.X
+ VPWR VGND sg13g2_mux4_1
XFILLER_60_192 VPWR VGND sg13g2_fill_1
X_4834_ VGND VPWR Tile_X0Y0_DSP_top.Inst_DSP_top_ConfigMem.Inst_frame6_bit7.Q _0575_
+ _0577_ _0576_ sg13g2_a21oi_1
X_5883_ Tile_X0Y1_FrameData[0] Tile_X0Y1_FrameStrobe[6] Tile_X0Y1_DSP_bot.Inst_DSP_bot_ConfigMem.Inst_frame6_bit0.Q
+ VPWR VGND sg13g2_dlhq_1
X_6504_ Tile_X0Y1_WW4END[11] Tile_X0Y1_WW4BEG[7] VPWR VGND sg13g2_buf_1
X_6435_ Tile_X0Y0_S4END[10] Tile_X0Y1_S4BEG[2] VPWR VGND sg13g2_buf_1
X_5317_ Tile_X0Y0_FrameData[8] Tile_X0Y1_FrameStrobe[3] Tile_X0Y0_DSP_top.Inst_DSP_top_ConfigMem.Inst_frame3_bit8.Q
+ VPWR VGND sg13g2_dlhq_1
X_3647_ Tile_X0Y0_W2END[2] Tile_X0Y0_DSP_top.Inst_DSP_top_switch_matrix.E2BEG4 Tile_X0Y0_DSP_top.Inst_DSP_top_ConfigMem.Inst_frame0_bit26.Q
+ _1985_ VPWR VGND sg13g2_mux2_1
X_4696_ VPWR Tile_X0Y0_DSP_top.Inst_DSP_top_switch_matrix.N2BEGb6 _0445_ VGND sg13g2_inv_1
X_3578_ _1780_ VPWR _1930_ VGND _1928_ _1929_ sg13g2_o21ai_1
X_6366_ Tile_X0Y1_EE4END[5] Tile_X0Y1_EE4BEG[1] VPWR VGND sg13g2_buf_1
XFILLER_20_49 VPWR VGND sg13g2_fill_1
X_5179_ Tile_X0Y0_DSP_top.Inst_DSP_top_ConfigMem.Inst_frame3_bit16.Q Tile_X0Y0_DSP_top.Inst_DSP_top_switch_matrix.bot2top0
+ Tile_X0Y0_DSP_top.Inst_DSP_top_switch_matrix.bot2top1 Tile_X0Y0_DSP_top.Inst_DSP_top_switch_matrix.bot2top2
+ Tile_X0Y0_DSP_top.Inst_DSP_top_switch_matrix.bot2top3 Tile_X0Y0_DSP_top.Inst_DSP_top_ConfigMem.Inst_frame3_bit17.Q
+ _0905_ VPWR VGND sg13g2_mux4_1
X_5248_ Tile_X0Y0_FrameData[13] Tile_X0Y1_FrameStrobe[1] Tile_X0Y0_DSP_top.Inst_DSP_top_ConfigMem.Inst_frame1_bit13.Q
+ VPWR VGND sg13g2_dlhq_1
X_6297_ Tile_X0Y0_W2MID[0] Tile_X0Y0_W2BEGb[0] VPWR VGND sg13g2_buf_1
XFILLER_29_25 VPWR VGND sg13g2_fill_1
XFILLER_24_351 VPWR VGND sg13g2_fill_1
XFILLER_19_112 VPWR VGND sg13g2_decap_4
X_2880_ VPWR Tile_X0Y1_DSP_bot.B1 _1258_ VGND sg13g2_inv_1
XFILLER_30_321 VPWR VGND sg13g2_fill_1
X_6220_ Tile_X0Y1_FrameStrobe[8] Tile_X0Y0_FrameStrobe_O[8] VPWR VGND sg13g2_buf_1
X_4550_ _0260_ _0305_ Tile_X0Y0_DSP_top.Inst_DSP_top_switch_matrix.JN2BEG6 VPWR VGND
+ sg13g2_nor2_1
X_4481_ Tile_X0Y0_DSP_top.Inst_DSP_top_ConfigMem.Inst_frame4_bit16.Q Tile_X0Y0_E1END[1]
+ _0240_ VPWR VGND sg13g2_nor2b_1
X_6151_ Tile_X0Y0_E2MID[7] Tile_X0Y0_E2BEGb[7] VPWR VGND sg13g2_buf_1
X_3363_ _1725_ Tile_X0Y1_DSP_bot.Inst_DSP_bot_ConfigMem.Inst_frame1_bit26.Q _1726_
+ VPWR VGND sg13g2_nor2b_1
X_3432_ _1790_ _1424_ _1425_ VPWR VGND sg13g2_xnor2_1
X_3501_ Tile_X0Y1_DSP_bot.Inst_DSP_bot_ConfigMem.Inst_frame8_bit12.Q VPWR _1857_ VGND
+ Tile_X0Y1_DSP_bot.Inst_DSP_bot_ConfigMem.Inst_frame6_bit23.Q _1856_ sg13g2_o21ai_1
X_5102_ Tile_X0Y0_DSP_top.Inst_DSP_top_ConfigMem.Inst_frame2_bit8.Q Tile_X0Y1_NN4END[7]
+ Tile_X0Y0_E1END[1] Tile_X0Y0_E2END[3] Tile_X0Y0_E6END[1] Tile_X0Y0_DSP_top.Inst_DSP_top_ConfigMem.Inst_frame2_bit9.Q
+ _0833_ VPWR VGND sg13g2_mux4_1
X_6082_ VPWR VGND _2480_ sg13g2_tiehi
X_3294_ _1660_ VPWR _1661_ VGND Tile_X0Y1_DSP_bot.Inst_DSP_bot_ConfigMem.Inst_frame2_bit28.Q
+ Tile_X0Y1_DSP_bot.Inst_DSP_bot_switch_matrix.Q4 sg13g2_o21ai_1
X_5033_ _0763_ _0767_ Tile_X0Y1_DSP_bot.Inst_DSP_bot_ConfigMem.Inst_frame1_bit7.Q
+ _0768_ VPWR VGND sg13g2_nand3_1
X_5935_ Tile_X0Y1_FrameData[12] Tile_X0Y1_FrameStrobe[8] Tile_X0Y1_DSP_bot.Inst_DSP_bot_ConfigMem.Inst_frame8_bit12.Q
+ VPWR VGND sg13g2_dlhq_1
X_5866_ Tile_X0Y1_FrameData[17] Tile_X0Y1_FrameStrobe[6] Tile_X0Y1_DSP_bot.Inst_DSP_bot_ConfigMem.Inst_frame6_bit17.Q
+ VPWR VGND sg13g2_dlhq_1
X_4817_ VGND VPWR Tile_X0Y0_DSP_top.Inst_DSP_top_ConfigMem.Inst_frame1_bit12.Q Tile_X0Y0_DSP_top.Inst_DSP_top_switch_matrix.bot2top6
+ _0560_ _0559_ sg13g2_a21oi_1
X_4748_ VGND VPWR Tile_X0Y1_DSP_bot.Inst_DSP_bot_ConfigMem.Inst_frame12_bit2.Q _0109_
+ _0494_ Tile_X0Y1_DSP_bot.Inst_DSP_bot_ConfigMem.Inst_frame12_bit3.Q sg13g2_a21oi_1
X_4679_ _0050_ VPWR _0430_ VGND Tile_X0Y1_DSP_bot.Inst_DSP_bot_ConfigMem.Inst_frame4_bit22.Q
+ _0429_ sg13g2_o21ai_1
X_5797_ Tile_X0Y1_FrameData[22] Tile_X0Y1_FrameStrobe[4] Tile_X0Y1_DSP_bot.Inst_DSP_bot_ConfigMem.Inst_frame4_bit22.Q
+ VPWR VGND sg13g2_dlhq_1
XFILLER_102_120 VPWR VGND sg13g2_fill_2
XFILLER_48_207 VPWR VGND sg13g2_fill_2
X_6418_ Tile_X0Y1_DSP_bot.Inst_DSP_bot_switch_matrix.JS2BEG1 Tile_X0Y1_S2BEG[1] VPWR
+ VGND sg13g2_buf_1
X_6349_ Tile_X0Y1_E2MID[4] Tile_X0Y1_E2BEGb[4] VPWR VGND sg13g2_buf_1
XFILLER_71_210 VPWR VGND sg13g2_fill_1
XFILLER_12_321 VPWR VGND sg13g2_fill_1
XFILLER_12_332 VPWR VGND sg13g2_fill_1
XFILLER_8_358 VPWR VGND sg13g2_fill_2
X_3981_ _2271_ Tile_X0Y0_DSP_top.Inst_DSP_top_ConfigMem.Inst_frame10_bit23.Q _2270_
+ VPWR VGND sg13g2_nand2_1
X_2932_ _0608_ _1308_ _1309_ VPWR VGND sg13g2_nor2_1
X_5720_ Tile_X0Y1_FrameData[3] Tile_X0Y1_FrameStrobe[1] Tile_X0Y1_DSP_bot.Inst_DSP_bot_ConfigMem.Inst_frame1_bit3.Q
+ VPWR VGND sg13g2_dlhq_1
XFILLER_15_170 VPWR VGND sg13g2_fill_1
X_5582_ Tile_X0Y0_FrameData[31] Tile_X0Y1_FrameStrobe[12] Tile_X0Y0_DSP_top.Inst_DSP_top_ConfigMem.Inst_frame12_bit31.Q
+ VPWR VGND sg13g2_dlhq_1
X_4602_ _0355_ VPWR _0356_ VGND Tile_X0Y0_DSP_top.Inst_DSP_top_ConfigMem.Inst_frame4_bit6.Q
+ _0354_ sg13g2_o21ai_1
X_5651_ _2523_ VGND VPWR Tile_X0Y0_DSP_top.Inst_DSP_top_switch_matrix.inst_cus_mux41_buf_top2bot9.X
+ Tile_X0Y1_DSP_bot.Inst_MULADD.C_reg\[11\] clknet_3_6_0_Tile_X0Y1_UserCLK_regs sg13g2_dfrbpq_1
X_2863_ Tile_X0Y1_DSP_bot.Inst_DSP_bot_ConfigMem.Inst_frame3_bit17.Q VPWR _1243_ VGND
+ Tile_X0Y0_S2MID[5] Tile_X0Y1_DSP_bot.Inst_DSP_bot_ConfigMem.Inst_frame3_bit16.Q
+ sg13g2_o21ai_1
X_2794_ Tile_X0Y1_DSP_bot.Inst_DSP_bot_ConfigMem.Inst_frame7_bit1.Q Tile_X0Y1_N2MID[6]
+ Tile_X0Y1_W2MID[6] Tile_X0Y0_DSP_top.Inst_DSP_top_switch_matrix.JS2BEG6 Tile_X0Y0_DSP_top.Inst_DSP_top_switch_matrix.N2BEGb3
+ Tile_X0Y1_DSP_bot.Inst_DSP_bot_ConfigMem.Inst_frame7_bit0.Q _1175_ VPWR VGND sg13g2_mux4_1
X_4533_ VGND VPWR Tile_X0Y1_DSP_bot.Inst_DSP_bot_ConfigMem.Inst_frame12_bit12.Q _0274_
+ _0289_ _0042_ sg13g2_a21oi_1
X_6203_ Tile_X0Y0_FrameData[23] Tile_X0Y0_FrameData_O[23] VPWR VGND sg13g2_buf_1
X_6134_ Tile_X0Y0_DSP_top.Inst_DSP_top_switch_matrix.E1BEG2 Tile_X0Y0_E1BEG[2] VPWR
+ VGND sg13g2_buf_1
X_3346_ Tile_X0Y1_DSP_bot.Inst_DSP_bot_ConfigMem.Inst_frame3_bit27.Q VPWR _1710_ VGND
+ _1706_ _1707_ sg13g2_o21ai_1
X_4395_ Tile_X0Y1_DSP_bot.Inst_DSP_bot_switch_matrix.Q0 Tile_X0Y1_DSP_bot.Inst_DSP_bot_switch_matrix.Q1
+ Tile_X0Y1_DSP_bot.Inst_DSP_bot_ConfigMem.Inst_frame3_bit8.Q _0157_ VPWR VGND sg13g2_mux2_1
X_4464_ Tile_X0Y1_DSP_bot.Inst_DSP_bot_ConfigMem.Inst_frame0_bit20.Q Tile_X0Y1_N4END[1]
+ Tile_X0Y0_SS4END[5] Tile_X0Y1_W2END[4] Tile_X0Y1_DSP_bot.Inst_DSP_bot_switch_matrix.JS2BEG3
+ Tile_X0Y1_DSP_bot.Inst_DSP_bot_ConfigMem.Inst_frame0_bit21.Q _0223_ VPWR VGND sg13g2_mux4_1
X_3415_ VGND VPWR _1765_ _1768_ _1775_ _1774_ sg13g2_a21oi_1
X_3277_ _1643_ VPWR _1644_ VGND Tile_X0Y1_DSP_bot.Inst_DSP_bot_ConfigMem.Inst_frame1_bit29.Q
+ _1642_ sg13g2_o21ai_1
XFILLER_38_251 VPWR VGND sg13g2_fill_2
X_5016_ Tile_X0Y1_DSP_bot.Inst_DSP_bot_ConfigMem.Inst_frame9_bit28.Q _0747_ _0750_
+ _0751_ VPWR VGND sg13g2_nor3_1
X_6065_ Tile_X0Y1_FrameData[10] Tile_X0Y1_FrameStrobe[12] Tile_X0Y1_DSP_bot.Inst_DSP_bot_ConfigMem.Inst_frame12_bit10.Q
+ VPWR VGND sg13g2_dlhq_1
X_5849_ Tile_X0Y1_FrameData[2] Tile_X0Y1_FrameStrobe[5] Tile_X0Y1_DSP_bot.Inst_DSP_bot_ConfigMem.Inst_frame5_bit2.Q
+ VPWR VGND sg13g2_dlhq_1
X_5918_ Tile_X0Y1_FrameData[29] Tile_X0Y1_FrameStrobe[8] Tile_X0Y1_DSP_bot.Inst_DSP_bot_ConfigMem.Inst_frame8_bit29.Q
+ VPWR VGND sg13g2_dlhq_1
XFILLER_107_212 VPWR VGND sg13g2_fill_2
XFILLER_73_8 VPWR VGND sg13g2_fill_2
X_3200_ _1572_ Tile_X0Y0_DSP_top.Inst_DSP_top_ConfigMem.Inst_frame4_bit20.Q Tile_X0Y0_W1END[2]
+ VPWR VGND sg13g2_nand2b_1
X_4180_ _2423_ Tile_X0Y1_DSP_bot.Inst_DSP_bot_ConfigMem.Inst_frame9_bit5.Q _1868_
+ VPWR VGND sg13g2_nand2_1
X_3131_ _1436_ _1445_ _1158_ _1506_ VPWR VGND sg13g2_nand3_1
X_3062_ _1439_ _0869_ _0608_ VPWR VGND sg13g2_nand2b_1
X_3964_ _2254_ _2255_ Tile_X0Y0_DSP_top.Inst_DSP_top_ConfigMem.Inst_frame10_bit0.Q
+ _2256_ VPWR VGND sg13g2_mux2_1
X_3895_ Tile_X0Y0_DSP_top.Inst_DSP_top_ConfigMem.Inst_frame10_bit16.Q Tile_X0Y0_S2END[1]
+ Tile_X0Y0_S4END[0] Tile_X0Y0_W6END[0] Tile_X0Y0_DSP_top.Inst_DSP_top_switch_matrix.bot2top3
+ Tile_X0Y0_DSP_top.Inst_DSP_top_ConfigMem.Inst_frame10_bit17.Q Tile_X0Y0_DSP_top.Inst_DSP_top_switch_matrix.S4BEG3
+ VPWR VGND sg13g2_mux4_1
X_5703_ Tile_X0Y1_FrameData[20] Tile_X0Y1_FrameStrobe[1] Tile_X0Y1_DSP_bot.Inst_DSP_bot_ConfigMem.Inst_frame1_bit20.Q
+ VPWR VGND sg13g2_dlhq_1
X_2915_ _1292_ VPWR _1293_ VGND Tile_X0Y1_DSP_bot.Inst_DSP_bot_ConfigMem.Inst_frame9_bit30.Q
+ _1290_ sg13g2_o21ai_1
X_2777_ Tile_X0Y0_DSP_top.Inst_DSP_top_ConfigMem.Inst_frame2_bit24.Q Tile_X0Y0_DSP_top.Inst_DSP_top_switch_matrix.bot2top0
+ Tile_X0Y0_DSP_top.Inst_DSP_top_switch_matrix.bot2top1 Tile_X0Y0_DSP_top.Inst_DSP_top_switch_matrix.bot2top2
+ Tile_X0Y0_DSP_top.Inst_DSP_top_switch_matrix.bot2top3 Tile_X0Y0_DSP_top.Inst_DSP_top_ConfigMem.Inst_frame2_bit25.Q
+ _1159_ VPWR VGND sg13g2_mux4_1
X_5565_ Tile_X0Y0_FrameData[16] Tile_X0Y1_FrameStrobe[11] Tile_X0Y0_DSP_top.Inst_DSP_top_ConfigMem.Inst_frame11_bit16.Q
+ VPWR VGND sg13g2_dlhq_1
X_5496_ Tile_X0Y0_FrameData[21] Tile_X0Y1_FrameStrobe[9] Tile_X0Y0_DSP_top.Inst_DSP_top_ConfigMem.Inst_frame9_bit21.Q
+ VPWR VGND sg13g2_dlhq_1
X_2846_ _1226_ _1224_ _1225_ VPWR VGND sg13g2_nand2_1
X_5634_ _2506_ VGND VPWR Tile_X0Y1_DSP_bot.B2 Tile_X0Y1_DSP_bot.Inst_MULADD.B_reg\[2\]
+ clknet_3_0_0_Tile_X0Y1_UserCLK_regs sg13g2_dfrbpq_1
X_4516_ Tile_X0Y0_DSP_top.Inst_DSP_top_switch_matrix.N2BEGb1 _0271_ _0273_ _0269_
+ _0262_ VPWR VGND sg13g2_a22oi_1
X_4447_ VGND VPWR _0206_ _0207_ _0208_ _0198_ sg13g2_a21oi_1
X_4378_ Tile_X0Y0_DSP_top.Inst_DSP_top_ConfigMem.Inst_frame2_bit4.Q Tile_X0Y0_DSP_top.Inst_DSP_top_switch_matrix.bot2top0
+ Tile_X0Y0_DSP_top.Inst_DSP_top_switch_matrix.bot2top2 Tile_X0Y0_DSP_top.Inst_DSP_top_switch_matrix.bot2top3
+ Tile_X0Y0_DSP_top.Inst_DSP_top_switch_matrix.bot2top4 Tile_X0Y0_DSP_top.Inst_DSP_top_ConfigMem.Inst_frame2_bit5.Q
+ _0141_ VPWR VGND sg13g2_mux4_1
X_3329_ _1690_ _1692_ _1693_ VPWR VGND sg13g2_nor2_1
X_6117_ VPWR VGND _2515_ sg13g2_tiehi
XFILLER_26_210 VPWR VGND sg13g2_decap_8
X_6048_ Tile_X0Y1_FrameData[27] Tile_X0Y1_FrameStrobe[12] Tile_X0Y1_DSP_bot.Inst_DSP_bot_ConfigMem.Inst_frame12_bit27.Q
+ VPWR VGND sg13g2_dlhq_1
XFILLER_41_246 VPWR VGND sg13g2_fill_2
XFILLER_94_86 VPWR VGND sg13g2_fill_2
X_5350_ Tile_X0Y0_FrameData[7] Tile_X0Y1_FrameStrobe[4] Tile_X0Y0_DSP_top.Inst_DSP_top_ConfigMem.Inst_frame4_bit7.Q
+ VPWR VGND sg13g2_dlhq_1
X_2562_ Tile_X0Y0_DSP_top.Inst_DSP_top_ConfigMem.Inst_frame4_bit12.Q Tile_X0Y0_E6END[0]
+ Tile_X0Y0_S2END[4] Tile_X0Y0_W2END[4] Tile_X0Y0_W6END[0] Tile_X0Y0_DSP_top.Inst_DSP_top_ConfigMem.Inst_frame4_bit13.Q
+ _0953_ VPWR VGND sg13g2_mux4_1
X_3680_ Tile_X0Y0_DSP_top.Inst_DSP_top_ConfigMem.Inst_frame8_bit22.Q _2015_ _2016_
+ VPWR VGND sg13g2_nor2_1
X_2700_ _1083_ _1082_ _1085_ VPWR VGND sg13g2_xor2_1
X_2631_ VPWR _1019_ _1018_ VGND sg13g2_inv_1
X_5281_ Tile_X0Y0_FrameData[12] Tile_X0Y1_FrameStrobe[2] Tile_X0Y0_DSP_top.Inst_DSP_top_ConfigMem.Inst_frame2_bit12.Q
+ VPWR VGND sg13g2_dlhq_1
X_4301_ VPWR _0064_ Tile_X0Y0_DSP_top.Inst_DSP_top_ConfigMem.Inst_frame7_bit13.Q VGND
+ sg13g2_inv_1
XFILLER_4_191 VPWR VGND sg13g2_fill_1
XFILLER_4_73 VPWR VGND sg13g2_fill_1
X_4163_ Tile_X0Y1_DSP_bot.Inst_DSP_bot_ConfigMem.Inst_frame11_bit29.Q VPWR _2412_
+ VGND _2406_ _2409_ sg13g2_o21ai_1
X_4232_ Tile_X0Y1_DSP_bot.Inst_DSP_bot_ConfigMem.Inst_frame8_bit29.Q Tile_X0Y1_W2MID[0]
+ Tile_X0Y0_DSP_top.Inst_DSP_top_switch_matrix.N2BEGb3 Tile_X0Y0_DSP_top.Inst_DSP_top_switch_matrix.N2BEGb2
+ Tile_X0Y1_DSP_bot.Inst_DSP_bot_switch_matrix.E2BEG2 Tile_X0Y1_DSP_bot.Inst_DSP_bot_ConfigMem.Inst_frame8_bit28.Q
+ _2470_ VPWR VGND sg13g2_mux4_1
XFILLER_82_157 VPWR VGND sg13g2_fill_2
XFILLER_82_135 VPWR VGND sg13g2_fill_1
X_3114_ Tile_X0Y0_S2MID[1] Tile_X0Y0_W2MID[1] Tile_X0Y0_DSP_top.Inst_DSP_top_ConfigMem.Inst_frame6_bit22.Q
+ _1490_ VPWR VGND sg13g2_mux2_1
XFILLER_55_305 VPWR VGND sg13g2_fill_2
X_3045_ VGND VPWR _1420_ _1421_ _1422_ _1414_ sg13g2_a21oi_1
X_4094_ Tile_X0Y1_E2END[1] Tile_X0Y1_E6END[1] Tile_X0Y1_DSP_bot.Inst_DSP_bot_ConfigMem.Inst_frame2_bit0.Q
+ _2356_ VPWR VGND sg13g2_mux2_1
X_3878_ Tile_X0Y0_DSP_top.Inst_DSP_top_ConfigMem.Inst_frame4_bit0.Q Tile_X0Y1_N2MID[1]
+ _2191_ VPWR VGND sg13g2_nor2b_1
X_3947_ Tile_X0Y0_DSP_top.Inst_DSP_top_ConfigMem.Inst_frame11_bit22.Q VPWR _2242_
+ VGND Tile_X0Y0_DSP_top.Inst_DSP_top_ConfigMem.Inst_frame11_bit21.Q _2241_ sg13g2_o21ai_1
X_4996_ Tile_X0Y1_DSP_bot.Inst_DSP_bot_ConfigMem.Inst_frame8_bit4.Q VPWR _0732_ VGND
+ Tile_X0Y1_DSP_bot.Inst_DSP_bot_ConfigMem.Inst_frame0_bit15.Q _0731_ sg13g2_o21ai_1
X_5548_ Tile_X0Y0_FrameData[1] Tile_X0Y1_FrameStrobe[10] Tile_X0Y0_DSP_top.Inst_DSP_top_ConfigMem.Inst_frame10_bit1.Q
+ VPWR VGND sg13g2_dlhq_1
X_5617_ _2478_ VGND VPWR _0013_ Tile_X0Y1_DSP_bot.Inst_MULADD.ACC\[13\] clknet_3_5_0_Tile_X0Y1_UserCLK_regs
+ sg13g2_dfrbpq_1
X_5479_ Tile_X0Y0_FrameData[6] Tile_X0Y1_FrameStrobe[8] Tile_X0Y0_DSP_top.Inst_DSP_top_ConfigMem.Inst_frame8_bit6.Q
+ VPWR VGND sg13g2_dlhq_1
X_2829_ _1206_ VPWR _1209_ VGND _1207_ _1208_ sg13g2_o21ai_1
XFILLER_2_106 VPWR VGND sg13g2_fill_1
XFILLER_54_360 VPWR VGND sg13g2_fill_1
XFILLER_96_238 VPWR VGND sg13g2_fill_1
XFILLER_43_9 VPWR VGND sg13g2_fill_1
XFILLER_45_360 VPWR VGND sg13g2_fill_1
X_3732_ _0114_ _0406_ Tile_X0Y0_DSP_top.Inst_DSP_top_switch_matrix.JS2BEG4 Tile_X0Y0_DSP_top.Inst_DSP_top_switch_matrix.JW2BEG6
+ Tile_X0Y0_DSP_top.Inst_DSP_top_switch_matrix.JS2BEG6 Tile_X0Y0_DSP_top.Inst_DSP_top_ConfigMem.Inst_frame8_bit26.Q
+ _2063_ VPWR VGND sg13g2_mux4_1
X_4781_ _0526_ _0049_ Tile_X0Y0_DSP_top.Inst_DSP_top_ConfigMem.Inst_frame7_bit8.Q
+ VPWR VGND sg13g2_nand2_1
X_3801_ _2128_ _2072_ _2127_ VPWR VGND sg13g2_nand2_1
X_4850_ _0592_ VPWR _0593_ VGND Tile_X0Y0_DSP_top.Inst_DSP_top_ConfigMem.Inst_frame1_bit4.Q
+ Tile_X0Y0_S2END[2] sg13g2_o21ai_1
X_6451_ Tile_X0Y0_SS4END[10] Tile_X0Y1_SS4BEG[2] VPWR VGND sg13g2_buf_1
X_5333_ Tile_X0Y0_FrameData[24] Tile_X0Y1_FrameStrobe[4] Tile_X0Y0_DSP_top.Inst_DSP_top_ConfigMem.Inst_frame4_bit24.Q
+ VPWR VGND sg13g2_dlhq_1
X_5402_ Tile_X0Y0_FrameData[19] Tile_X0Y1_FrameStrobe[6] Tile_X0Y0_DSP_top.Inst_DSP_top_ConfigMem.Inst_frame6_bit19.Q
+ VPWR VGND sg13g2_dlhq_1
X_2545_ Tile_X0Y0_DSP_top.Inst_DSP_top_ConfigMem.Inst_frame6_bit10.Q Tile_X0Y0_DSP_top.Inst_DSP_top_switch_matrix.N2BEGb3
+ Tile_X0Y0_E2MID[3] Tile_X0Y0_S2MID[3] Tile_X0Y0_W2MID[3] Tile_X0Y0_DSP_top.Inst_DSP_top_ConfigMem.Inst_frame6_bit11.Q
+ _0937_ VPWR VGND sg13g2_mux4_1
X_3663_ _1999_ VPWR Tile_X0Y0_DSP_top.Inst_DSP_top_switch_matrix.bot2top5 VGND Tile_X0Y1_DSP_bot.Inst_DSP_bot_ConfigMem.Inst_frame12_bit5.Q
+ _1998_ sg13g2_o21ai_1
X_2614_ _1002_ _0974_ _0998_ VPWR VGND sg13g2_xnor2_1
XFILLER_55_0 VPWR VGND sg13g2_decap_8
X_6382_ Tile_X0Y1_FrameData[1] Tile_X0Y1_FrameData_O[1] VPWR VGND sg13g2_buf_1
X_3594_ _1945_ Tile_X0Y1_DSP_bot.Inst_MULADD.ACC\[2\] Tile_X0Y1_DSP_bot.Inst_DSP_bot_ConfigMem.Inst_frame12_bit5.Q
+ VPWR VGND sg13g2_nand2_1
X_5195_ _0909_ _0920_ Tile_X0Y0_DSP_top.Inst_DSP_top_switch_matrix.E2BEG4 VPWR VGND
+ sg13g2_nor2_1
X_5264_ Tile_X0Y0_FrameData[29] Tile_X0Y1_FrameStrobe[2] Tile_X0Y0_DSP_top.Inst_DSP_top_ConfigMem.Inst_frame2_bit29.Q
+ VPWR VGND sg13g2_dlhq_1
X_4146_ VPWR _2396_ _2395_ VGND sg13g2_inv_1
X_4215_ VGND VPWR Tile_X0Y1_DSP_bot.Inst_DSP_bot_ConfigMem.Inst_frame9_bit18.Q _1784_
+ _2454_ _2453_ sg13g2_a21oi_1
X_3028_ _1076_ _1307_ _1405_ VPWR VGND sg13g2_and2_1
XFILLER_36_360 VPWR VGND sg13g2_fill_1
X_4077_ Tile_X0Y1_DSP_bot.Inst_DSP_bot_ConfigMem.Inst_frame10_bit0.Q Tile_X0Y1_DSP_bot.Inst_DSP_bot_switch_matrix.Q5
+ _0209_ Tile_X0Y1_DSP_bot.Inst_DSP_bot_switch_matrix.E2BEG0 _0223_ Tile_X0Y1_DSP_bot.Inst_DSP_bot_ConfigMem.Inst_frame10_bit1.Q
+ Tile_X0Y1_DSP_bot.Inst_DSP_bot_switch_matrix.S1BEG1 VPWR VGND sg13g2_mux4_1
X_4979_ Tile_X0Y0_DSP_top.Inst_DSP_top_ConfigMem.Inst_frame2_bit0.Q Tile_X0Y1_NN4END[5]
+ Tile_X0Y0_E1END[3] Tile_X0Y0_E2END[1] Tile_X0Y0_E6END[1] Tile_X0Y0_DSP_top.Inst_DSP_top_ConfigMem.Inst_frame2_bit1.Q
+ _0716_ VPWR VGND sg13g2_mux4_1
XFILLER_50_36 VPWR VGND sg13g2_fill_1
XFILLER_59_67 VPWR VGND sg13g2_fill_1
XFILLER_46_146 VPWR VGND sg13g2_fill_1
XFILLER_24_70 VPWR VGND sg13g2_fill_2
X_4000_ Tile_X0Y0_DSP_top.Inst_DSP_top_ConfigMem.Inst_frame9_bit6.Q Tile_X0Y0_DSP_top.Inst_DSP_top_switch_matrix.bot2top6
+ _2287_ VPWR VGND sg13g2_nor2_1
XFILLER_69_216 VPWR VGND sg13g2_fill_2
X_4902_ _0057_ _0636_ _0642_ VPWR VGND sg13g2_nor2_1
X_5882_ Tile_X0Y1_FrameData[1] Tile_X0Y1_FrameStrobe[6] Tile_X0Y1_DSP_bot.Inst_DSP_bot_ConfigMem.Inst_frame6_bit1.Q
+ VPWR VGND sg13g2_dlhq_1
XFILLER_18_360 VPWR VGND sg13g2_fill_1
X_5951_ Tile_X0Y1_FrameData[28] Tile_X0Y1_FrameStrobe[9] Tile_X0Y1_DSP_bot.Inst_DSP_bot_ConfigMem.Inst_frame9_bit28.Q
+ VPWR VGND sg13g2_dlhq_1
X_6434_ Tile_X0Y0_S4END[9] Tile_X0Y1_S4BEG[1] VPWR VGND sg13g2_buf_1
X_4764_ VGND VPWR Tile_X0Y0_DSP_top.Inst_DSP_top_ConfigMem.Inst_frame4_bit10.Q _0509_
+ _0510_ Tile_X0Y0_DSP_top.Inst_DSP_top_ConfigMem.Inst_frame4_bit11.Q sg13g2_a21oi_1
X_3715_ Tile_X0Y0_DSP_top.Inst_DSP_top_ConfigMem.Inst_frame6_bit31.Q Tile_X0Y0_DSP_top.Inst_DSP_top_switch_matrix.N2BEGb1
+ Tile_X0Y0_S2MID[1] Tile_X0Y0_E2MID[1] Tile_X0Y0_W2MID[1] Tile_X0Y0_DSP_top.Inst_DSP_top_ConfigMem.Inst_frame6_bit30.Q
+ _2048_ VPWR VGND sg13g2_mux4_1
X_4833_ Tile_X0Y0_DSP_top.Inst_DSP_top_ConfigMem.Inst_frame8_bit0.Q VPWR _0576_ VGND
+ Tile_X0Y0_DSP_top.Inst_DSP_top_ConfigMem.Inst_frame6_bit7.Q _0574_ sg13g2_o21ai_1
X_4695_ _0314_ _0444_ _0445_ VPWR VGND sg13g2_and2_1
X_6503_ Tile_X0Y1_WW4END[10] Tile_X0Y1_WW4BEG[6] VPWR VGND sg13g2_buf_1
XFILLER_102_346 VPWR VGND sg13g2_fill_1
X_5316_ Tile_X0Y0_FrameData[9] Tile_X0Y1_FrameStrobe[3] Tile_X0Y0_DSP_top.Inst_DSP_top_ConfigMem.Inst_frame3_bit9.Q
+ VPWR VGND sg13g2_dlhq_1
X_3646_ _1983_ VPWR _1984_ VGND Tile_X0Y0_DSP_top.Inst_DSP_top_ConfigMem.Inst_frame8_bit20.Q
+ _1982_ sg13g2_o21ai_1
X_5247_ Tile_X0Y0_FrameData[14] Tile_X0Y1_FrameStrobe[1] Tile_X0Y0_DSP_top.Inst_DSP_top_ConfigMem.Inst_frame1_bit14.Q
+ VPWR VGND sg13g2_dlhq_1
X_6296_ Tile_X0Y0_W2END[7] Tile_X0Y0_W2BEG[7] VPWR VGND sg13g2_buf_1
X_3577_ _1929_ _1777_ _1779_ VPWR VGND sg13g2_xnor2_1
X_6365_ Tile_X0Y1_EE4END[4] Tile_X0Y1_EE4BEG[0] VPWR VGND sg13g2_buf_1
X_5178_ _0818_ _0901_ _0904_ VPWR VGND sg13g2_nor2_1
XFILLER_28_179 VPWR VGND sg13g2_decap_8
X_4129_ _2381_ VPWR _2382_ VGND Tile_X0Y1_DSP_bot.Inst_DSP_bot_ConfigMem.Inst_frame11_bit13.Q
+ Tile_X0Y1_DSP_bot.Inst_DSP_bot_switch_matrix.Q7 sg13g2_o21ai_1
XFILLER_51_160 VPWR VGND sg13g2_fill_2
XFILLER_74_252 VPWR VGND sg13g2_fill_2
XFILLER_19_168 VPWR VGND sg13g2_fill_2
X_3500_ _1855_ VPWR _1856_ VGND Tile_X0Y1_N2MID[1] Tile_X0Y1_DSP_bot.Inst_DSP_bot_ConfigMem.Inst_frame6_bit22.Q
+ sg13g2_o21ai_1
X_4480_ VGND VPWR Tile_X0Y1_N2MID[5] Tile_X0Y0_DSP_top.Inst_DSP_top_ConfigMem.Inst_frame4_bit16.Q
+ _0239_ Tile_X0Y0_DSP_top.Inst_DSP_top_ConfigMem.Inst_frame4_bit17.Q sg13g2_a21oi_1
X_6150_ Tile_X0Y0_E2MID[6] Tile_X0Y0_E2BEGb[6] VPWR VGND sg13g2_buf_1
X_5101_ _0830_ Tile_X0Y0_DSP_top.Inst_DSP_top_ConfigMem.Inst_frame2_bit9.Q _0831_
+ _0832_ VPWR VGND sg13g2_a21o_1
X_3362_ VGND VPWR Tile_X0Y1_DSP_bot.Inst_DSP_bot_ConfigMem.Inst_frame1_bit24.Q _0131_
+ _1725_ _1724_ sg13g2_a21oi_1
X_3431_ _1781_ VPWR _1789_ VGND Tile_X0Y1_DSP_bot.Inst_DSP_bot_ConfigMem.Inst_frame12_bit3.Q
+ _1788_ sg13g2_o21ai_1
X_6081_ VPWR VGND _2479_ sg13g2_tiehi
XFILLER_57_208 VPWR VGND sg13g2_fill_2
X_3293_ _1660_ Tile_X0Y1_DSP_bot.Inst_DSP_bot_ConfigMem.Inst_frame2_bit28.Q _0125_
+ VPWR VGND sg13g2_nand2_1
X_5032_ _0765_ Tile_X0Y1_DSP_bot.Inst_DSP_bot_ConfigMem.Inst_frame1_bit5.Q _0766_
+ _0767_ VPWR VGND sg13g2_a21o_1
XFILLER_18_0 VPWR VGND sg13g2_fill_2
X_4816_ Tile_X0Y0_DSP_top.Inst_DSP_top_ConfigMem.Inst_frame1_bit12.Q Tile_X0Y0_DSP_top.Inst_DSP_top_switch_matrix.bot2top5
+ _0559_ VPWR VGND sg13g2_nor2b_1
X_5865_ Tile_X0Y1_FrameData[18] Tile_X0Y1_FrameStrobe[6] Tile_X0Y1_DSP_bot.Inst_DSP_bot_ConfigMem.Inst_frame6_bit18.Q
+ VPWR VGND sg13g2_dlhq_1
XFILLER_33_160 VPWR VGND sg13g2_fill_1
X_5934_ Tile_X0Y1_FrameData[13] Tile_X0Y1_FrameStrobe[8] Tile_X0Y1_DSP_bot.Inst_DSP_bot_ConfigMem.Inst_frame8_bit13.Q
+ VPWR VGND sg13g2_dlhq_1
X_3629_ Tile_X0Y0_DSP_top.Inst_DSP_top_ConfigMem.Inst_frame3_bit25.Q Tile_X0Y0_DSP_top.Inst_DSP_top_switch_matrix.bot2top4
+ Tile_X0Y0_DSP_top.Inst_DSP_top_switch_matrix.bot2top7 Tile_X0Y0_DSP_top.Inst_DSP_top_switch_matrix.bot2top5
+ Tile_X0Y0_DSP_top.Inst_DSP_top_switch_matrix.bot2top8 Tile_X0Y0_DSP_top.Inst_DSP_top_ConfigMem.Inst_frame3_bit24.Q
+ _1968_ VPWR VGND sg13g2_mux4_1
X_4747_ _0493_ _0072_ Tile_X0Y0_DSP_top.Inst_DSP_top_switch_matrix.inst_cus_mux41_buf_top2bot12.X
+ VPWR VGND sg13g2_nand2b_1
X_5796_ Tile_X0Y1_FrameData[23] Tile_X0Y1_FrameStrobe[4] Tile_X0Y1_DSP_bot.Inst_DSP_bot_ConfigMem.Inst_frame4_bit23.Q
+ VPWR VGND sg13g2_dlhq_1
X_4678_ Tile_X0Y1_DSP_bot.Inst_DSP_bot_ConfigMem.Inst_frame4_bit21.Q Tile_X0Y1_N1END[2]
+ Tile_X0Y1_E1END[2] Tile_X0Y1_N2END[6] Tile_X0Y1_E2END[6] Tile_X0Y1_DSP_bot.Inst_DSP_bot_ConfigMem.Inst_frame4_bit20.Q
+ _0429_ VPWR VGND sg13g2_mux4_1
X_6417_ Tile_X0Y1_DSP_bot.Inst_DSP_bot_switch_matrix.JS2BEG0 Tile_X0Y1_S2BEG[0] VPWR
+ VGND sg13g2_buf_1
X_6279_ Tile_X0Y0_DSP_top.NN4BEG_outbuf_11.A Tile_X0Y0_NN4BEG[11] VPWR VGND sg13g2_buf_1
XFILLER_88_333 VPWR VGND sg13g2_fill_2
X_6348_ Tile_X0Y1_E2MID[3] Tile_X0Y1_E2BEGb[3] VPWR VGND sg13g2_buf_1
XFILLER_56_263 VPWR VGND sg13g2_fill_1
XFILLER_98_108 VPWR VGND sg13g2_fill_2
XFILLER_94_358 VPWR VGND sg13g2_fill_2
XFILLER_47_241 VPWR VGND sg13g2_decap_8
X_3980_ _2269_ VPWR _2270_ VGND _0121_ _0679_ sg13g2_o21ai_1
X_5650_ _2522_ VGND VPWR Tile_X0Y0_DSP_top.Inst_DSP_top_switch_matrix.inst_cus_mux41_buf_top2bot8.X
+ Tile_X0Y1_DSP_bot.Inst_MULADD.C_reg\[10\] clknet_3_5_0_Tile_X0Y1_UserCLK_regs sg13g2_dfrbpq_1
XFILLER_62_299 VPWR VGND sg13g2_fill_2
XFILLER_62_277 VPWR VGND sg13g2_fill_1
X_2931_ _1306_ VPWR _1308_ VGND Tile_X0Y1_DSP_bot.Inst_DSP_bot_ConfigMem.Inst_frame12_bit1.Q
+ Tile_X0Y1_DSP_bot.B0 sg13g2_o21ai_1
XFILLER_22_108 VPWR VGND sg13g2_fill_1
X_2793_ _1163_ _1174_ Tile_X0Y0_DSP_top.Inst_DSP_top_switch_matrix.JS2BEG6 VPWR VGND
+ sg13g2_nor2_1
X_5581_ Tile_X0Y0_FrameData[0] Tile_X0Y1_FrameStrobe[11] Tile_X0Y0_DSP_top.Inst_DSP_top_ConfigMem.Inst_frame11_bit0.Q
+ VPWR VGND sg13g2_dlhq_1
X_4601_ Tile_X0Y0_DSP_top.Inst_DSP_top_ConfigMem.Inst_frame4_bit7.Q _0353_ _0355_
+ VPWR VGND sg13g2_nor2_1
X_2862_ Tile_X0Y1_W1END[1] Tile_X0Y1_DSP_bot.Inst_DSP_bot_ConfigMem.Inst_frame3_bit16.Q
+ _1242_ VPWR VGND sg13g2_nor2b_1
X_4532_ Tile_X0Y1_DSP_bot.Inst_DSP_bot_ConfigMem.Inst_frame6_bit4.Q Tile_X0Y1_N2MID[5]
+ Tile_X0Y1_E2MID[5] Tile_X0Y0_DSP_top.Inst_DSP_top_switch_matrix.JS2BEG5 Tile_X0Y1_W2MID[5]
+ Tile_X0Y1_DSP_bot.Inst_DSP_bot_ConfigMem.Inst_frame6_bit5.Q _0288_ VPWR VGND sg13g2_mux4_1
X_4463_ Tile_X0Y1_DSP_bot.Inst_DSP_bot_switch_matrix.JS2BEG3 _0221_ _0222_ _0218_
+ _0211_ VPWR VGND sg13g2_a22oi_1
X_6202_ Tile_X0Y0_FrameData[22] Tile_X0Y0_FrameData_O[22] VPWR VGND sg13g2_buf_1
X_6133_ Tile_X0Y0_DSP_top.Inst_DSP_top_switch_matrix.E1BEG1 Tile_X0Y0_E1BEG[1] VPWR
+ VGND sg13g2_buf_1
X_3345_ Tile_X0Y1_DSP_bot.Inst_DSP_bot_ConfigMem.Inst_frame3_bit26.Q _1708_ _1709_
+ VPWR VGND sg13g2_nor2_1
X_3276_ VGND VPWR Tile_X0Y1_DSP_bot.Inst_DSP_bot_ConfigMem.Inst_frame1_bit29.Q _1640_
+ _1643_ Tile_X0Y1_DSP_bot.Inst_DSP_bot_ConfigMem.Inst_frame1_bit30.Q sg13g2_a21oi_1
X_4394_ _0156_ Tile_X0Y1_DSP_bot.Inst_DSP_bot_ConfigMem.Inst_frame3_bit9.Q _0155_
+ VPWR VGND sg13g2_nand2_1
X_6064_ Tile_X0Y1_FrameData[11] Tile_X0Y1_FrameStrobe[12] Tile_X0Y1_DSP_bot.Inst_DSP_bot_ConfigMem.Inst_frame12_bit11.Q
+ VPWR VGND sg13g2_dlhq_1
X_3414_ _1770_ _1773_ _1774_ VPWR VGND sg13g2_nor2_1
XFILLER_97_196 VPWR VGND sg13g2_decap_4
XFILLER_53_255 VPWR VGND sg13g2_fill_2
X_5015_ Tile_X0Y1_DSP_bot.Inst_DSP_bot_ConfigMem.Inst_frame7_bit7.Q _0748_ _0749_
+ _0750_ VPWR VGND sg13g2_nor3_1
XFILLER_53_288 VPWR VGND sg13g2_fill_1
X_5779_ Tile_X0Y1_FrameData[8] Tile_X0Y1_FrameStrobe[3] Tile_X0Y1_DSP_bot.Inst_DSP_bot_ConfigMem.Inst_frame3_bit8.Q
+ VPWR VGND sg13g2_dlhq_1
X_5848_ Tile_X0Y1_FrameData[3] Tile_X0Y1_FrameStrobe[5] Tile_X0Y1_DSP_bot.Inst_DSP_bot_ConfigMem.Inst_frame5_bit3.Q
+ VPWR VGND sg13g2_dlhq_1
XFILLER_13_108 VPWR VGND sg13g2_fill_1
XFILLER_21_174 VPWR VGND sg13g2_fill_2
X_5917_ Tile_X0Y1_FrameData[30] Tile_X0Y1_FrameStrobe[8] Tile_X0Y1_DSP_bot.Inst_DSP_bot_ConfigMem.Inst_frame8_bit30.Q
+ VPWR VGND sg13g2_dlhq_1
XFILLER_107_96 VPWR VGND sg13g2_fill_1
X_3130_ VPWR _1505_ _1504_ VGND sg13g2_inv_1
XFILLER_67_358 VPWR VGND sg13g2_fill_2
X_3061_ _0608_ _0816_ _1438_ VPWR VGND sg13g2_nor2_1
X_3963_ Tile_X0Y0_DSP_top.Inst_DSP_top_ConfigMem.Inst_frame11_bit30.Q _0679_ _0860_
+ _1510_ _2015_ Tile_X0Y0_DSP_top.Inst_DSP_top_ConfigMem.Inst_frame11_bit31.Q _2255_
+ VPWR VGND sg13g2_mux4_1
X_3894_ Tile_X0Y0_DSP_top.Inst_DSP_top_ConfigMem.Inst_frame10_bit15.Q Tile_X0Y0_S2END[0]
+ Tile_X0Y0_W6END[1] Tile_X0Y0_S4END[3] Tile_X0Y0_DSP_top.Inst_DSP_top_switch_matrix.bot2top2
+ Tile_X0Y0_DSP_top.Inst_DSP_top_ConfigMem.Inst_frame10_bit14.Q Tile_X0Y0_DSP_top.Inst_DSP_top_switch_matrix.S4BEG2
+ VPWR VGND sg13g2_mux4_1
X_2845_ _1225_ _1216_ _1218_ VPWR VGND sg13g2_xnor2_1
X_5702_ Tile_X0Y1_FrameData[21] Tile_X0Y1_FrameStrobe[1] Tile_X0Y1_DSP_bot.Inst_DSP_bot_ConfigMem.Inst_frame1_bit21.Q
+ VPWR VGND sg13g2_dlhq_1
X_5633_ _2505_ VGND VPWR Tile_X0Y1_DSP_bot.B1 Tile_X0Y1_DSP_bot.Inst_MULADD.B_reg\[1\]
+ clknet_3_1_0_Tile_X0Y1_UserCLK_regs sg13g2_dfrbpq_1
X_2914_ VPWR _1292_ _1291_ VGND sg13g2_inv_1
X_5564_ Tile_X0Y0_FrameData[17] Tile_X0Y1_FrameStrobe[11] Tile_X0Y0_DSP_top.Inst_DSP_top_ConfigMem.Inst_frame11_bit17.Q
+ VPWR VGND sg13g2_dlhq_1
X_4446_ _0200_ Tile_X0Y0_DSP_top.Inst_DSP_top_ConfigMem.Inst_frame2_bit31.Q _0207_
+ VPWR VGND sg13g2_nor2b_1
X_5495_ Tile_X0Y0_FrameData[22] Tile_X0Y1_FrameStrobe[9] Tile_X0Y0_DSP_top.Inst_DSP_top_ConfigMem.Inst_frame9_bit22.Q
+ VPWR VGND sg13g2_dlhq_1
X_2776_ _1158_ _1142_ _1157_ VPWR VGND sg13g2_nand2_1
X_4515_ VGND VPWR Tile_X0Y1_DSP_bot.Inst_DSP_bot_ConfigMem.Inst_frame4_bit6.Q _0272_
+ _0273_ Tile_X0Y1_DSP_bot.Inst_DSP_bot_ConfigMem.Inst_frame4_bit7.Q sg13g2_a21oi_1
X_4377_ Tile_X0Y0_DSP_top.Inst_DSP_top_ConfigMem.Inst_frame2_bit4.Q Tile_X0Y0_DSP_top.Inst_DSP_top_switch_matrix.bot2top5
+ Tile_X0Y0_DSP_top.Inst_DSP_top_switch_matrix.bot2top6 Tile_X0Y0_DSP_top.Inst_DSP_top_switch_matrix.bot2top7
+ Tile_X0Y0_DSP_top.Inst_DSP_top_switch_matrix.bot2top8 Tile_X0Y0_DSP_top.Inst_DSP_top_ConfigMem.Inst_frame2_bit5.Q
+ _0140_ VPWR VGND sg13g2_mux4_1
X_3328_ _1430_ _1691_ _1692_ VPWR VGND sg13g2_and2_1
X_3259_ Tile_X0Y1_DSP_bot.Inst_DSP_bot_ConfigMem.Inst_frame1_bit22.Q _1626_ _1627_
+ VPWR VGND sg13g2_nor2_1
X_6047_ Tile_X0Y1_FrameData[28] Tile_X0Y1_FrameStrobe[12] Tile_X0Y1_DSP_bot.Inst_DSP_bot_ConfigMem.Inst_frame12_bit28.Q
+ VPWR VGND sg13g2_dlhq_1
X_6116_ VPWR VGND _2514_ sg13g2_tiehi
XFILLER_91_158 VPWR VGND sg13g2_decap_8
XFILLER_76_177 VPWR VGND sg13g2_fill_1
X_4300_ VPWR _0063_ Tile_X0Y0_DSP_top.Inst_DSP_top_ConfigMem.Inst_frame2_bit18.Q VGND
+ sg13g2_inv_1
XFILLER_99_225 VPWR VGND sg13g2_fill_2
X_2561_ Tile_X0Y0_DSP_top.Inst_DSP_top_ConfigMem.Inst_frame4_bit12.Q Tile_X0Y1_N2MID[4]
+ Tile_X0Y1_N4END[4] Tile_X0Y0_E1END[2] Tile_X0Y0_E2END[4] Tile_X0Y0_DSP_top.Inst_DSP_top_ConfigMem.Inst_frame4_bit13.Q
+ _0952_ VPWR VGND sg13g2_mux4_1
X_5280_ Tile_X0Y0_FrameData[13] Tile_X0Y1_FrameStrobe[2] Tile_X0Y0_DSP_top.Inst_DSP_top_ConfigMem.Inst_frame2_bit13.Q
+ VPWR VGND sg13g2_dlhq_1
X_2630_ Tile_X0Y1_DSP_bot.Inst_DSP_bot_ConfigMem.Inst_frame6_bit2.Q _0034_ _0080_
+ _0634_ _0081_ Tile_X0Y1_DSP_bot.Inst_DSP_bot_ConfigMem.Inst_frame6_bit3.Q _1018_
+ VPWR VGND sg13g2_mux4_1
XFILLER_99_258 VPWR VGND sg13g2_fill_2
X_3113_ _1488_ VPWR _1489_ VGND Tile_X0Y0_DSP_top.Inst_DSP_top_ConfigMem.Inst_frame6_bit22.Q
+ Tile_X0Y0_DSP_top.Inst_DSP_top_switch_matrix.N2BEGb1 sg13g2_o21ai_1
X_4093_ VGND VPWR _2355_ _2354_ _2348_ sg13g2_or2_1
X_4162_ Tile_X0Y1_DSP_bot.Inst_DSP_bot_ConfigMem.Inst_frame11_bit28.Q _2410_ _2411_
+ VPWR VGND sg13g2_nor2_1
X_4231_ Tile_X0Y1_DSP_bot.Inst_DSP_bot_ConfigMem.Inst_frame8_bit31.Q VPWR _2469_ VGND
+ _2465_ _2468_ sg13g2_o21ai_1
X_3044_ _1421_ _1412_ _1413_ VPWR VGND sg13g2_xnor2_1
X_4995_ VGND VPWR Tile_X0Y0_SS4END[4] Tile_X0Y1_DSP_bot.Inst_DSP_bot_ConfigMem.Inst_frame0_bit14.Q
+ _0731_ _0730_ sg13g2_a21oi_1
X_3877_ _2189_ VPWR _2190_ VGND Tile_X0Y0_DSP_top.Inst_DSP_top_ConfigMem.Inst_frame4_bit0.Q
+ _0052_ sg13g2_o21ai_1
X_3946_ _2240_ VPWR _2241_ VGND Tile_X0Y0_DSP_top.Inst_DSP_top_ConfigMem.Inst_frame11_bit20.Q
+ Tile_X0Y0_DSP_top.Inst_DSP_top_switch_matrix.bot2top8 sg13g2_o21ai_1
X_5616_ _2479_ VGND VPWR _0012_ Tile_X0Y1_DSP_bot.Inst_MULADD.ACC\[12\] clknet_3_7_0_Tile_X0Y1_UserCLK_regs
+ sg13g2_dfrbpq_1
X_2828_ _1208_ _1204_ _1205_ VPWR VGND sg13g2_xnor2_1
XFILLER_23_17 VPWR VGND sg13g2_fill_1
XFILLER_23_39 VPWR VGND sg13g2_fill_2
X_5547_ Tile_X0Y0_FrameData[2] Tile_X0Y1_FrameStrobe[10] Tile_X0Y0_DSP_top.Inst_DSP_top_ConfigMem.Inst_frame10_bit2.Q
+ VPWR VGND sg13g2_dlhq_1
X_2759_ VGND VPWR _1138_ _1139_ _1141_ _1137_ sg13g2_a21oi_1
X_5478_ Tile_X0Y0_FrameData[7] Tile_X0Y1_FrameStrobe[8] Tile_X0Y0_DSP_top.Inst_DSP_top_ConfigMem.Inst_frame8_bit7.Q
+ VPWR VGND sg13g2_dlhq_1
X_4429_ _0188_ VPWR _0190_ VGND Tile_X0Y1_DSP_bot.Inst_DSP_bot_ConfigMem.Inst_frame12_bit7.Q
+ _0154_ sg13g2_o21ai_1
XFILLER_100_296 VPWR VGND sg13g2_fill_1
XFILLER_58_144 VPWR VGND sg13g2_fill_2
XFILLER_48_58 VPWR VGND sg13g2_fill_2
XFILLER_108_330 VPWR VGND sg13g2_decap_8
XFILLER_49_133 VPWR VGND sg13g2_fill_1
XFILLER_72_180 VPWR VGND sg13g2_fill_2
X_6450_ Tile_X0Y0_SS4END[9] Tile_X0Y1_SS4BEG[1] VPWR VGND sg13g2_buf_1
X_3731_ _2061_ _2060_ Tile_X0Y0_DSP_top.Inst_DSP_top_ConfigMem.Inst_frame8_bit28.Q
+ _2062_ VPWR VGND sg13g2_a21o_1
X_4780_ Tile_X0Y0_W2MID[6] Tile_X0Y0_DSP_top.Inst_DSP_top_switch_matrix.JN2BEG4 Tile_X0Y0_DSP_top.Inst_DSP_top_ConfigMem.Inst_frame7_bit8.Q
+ _0525_ VPWR VGND sg13g2_mux2_1
X_3800_ _2126_ VPWR _2127_ VGND Tile_X0Y1_DSP_bot.Inst_DSP_bot_ConfigMem.Inst_frame12_bit2.Q
+ Tile_X0Y0_DSP_top.Inst_DSP_top_switch_matrix.inst_cus_mux81_buf_top2bot17.X sg13g2_o21ai_1
X_3662_ _1999_ Tile_X0Y1_DSP_bot.Inst_DSP_bot_ConfigMem.Inst_frame12_bit5.Q Tile_X0Y1_DSP_bot.Inst_MULADD.ACC\[15\]
+ VPWR VGND sg13g2_nand2_1
XFILLER_54_90 VPWR VGND sg13g2_decap_4
XFILLER_9_262 VPWR VGND sg13g2_fill_1
X_5332_ Tile_X0Y0_FrameData[25] Tile_X0Y1_FrameStrobe[4] Tile_X0Y0_DSP_top.Inst_DSP_top_ConfigMem.Inst_frame4_bit25.Q
+ VPWR VGND sg13g2_dlhq_1
X_5263_ Tile_X0Y0_FrameData[30] Tile_X0Y1_FrameStrobe[2] Tile_X0Y0_DSP_top.Inst_DSP_top_ConfigMem.Inst_frame2_bit30.Q
+ VPWR VGND sg13g2_dlhq_1
X_2544_ Tile_X0Y0_DSP_top.Inst_DSP_top_ConfigMem.Inst_frame7_bit11.Q Tile_X0Y0_DSP_top.Inst_DSP_top_switch_matrix.N2BEGb2
+ Tile_X0Y0_W2MID[2] Tile_X0Y0_E2MID[2] Tile_X0Y0_DSP_top.Inst_DSP_top_switch_matrix.E2BEG4
+ Tile_X0Y0_DSP_top.Inst_DSP_top_ConfigMem.Inst_frame7_bit10.Q _0936_ VPWR VGND sg13g2_mux4_1
X_5401_ Tile_X0Y0_FrameData[20] Tile_X0Y1_FrameStrobe[6] Tile_X0Y0_DSP_top.Inst_DSP_top_ConfigMem.Inst_frame6_bit20.Q
+ VPWR VGND sg13g2_dlhq_1
X_2613_ _0745_ _1000_ _1001_ VPWR VGND sg13g2_and2_1
XFILLER_48_0 VPWR VGND sg13g2_fill_2
X_6381_ Tile_X0Y1_FrameData[0] Tile_X0Y1_FrameData_O[0] VPWR VGND sg13g2_buf_1
X_3593_ _1918_ _1916_ _1944_ VPWR VGND sg13g2_xor2_1
X_5194_ Tile_X0Y0_DSP_top.Inst_DSP_top_ConfigMem.Inst_frame3_bit19.Q _0914_ _0919_
+ _0920_ VPWR VGND sg13g2_nor3_1
XFILLER_87_239 VPWR VGND sg13g2_fill_1
XFILLER_55_147 VPWR VGND sg13g2_fill_2
X_4145_ Tile_X0Y1_DSP_bot.Inst_DSP_bot_ConfigMem.Inst_frame11_bit22.Q _1018_ _1255_
+ _1885_ _1794_ Tile_X0Y1_DSP_bot.Inst_DSP_bot_ConfigMem.Inst_frame11_bit23.Q _2395_
+ VPWR VGND sg13g2_mux4_1
X_4076_ _2339_ VPWR Tile_X0Y1_DSP_bot.Inst_DSP_bot_switch_matrix.E2BEG0 VGND Tile_X0Y1_DSP_bot.Inst_DSP_bot_ConfigMem.Inst_frame3_bit3.Q
+ _2346_ sg13g2_o21ai_1
X_4214_ Tile_X0Y1_DSP_bot.Inst_DSP_bot_ConfigMem.Inst_frame9_bit19.Q VPWR _2453_ VGND
+ Tile_X0Y1_DSP_bot.Inst_DSP_bot_ConfigMem.Inst_frame9_bit18.Q _1866_ sg13g2_o21ai_1
X_4978_ _0714_ VPWR _0715_ VGND Tile_X0Y0_DSP_top.Inst_DSP_top_ConfigMem.Inst_frame2_bit2.Q
+ _0707_ sg13g2_o21ai_1
X_3027_ _1397_ _1392_ _1404_ VPWR VGND sg13g2_xor2_1
X_3929_ VGND VPWR _0052_ Tile_X0Y0_DSP_top.Inst_DSP_top_ConfigMem.Inst_frame11_bit17.Q
+ _2225_ Tile_X0Y0_DSP_top.Inst_DSP_top_ConfigMem.Inst_frame11_bit18.Q sg13g2_a21oi_1
XFILLER_93_209 VPWR VGND sg13g2_fill_1
XFILLER_24_60 VPWR VGND sg13g2_fill_2
XFILLER_69_239 VPWR VGND sg13g2_decap_8
XFILLER_60_172 VPWR VGND sg13g2_fill_1
X_4832_ Tile_X0Y0_S2MID[1] Tile_X0Y0_W2MID[1] Tile_X0Y0_DSP_top.Inst_DSP_top_ConfigMem.Inst_frame6_bit6.Q
+ _0575_ VPWR VGND sg13g2_mux2_1
XFILLER_52_128 VPWR VGND sg13g2_fill_2
X_4901_ _0640_ VPWR _0641_ VGND Tile_X0Y1_DSP_bot.Inst_DSP_bot_ConfigMem.Inst_frame4_bit17.Q
+ _0637_ sg13g2_o21ai_1
X_5881_ Tile_X0Y1_FrameData[2] Tile_X0Y1_FrameStrobe[6] Tile_X0Y1_DSP_bot.Inst_DSP_bot_ConfigMem.Inst_frame6_bit2.Q
+ VPWR VGND sg13g2_dlhq_1
X_5950_ Tile_X0Y1_FrameData[29] Tile_X0Y1_FrameStrobe[9] Tile_X0Y1_DSP_bot.Inst_DSP_bot_ConfigMem.Inst_frame9_bit29.Q
+ VPWR VGND sg13g2_dlhq_1
X_6433_ Tile_X0Y0_S4END[8] Tile_X0Y1_S4BEG[0] VPWR VGND sg13g2_buf_1
XFILLER_106_119 VPWR VGND sg13g2_fill_2
X_4763_ VPWR _0509_ _0508_ VGND sg13g2_inv_1
X_3645_ VGND VPWR Tile_X0Y0_DSP_top.Inst_DSP_top_ConfigMem.Inst_frame8_bit20.Q _0388_
+ _1983_ Tile_X0Y0_DSP_top.Inst_DSP_top_ConfigMem.Inst_frame8_bit21.Q sg13g2_a21oi_1
X_3714_ Tile_X0Y0_DSP_top.Inst_DSP_top_ConfigMem.Inst_frame7_bit31.Q Tile_X0Y0_DSP_top.Inst_DSP_top_switch_matrix.N2BEGb0
+ Tile_X0Y0_W2MID[0] Tile_X0Y0_E2MID[0] Tile_X0Y0_DSP_top.Inst_DSP_top_switch_matrix.JW2BEG6
+ Tile_X0Y0_DSP_top.Inst_DSP_top_ConfigMem.Inst_frame7_bit30.Q _2047_ VPWR VGND sg13g2_mux4_1
X_4694_ _0441_ _0438_ _0443_ _0444_ VPWR VGND sg13g2_a21o_1
X_6502_ Tile_X0Y1_WW4END[9] Tile_X0Y1_WW4BEG[5] VPWR VGND sg13g2_buf_1
X_5315_ Tile_X0Y0_FrameData[10] Tile_X0Y1_FrameStrobe[3] Tile_X0Y0_DSP_top.Inst_DSP_top_ConfigMem.Inst_frame3_bit10.Q
+ VPWR VGND sg13g2_dlhq_1
X_5246_ Tile_X0Y0_FrameData[15] Tile_X0Y1_FrameStrobe[1] Tile_X0Y0_DSP_top.Inst_DSP_top_ConfigMem.Inst_frame1_bit15.Q
+ VPWR VGND sg13g2_dlhq_1
X_6295_ Tile_X0Y0_DSP_top.Inst_DSP_top_switch_matrix.JW2BEG6 Tile_X0Y0_W2BEG[6] VPWR
+ VGND sg13g2_buf_1
X_3576_ VGND VPWR _1926_ _1927_ _1928_ _1791_ sg13g2_a21oi_1
X_6364_ Tile_X0Y1_DSP_bot.Inst_DSP_bot_switch_matrix.E6BEG1 Tile_X0Y1_E6BEG[11] VPWR
+ VGND sg13g2_buf_1
X_5177_ _0816_ _0900_ _0903_ VPWR VGND sg13g2_nor2_1
X_4059_ Tile_X0Y1_DSP_bot.Inst_DSP_bot_ConfigMem.Inst_frame11_bit7.Q Tile_X0Y1_DSP_bot.Inst_DSP_bot_switch_matrix.Q5
+ Tile_X0Y0_DSP_top.Inst_DSP_top_switch_matrix.N2BEGb1 _1793_ _1761_ Tile_X0Y1_DSP_bot.Inst_DSP_bot_ConfigMem.Inst_frame11_bit6.Q
+ Tile_X0Y1_DSP_bot.Inst_DSP_bot_switch_matrix.E1BEG2 VPWR VGND sg13g2_mux4_1
X_4128_ _2381_ Tile_X0Y1_DSP_bot.Inst_DSP_bot_ConfigMem.Inst_frame11_bit13.Q _0874_
+ VPWR VGND sg13g2_nand2_1
XFILLER_19_125 VPWR VGND sg13g2_fill_2
XFILLER_19_93 VPWR VGND sg13g2_fill_2
X_5100_ Tile_X0Y0_DSP_top.Inst_DSP_top_ConfigMem.Inst_frame2_bit10.Q VPWR _0831_ VGND
+ Tile_X0Y0_DSP_top.Inst_DSP_top_ConfigMem.Inst_frame2_bit9.Q _0828_ sg13g2_o21ai_1
X_6080_ VPWR VGND _2478_ sg13g2_tiehi
X_3361_ Tile_X0Y1_DSP_bot.Inst_DSP_bot_ConfigMem.Inst_frame1_bit25.Q VPWR _1724_ VGND
+ Tile_X0Y1_DSP_bot.Inst_DSP_bot_ConfigMem.Inst_frame1_bit24.Q Tile_X0Y1_DSP_bot.Inst_DSP_bot_switch_matrix.Q7
+ sg13g2_o21ai_1
X_3292_ Tile_X0Y1_DSP_bot.Inst_DSP_bot_ConfigMem.Inst_frame2_bit30.Q _1658_ _1659_
+ VPWR VGND sg13g2_nor2_1
X_5031_ Tile_X0Y1_DSP_bot.Inst_DSP_bot_ConfigMem.Inst_frame1_bit6.Q VPWR _0766_ VGND
+ Tile_X0Y1_DSP_bot.Inst_DSP_bot_ConfigMem.Inst_frame1_bit5.Q _0764_ sg13g2_o21ai_1
X_3430_ _1787_ VPWR _1788_ VGND Tile_X0Y1_DSP_bot.Inst_DSP_bot_ConfigMem.Inst_frame12_bit2.Q
+ Tile_X0Y1_DSP_bot.C6 sg13g2_o21ai_1
XFILLER_65_253 VPWR VGND sg13g2_fill_2
X_4815_ VGND VPWR Tile_X0Y0_DSP_top.Inst_DSP_top_ConfigMem.Inst_frame1_bit12.Q _0134_
+ _0558_ _0557_ sg13g2_a21oi_1
X_5795_ Tile_X0Y1_FrameData[24] Tile_X0Y1_FrameStrobe[4] Tile_X0Y1_DSP_bot.Inst_DSP_bot_ConfigMem.Inst_frame4_bit24.Q
+ VPWR VGND sg13g2_dlhq_1
X_5933_ Tile_X0Y1_FrameData[14] Tile_X0Y1_FrameStrobe[8] Tile_X0Y1_DSP_bot.Inst_DSP_bot_ConfigMem.Inst_frame8_bit14.Q
+ VPWR VGND sg13g2_dlhq_1
X_5864_ Tile_X0Y1_FrameData[19] Tile_X0Y1_FrameStrobe[6] Tile_X0Y1_DSP_bot.Inst_DSP_bot_ConfigMem.Inst_frame6_bit19.Q
+ VPWR VGND sg13g2_dlhq_1
XFILLER_18_180 VPWR VGND sg13g2_fill_2
X_3628_ VPWR _1967_ _1966_ VGND sg13g2_inv_1
X_4746_ _0492_ VPWR Tile_X0Y0_DSP_top.Inst_DSP_top_switch_matrix.inst_cus_mux41_buf_top2bot12.X
+ VGND _0253_ _0255_ sg13g2_o21ai_1
X_4677_ VPWR _0428_ _0427_ VGND sg13g2_inv_1
X_6416_ Tile_X0Y1_DSP_bot.Inst_DSP_bot_switch_matrix.S1BEG3 Tile_X0Y1_S1BEG[3] VPWR
+ VGND sg13g2_buf_1
X_6347_ Tile_X0Y1_E2MID[2] Tile_X0Y1_E2BEGb[2] VPWR VGND sg13g2_buf_1
X_6278_ Tile_X0Y0_DSP_top.NN4BEG_outbuf_10.A Tile_X0Y0_NN4BEG[10] VPWR VGND sg13g2_buf_1
XFILLER_102_122 VPWR VGND sg13g2_fill_1
X_5229_ Tile_X0Y0_FrameData[0] Tile_X0Y1_FrameStrobe[0] Tile_X0Y0_DSP_top.Inst_DSP_top_ConfigMem.Inst_frame0_bit0.Q
+ VPWR VGND sg13g2_dlhq_1
X_3559_ Tile_X0Y1_DSP_bot.Inst_DSP_bot_ConfigMem.Inst_frame12_bit2.Q Tile_X0Y1_DSP_bot.Inst_MULADD.C_reg\[0\]
+ _1911_ VPWR VGND sg13g2_and2_1
XFILLER_12_301 VPWR VGND sg13g2_fill_1
XANTENNA_90 VPWR VGND Tile_X0Y0_S2MID[4] sg13g2_antennanp
X_4600_ Tile_X0Y0_DSP_top.Inst_DSP_top_ConfigMem.Inst_frame4_bit5.Q Tile_X0Y1_N2MID[2]
+ Tile_X0Y0_E1END[0] Tile_X0Y1_N4END[6] Tile_X0Y0_E2END[2] Tile_X0Y0_DSP_top.Inst_DSP_top_ConfigMem.Inst_frame4_bit4.Q
+ _0354_ VPWR VGND sg13g2_mux4_1
X_2861_ _0669_ _0435_ Tile_X0Y1_DSP_bot.Inst_DSP_bot_ConfigMem.Inst_frame3_bit16.Q
+ _1241_ VPWR VGND sg13g2_mux2_1
X_2930_ Tile_X0Y1_DSP_bot.Inst_MULADD.B_reg\[0\] Tile_X0Y1_DSP_bot.B0 _0074_ _1307_
+ VPWR VGND sg13g2_mux2_1
X_6201_ Tile_X0Y0_FrameData[21] Tile_X0Y0_FrameData_O[21] VPWR VGND sg13g2_buf_1
X_2792_ VPWR VGND _1173_ Tile_X0Y0_DSP_top.Inst_DSP_top_ConfigMem.Inst_frame2_bit27.Q
+ _1170_ _1165_ _1174_ _1168_ sg13g2_a221oi_1
X_5580_ Tile_X0Y0_FrameData[1] Tile_X0Y1_FrameStrobe[11] Tile_X0Y0_DSP_top.Inst_DSP_top_ConfigMem.Inst_frame11_bit1.Q
+ VPWR VGND sg13g2_dlhq_1
X_4531_ VPWR Tile_X0Y1_DSP_bot.Inst_DSP_bot_switch_matrix.JW2BEG2 _0287_ VGND sg13g2_inv_1
X_4462_ VGND VPWR Tile_X0Y1_DSP_bot.Inst_DSP_bot_ConfigMem.Inst_frame2_bit14.Q _0219_
+ _0222_ Tile_X0Y1_DSP_bot.Inst_DSP_bot_ConfigMem.Inst_frame2_bit15.Q sg13g2_a21oi_1
X_3413_ Tile_X0Y1_DSP_bot.Inst_DSP_bot_ConfigMem.Inst_frame8_bit20.Q VPWR _1773_ VGND
+ Tile_X0Y1_DSP_bot.Inst_DSP_bot_ConfigMem.Inst_frame6_bit31.Q _1772_ sg13g2_o21ai_1
XFILLER_97_131 VPWR VGND sg13g2_fill_2
X_6132_ Tile_X0Y0_DSP_top.Inst_DSP_top_switch_matrix.E1BEG0 Tile_X0Y0_E1BEG[0] VPWR
+ VGND sg13g2_buf_1
X_3344_ Tile_X0Y1_DSP_bot.Inst_DSP_bot_ConfigMem.Inst_frame3_bit24.Q Tile_X0Y1_DSP_bot.Inst_DSP_bot_switch_matrix.Q0
+ Tile_X0Y1_DSP_bot.Inst_DSP_bot_switch_matrix.Q1 Tile_X0Y1_DSP_bot.Inst_DSP_bot_switch_matrix.Q2
+ Tile_X0Y1_DSP_bot.Inst_DSP_bot_switch_matrix.Q3 Tile_X0Y1_DSP_bot.Inst_DSP_bot_ConfigMem.Inst_frame3_bit25.Q
+ _1708_ VPWR VGND sg13g2_mux4_1
X_3275_ VGND VPWR Tile_X0Y1_DSP_bot.Inst_DSP_bot_ConfigMem.Inst_frame1_bit28.Q Tile_X0Y1_DSP_bot.Inst_DSP_bot_switch_matrix.Q1
+ _1642_ _1641_ sg13g2_a21oi_1
X_4393_ Tile_X0Y1_DSP_bot.Inst_DSP_bot_switch_matrix.Q3 Tile_X0Y1_DSP_bot.Inst_DSP_bot_switch_matrix.Q4
+ Tile_X0Y1_DSP_bot.Inst_DSP_bot_ConfigMem.Inst_frame3_bit8.Q _0155_ VPWR VGND sg13g2_mux2_1
X_6063_ Tile_X0Y1_FrameData[12] Tile_X0Y1_FrameStrobe[12] Tile_X0Y1_DSP_bot.Inst_DSP_bot_ConfigMem.Inst_frame12_bit12.Q
+ VPWR VGND sg13g2_dlhq_1
X_5014_ Tile_X0Y1_N2MID[0] Tile_X0Y1_DSP_bot.Inst_DSP_bot_ConfigMem.Inst_frame7_bit6.Q
+ _0749_ VPWR VGND sg13g2_nor2_1
XFILLER_30_0 VPWR VGND sg13g2_decap_4
X_5916_ Tile_X0Y1_FrameData[31] Tile_X0Y1_FrameStrobe[8] Tile_X0Y1_DSP_bot.Inst_DSP_bot_ConfigMem.Inst_frame8_bit31.Q
+ VPWR VGND sg13g2_dlhq_1
XFILLER_26_17 VPWR VGND sg13g2_fill_1
X_4729_ VGND VPWR Tile_X0Y1_DSP_bot.Inst_DSP_bot_ConfigMem.Inst_frame4_bit28.Q _0125_
+ _0477_ Tile_X0Y1_DSP_bot.Inst_DSP_bot_ConfigMem.Inst_frame4_bit29.Q sg13g2_a21oi_1
X_5778_ Tile_X0Y1_FrameData[9] Tile_X0Y1_FrameStrobe[3] Tile_X0Y1_DSP_bot.Inst_DSP_bot_ConfigMem.Inst_frame3_bit9.Q
+ VPWR VGND sg13g2_dlhq_1
X_5847_ Tile_X0Y1_FrameData[4] Tile_X0Y1_FrameStrobe[5] Tile_X0Y1_DSP_bot.Inst_DSP_bot_ConfigMem.Inst_frame5_bit4.Q
+ VPWR VGND sg13g2_dlhq_1
XFILLER_79_131 VPWR VGND sg13g2_decap_4
XFILLER_79_120 VPWR VGND sg13g2_decap_8
X_3060_ _1437_ _1153_ _1156_ VPWR VGND sg13g2_nand2_1
XFILLER_35_289 VPWR VGND sg13g2_fill_2
X_3962_ Tile_X0Y0_DSP_top.Inst_DSP_top_ConfigMem.Inst_frame11_bit30.Q Tile_X0Y0_DSP_top.Inst_DSP_top_switch_matrix.bot2top6
+ Tile_X0Y0_DSP_top.Inst_DSP_top_switch_matrix.bot2top7 Tile_X0Y0_DSP_top.Inst_DSP_top_switch_matrix.bot2top8
+ Tile_X0Y0_DSP_top.Inst_DSP_top_switch_matrix.bot2top9 Tile_X0Y0_DSP_top.Inst_DSP_top_ConfigMem.Inst_frame11_bit31.Q
+ _2254_ VPWR VGND sg13g2_mux4_1
X_5563_ Tile_X0Y0_FrameData[18] Tile_X0Y1_FrameStrobe[11] Tile_X0Y0_DSP_top.Inst_DSP_top_ConfigMem.Inst_frame11_bit18.Q
+ VPWR VGND sg13g2_dlhq_1
X_3893_ Tile_X0Y0_DSP_top.Inst_DSP_top_ConfigMem.Inst_frame10_bit13.Q Tile_X0Y0_E6END[0]
+ Tile_X0Y0_S4END[2] Tile_X0Y0_S2END[3] Tile_X0Y0_DSP_top.Inst_DSP_top_switch_matrix.bot2top1
+ Tile_X0Y0_DSP_top.Inst_DSP_top_ConfigMem.Inst_frame10_bit12.Q Tile_X0Y0_DSP_top.Inst_DSP_top_switch_matrix.S4BEG1
+ VPWR VGND sg13g2_mux4_1
X_2844_ _1223_ _1219_ _1224_ VPWR VGND sg13g2_xor2_1
X_5701_ Tile_X0Y1_FrameData[22] Tile_X0Y1_FrameStrobe[1] Tile_X0Y1_DSP_bot.Inst_DSP_bot_ConfigMem.Inst_frame1_bit22.Q
+ VPWR VGND sg13g2_dlhq_1
X_5632_ _2504_ VGND VPWR Tile_X0Y1_DSP_bot.B0 Tile_X0Y1_DSP_bot.Inst_MULADD.B_reg\[0\]
+ clknet_3_1_0_Tile_X0Y1_UserCLK_regs sg13g2_dfrbpq_1
X_2913_ Tile_X0Y1_DSP_bot.Inst_DSP_bot_ConfigMem.Inst_frame9_bit31.Q VPWR _1291_ VGND
+ _1286_ _1289_ sg13g2_o21ai_1
X_4376_ VGND VPWR Tile_X0Y0_DSP_top.Inst_DSP_top_ConfigMem.Inst_frame4_bit18.Q _0137_
+ _0139_ _0138_ sg13g2_a21oi_1
X_4445_ VGND VPWR _0206_ _0205_ _0204_ sg13g2_or2_1
X_5494_ Tile_X0Y0_FrameData[23] Tile_X0Y1_FrameStrobe[9] Tile_X0Y0_DSP_top.Inst_DSP_top_ConfigMem.Inst_frame9_bit23.Q
+ VPWR VGND sg13g2_dlhq_1
X_2775_ _1155_ _1154_ _1157_ VPWR VGND sg13g2_xor2_1
X_4514_ Tile_X0Y1_DSP_bot.Inst_DSP_bot_ConfigMem.Inst_frame4_bit4.Q Tile_X0Y1_E6END[0]
+ Tile_X0Y0_S2MID[2] Tile_X0Y1_W2END[2] Tile_X0Y1_W6END[0] Tile_X0Y1_DSP_bot.Inst_DSP_bot_ConfigMem.Inst_frame4_bit5.Q
+ _0272_ VPWR VGND sg13g2_mux4_1
X_3189_ VGND VPWR Tile_X0Y0_E2END[3] Tile_X0Y0_DSP_top.Inst_DSP_top_ConfigMem.Inst_frame0_bit16.Q
+ _1561_ _1560_ sg13g2_a21oi_1
XFILLER_85_178 VPWR VGND sg13g2_fill_2
XFILLER_73_307 VPWR VGND sg13g2_fill_2
X_3258_ Tile_X0Y1_DSP_bot.Inst_DSP_bot_ConfigMem.Inst_frame1_bit20.Q Tile_X0Y1_DSP_bot.Inst_DSP_bot_switch_matrix.Q0
+ Tile_X0Y1_DSP_bot.Inst_DSP_bot_switch_matrix.Q1 Tile_X0Y1_DSP_bot.Inst_DSP_bot_switch_matrix.Q2
+ Tile_X0Y1_DSP_bot.Inst_DSP_bot_switch_matrix.Q3 Tile_X0Y1_DSP_bot.Inst_DSP_bot_ConfigMem.Inst_frame1_bit21.Q
+ _1626_ VPWR VGND sg13g2_mux4_1
X_3327_ _1349_ _1428_ _1429_ _1691_ VPWR VGND sg13g2_or3_1
X_6046_ Tile_X0Y1_FrameData[29] Tile_X0Y1_FrameStrobe[12] Tile_X0Y1_DSP_bot.Inst_DSP_bot_ConfigMem.Inst_frame12_bit29.Q
+ VPWR VGND sg13g2_dlhq_1
X_6115_ VPWR VGND _2513_ sg13g2_tiehi
XFILLER_41_259 VPWR VGND sg13g2_fill_1
XFILLER_41_215 VPWR VGND sg13g2_decap_4
XFILLER_76_156 VPWR VGND sg13g2_fill_2
XFILLER_49_359 VPWR VGND sg13g2_fill_2
XFILLER_32_204 VPWR VGND sg13g2_fill_2
X_2560_ Tile_X0Y0_DSP_top.Inst_DSP_top_ConfigMem.Inst_frame4_bit15.Q VPWR _0951_ VGND
+ _0949_ _0950_ sg13g2_o21ai_1
X_4230_ VGND VPWR _1629_ _2463_ _2468_ _2467_ sg13g2_a21oi_1
XFILLER_82_115 VPWR VGND sg13g2_fill_2
X_3112_ _1488_ Tile_X0Y0_DSP_top.Inst_DSP_top_ConfigMem.Inst_frame6_bit22.Q Tile_X0Y0_E2MID[1]
+ VPWR VGND sg13g2_nand2b_1
X_3043_ _1415_ _1419_ _1420_ VPWR VGND sg13g2_nor2_1
X_4092_ Tile_X0Y1_DSP_bot.Inst_DSP_bot_ConfigMem.Inst_frame2_bit3.Q VPWR _2354_ VGND
+ _2352_ _2353_ sg13g2_o21ai_1
X_4161_ Tile_X0Y1_DSP_bot.Inst_DSP_bot_ConfigMem.Inst_frame11_bit26.Q Tile_X0Y1_DSP_bot.Inst_DSP_bot_switch_matrix.Q6
+ Tile_X0Y1_DSP_bot.Inst_DSP_bot_switch_matrix.Q7 Tile_X0Y1_DSP_bot.Inst_DSP_bot_switch_matrix.Q8
+ Tile_X0Y1_DSP_bot.Inst_DSP_bot_switch_matrix.Q9 Tile_X0Y1_DSP_bot.Inst_DSP_bot_ConfigMem.Inst_frame11_bit27.Q
+ _2410_ VPWR VGND sg13g2_mux4_1
X_3945_ _2240_ Tile_X0Y0_DSP_top.Inst_DSP_top_ConfigMem.Inst_frame11_bit20.Q _1537_
+ VPWR VGND sg13g2_nand2_1
XFILLER_90_192 VPWR VGND sg13g2_decap_4
X_4994_ Tile_X0Y1_DSP_bot.Inst_DSP_bot_ConfigMem.Inst_frame0_bit14.Q Tile_X0Y1_N4END[0]
+ _0730_ VPWR VGND sg13g2_nor2b_1
X_3876_ _2189_ Tile_X0Y0_E2END[1] Tile_X0Y0_DSP_top.Inst_DSP_top_ConfigMem.Inst_frame4_bit0.Q
+ VPWR VGND sg13g2_nand2_1
X_5546_ Tile_X0Y0_FrameData[3] Tile_X0Y1_FrameStrobe[10] Tile_X0Y0_DSP_top.Inst_DSP_top_ConfigMem.Inst_frame10_bit3.Q
+ VPWR VGND sg13g2_dlhq_1
X_5615_ _2480_ VGND VPWR _0011_ Tile_X0Y1_DSP_bot.Inst_MULADD.ACC\[11\] clknet_3_6_0_Tile_X0Y1_UserCLK_regs
+ sg13g2_dfrbpq_1
X_2758_ _1140_ _1139_ _1137_ VPWR VGND sg13g2_nand2b_1
X_2827_ VGND VPWR _1129_ _1199_ _1207_ _1201_ sg13g2_a21oi_1
X_4359_ VPWR _0122_ Tile_X0Y0_DSP_top.Inst_DSP_top_ConfigMem.Inst_frame10_bit25.Q
+ VGND sg13g2_inv_1
X_5477_ Tile_X0Y0_FrameData[8] Tile_X0Y1_FrameStrobe[8] Tile_X0Y0_DSP_top.Inst_DSP_top_ConfigMem.Inst_frame8_bit8.Q
+ VPWR VGND sg13g2_dlhq_1
X_2689_ _1074_ Tile_X0Y1_DSP_bot.Inst_DSP_bot_ConfigMem.Inst_frame12_bit0.Q Tile_X0Y1_DSP_bot.Inst_MULADD.A_reg\[1\]
+ VPWR VGND sg13g2_nand2_1
X_4428_ Tile_X0Y1_DSP_bot.Inst_DSP_bot_ConfigMem.Inst_frame12_bit6.Q Tile_X0Y1_DSP_bot.Inst_DSP_bot_switch_matrix.Q2
+ _0151_ _0185_ _0171_ Tile_X0Y1_DSP_bot.Inst_DSP_bot_ConfigMem.Inst_frame12_bit7.Q
+ _0189_ VPWR VGND sg13g2_mux4_1
X_6029_ Tile_X0Y1_FrameData[14] Tile_X0Y1_FrameStrobe[11] Tile_X0Y1_DSP_bot.Inst_DSP_bot_ConfigMem.Inst_frame11_bit14.Q
+ VPWR VGND sg13g2_dlhq_1
XFILLER_54_80 VPWR VGND sg13g2_fill_1
XFILLER_45_351 VPWR VGND sg13g2_fill_1
X_3730_ VGND VPWR Tile_X0Y0_DSP_top.Inst_DSP_top_ConfigMem.Inst_frame8_bit26.Q Tile_X0Y0_DSP_top.Inst_DSP_top_switch_matrix.E2BEG6
+ _2061_ _0114_ sg13g2_a21oi_1
X_3592_ _1943_ VPWR Tile_X0Y0_DSP_top.Inst_DSP_top_switch_matrix.bot2top4 VGND Tile_X0Y1_DSP_bot.Inst_DSP_bot_ConfigMem.Inst_frame12_bit5.Q
+ _1942_ sg13g2_o21ai_1
X_3661_ _1998_ _1962_ _1997_ VPWR VGND sg13g2_xnor2_1
X_5400_ Tile_X0Y0_FrameData[21] Tile_X0Y1_FrameStrobe[6] Tile_X0Y0_DSP_top.Inst_DSP_top_ConfigMem.Inst_frame6_bit21.Q
+ VPWR VGND sg13g2_dlhq_1
X_2612_ _0744_ VPWR _1000_ VGND _0608_ _0742_ sg13g2_o21ai_1
X_6380_ Tile_X0Y1_DSP_bot.Inst_DSP_bot_switch_matrix.EE4BEG3 Tile_X0Y1_EE4BEG[15]
+ VPWR VGND sg13g2_buf_1
X_5331_ Tile_X0Y0_FrameData[26] Tile_X0Y1_FrameStrobe[4] Tile_X0Y0_DSP_top.Inst_DSP_top_ConfigMem.Inst_frame4_bit26.Q
+ VPWR VGND sg13g2_dlhq_1
X_5193_ VPWR VGND Tile_X0Y0_DSP_top.Inst_DSP_top_ConfigMem.Inst_frame3_bit17.Q _0062_
+ _0918_ _0915_ _0919_ _0916_ sg13g2_a221oi_1
X_5262_ Tile_X0Y0_FrameData[31] Tile_X0Y1_FrameStrobe[2] Tile_X0Y0_DSP_top.Inst_DSP_top_ConfigMem.Inst_frame2_bit31.Q
+ VPWR VGND sg13g2_dlhq_1
X_2543_ VPWR Tile_X0Y0_DSP_top.Inst_DSP_top_switch_matrix.N2BEGb2 _0935_ VGND sg13g2_inv_1
X_4213_ Tile_X0Y1_DSP_bot.Inst_DSP_bot_ConfigMem.Inst_frame9_bit19.Q _2451_ _2452_
+ VPWR VGND sg13g2_nor2_1
X_3026_ _1403_ _1401_ _1402_ VPWR VGND sg13g2_nand2b_1
XFILLER_36_340 VPWR VGND sg13g2_fill_1
X_4075_ _2345_ VPWR _2346_ VGND Tile_X0Y1_DSP_bot.Inst_DSP_bot_ConfigMem.Inst_frame3_bit2.Q
+ _2340_ sg13g2_o21ai_1
X_4144_ _2392_ _2394_ Tile_X0Y1_DSP_bot.Inst_DSP_bot_switch_matrix.EE4BEG3 VPWR VGND
+ sg13g2_nor2_1
X_3928_ _2224_ _2223_ Tile_X0Y0_DSP_top.Inst_DSP_top_ConfigMem.Inst_frame11_bit16.Q
+ Tile_X0Y0_DSP_top.Inst_DSP_top_switch_matrix.EE4BEG0 VPWR VGND sg13g2_mux2_1
X_4977_ _0713_ Tile_X0Y0_DSP_top.Inst_DSP_top_ConfigMem.Inst_frame2_bit3.Q _0714_
+ VPWR VGND sg13g2_nor2b_1
XFILLER_109_117 VPWR VGND sg13g2_fill_1
X_3859_ Tile_X0Y0_DSP_top.Inst_DSP_top_ConfigMem.Inst_frame12_bit12.Q Tile_X0Y0_DSP_top.Inst_DSP_top_switch_matrix.bot2top3
+ _0644_ _2179_ _0668_ Tile_X0Y0_DSP_top.Inst_DSP_top_ConfigMem.Inst_frame12_bit13.Q
+ Tile_X0Y0_DSP_top.Inst_DSP_top_switch_matrix.N1BEG1 VPWR VGND sg13g2_mux4_1
X_5529_ Tile_X0Y0_FrameData[20] Tile_X0Y1_FrameStrobe[10] Tile_X0Y0_DSP_top.Inst_DSP_top_ConfigMem.Inst_frame10_bit20.Q
+ VPWR VGND sg13g2_dlhq_1
XFILLER_59_14 VPWR VGND sg13g2_fill_2
XFILLER_27_351 VPWR VGND sg13g2_fill_1
XFILLER_24_72 VPWR VGND sg13g2_fill_1
X_4762_ Tile_X0Y0_DSP_top.Inst_DSP_top_ConfigMem.Inst_frame4_bit8.Q Tile_X0Y0_E6END[1]
+ Tile_X0Y0_S2END[3] Tile_X0Y0_W2END[3] Tile_X0Y0_WW4END[1] Tile_X0Y0_DSP_top.Inst_DSP_top_ConfigMem.Inst_frame4_bit9.Q
+ _0508_ VPWR VGND sg13g2_mux4_1
XFILLER_92_298 VPWR VGND sg13g2_fill_2
X_4831_ _0573_ VPWR _0574_ VGND Tile_X0Y0_DSP_top.Inst_DSP_top_ConfigMem.Inst_frame6_bit6.Q
+ Tile_X0Y0_DSP_top.Inst_DSP_top_switch_matrix.N2BEGb1 sg13g2_o21ai_1
X_4900_ _0639_ Tile_X0Y1_DSP_bot.Inst_DSP_bot_ConfigMem.Inst_frame4_bit18.Q _0640_
+ VPWR VGND sg13g2_nor2b_1
XFILLER_45_192 VPWR VGND sg13g2_decap_8
X_5880_ Tile_X0Y1_FrameData[3] Tile_X0Y1_FrameStrobe[6] Tile_X0Y1_DSP_bot.Inst_DSP_bot_ConfigMem.Inst_frame6_bit3.Q
+ VPWR VGND sg13g2_dlhq_1
X_3713_ _2035_ _2046_ Tile_X0Y0_DSP_top.Inst_DSP_top_switch_matrix.JW2BEG6 VPWR VGND
+ sg13g2_nor2_1
X_3644_ Tile_X0Y0_DSP_top.Inst_DSP_top_ConfigMem.Inst_frame7_bit27.Q Tile_X0Y0_DSP_top.Inst_DSP_top_switch_matrix.N2BEGb2
+ Tile_X0Y0_W2MID[2] Tile_X0Y0_S2MID[2] Tile_X0Y0_DSP_top.Inst_DSP_top_switch_matrix.E2BEG6
+ Tile_X0Y0_DSP_top.Inst_DSP_top_ConfigMem.Inst_frame7_bit26.Q _1982_ VPWR VGND sg13g2_mux4_1
XFILLER_60_0 VPWR VGND sg13g2_fill_2
X_4693_ _0056_ VPWR _0443_ VGND Tile_X0Y1_DSP_bot.Inst_DSP_bot_ConfigMem.Inst_frame4_bit26.Q
+ _0442_ sg13g2_o21ai_1
X_3575_ _1927_ _1789_ _1790_ VPWR VGND sg13g2_xnor2_1
X_6501_ Tile_X0Y1_WW4END[8] Tile_X0Y1_WW4BEG[4] VPWR VGND sg13g2_buf_1
X_6432_ Tile_X0Y0_DSP_top.Inst_DSP_top_switch_matrix.JS2BEG7 Tile_X0Y1_S2BEGb[7] VPWR
+ VGND sg13g2_buf_1
X_6363_ Tile_X0Y1_DSP_bot.Inst_DSP_bot_switch_matrix.E6BEG0 Tile_X0Y1_E6BEG[10] VPWR
+ VGND sg13g2_buf_1
X_5245_ Tile_X0Y0_FrameData[16] Tile_X0Y1_FrameStrobe[1] Tile_X0Y0_DSP_top.Inst_DSP_top_ConfigMem.Inst_frame1_bit16.Q
+ VPWR VGND sg13g2_dlhq_1
XFILLER_102_359 VPWR VGND sg13g2_fill_2
X_5314_ Tile_X0Y0_FrameData[11] Tile_X0Y1_FrameStrobe[3] Tile_X0Y0_DSP_top.Inst_DSP_top_ConfigMem.Inst_frame3_bit11.Q
+ VPWR VGND sg13g2_dlhq_1
X_6294_ Tile_X0Y0_DSP_top.Inst_DSP_top_switch_matrix.JW2BEG5 Tile_X0Y0_W2BEG[5] VPWR
+ VGND sg13g2_buf_1
X_5176_ _0902_ _0786_ _0869_ VPWR VGND sg13g2_nand2_1
X_3009_ _1380_ _1378_ _1382_ _1386_ VPWR VGND sg13g2_a21o_1
XFILLER_36_170 VPWR VGND sg13g2_fill_2
X_4058_ Tile_X0Y1_DSP_bot.Inst_DSP_bot_ConfigMem.Inst_frame11_bit4.Q Tile_X0Y1_DSP_bot.Inst_DSP_bot_switch_matrix.Q4
+ _0209_ Tile_X0Y0_DSP_top.Inst_DSP_top_switch_matrix.N2BEGb0 _0223_ Tile_X0Y1_DSP_bot.Inst_DSP_bot_ConfigMem.Inst_frame11_bit5.Q
+ Tile_X0Y1_DSP_bot.Inst_DSP_bot_switch_matrix.E1BEG1 VPWR VGND sg13g2_mux4_1
X_4127_ _2379_ VPWR _2380_ VGND Tile_X0Y1_DSP_bot.Inst_DSP_bot_ConfigMem.Inst_frame11_bit13.Q
+ _1121_ sg13g2_o21ai_1
XFILLER_51_162 VPWR VGND sg13g2_fill_1
XFILLER_86_56 VPWR VGND sg13g2_fill_2
XFILLER_74_254 VPWR VGND sg13g2_fill_1
XFILLER_42_195 VPWR VGND sg13g2_decap_4
XFILLER_27_170 VPWR VGND sg13g2_decap_4
X_3360_ _1722_ VPWR _1723_ VGND Tile_X0Y1_DSP_bot.Inst_DSP_bot_ConfigMem.Inst_frame1_bit24.Q
+ Tile_X0Y1_DSP_bot.Inst_DSP_bot_switch_matrix.Q4 sg13g2_o21ai_1
X_3291_ Tile_X0Y1_DSP_bot.Inst_DSP_bot_ConfigMem.Inst_frame2_bit28.Q Tile_X0Y1_DSP_bot.Inst_DSP_bot_switch_matrix.Q0
+ Tile_X0Y1_DSP_bot.Inst_DSP_bot_switch_matrix.Q1 Tile_X0Y1_DSP_bot.Inst_DSP_bot_switch_matrix.Q2
+ Tile_X0Y1_DSP_bot.Inst_DSP_bot_switch_matrix.Q3 Tile_X0Y1_DSP_bot.Inst_DSP_bot_ConfigMem.Inst_frame2_bit29.Q
+ _1658_ VPWR VGND sg13g2_mux4_1
X_5030_ Tile_X0Y1_DSP_bot.Inst_DSP_bot_switch_matrix.Q7 Tile_X0Y1_DSP_bot.Inst_DSP_bot_switch_matrix.Q8
+ Tile_X0Y1_DSP_bot.Inst_DSP_bot_ConfigMem.Inst_frame1_bit4.Q _0765_ VPWR VGND sg13g2_mux2_1
X_5932_ Tile_X0Y1_FrameData[15] Tile_X0Y1_FrameStrobe[8] Tile_X0Y1_DSP_bot.Inst_DSP_bot_ConfigMem.Inst_frame8_bit15.Q
+ VPWR VGND sg13g2_dlhq_1
XFILLER_25_129 VPWR VGND sg13g2_decap_8
X_4745_ _0491_ VPWR _0492_ VGND Tile_X0Y0_DSP_top.Inst_DSP_top_ConfigMem.Inst_frame8_bit18.Q
+ _0446_ sg13g2_o21ai_1
XFILLER_80_279 VPWR VGND sg13g2_fill_2
XFILLER_80_268 VPWR VGND sg13g2_fill_1
X_4814_ Tile_X0Y0_DSP_top.Inst_DSP_top_ConfigMem.Inst_frame1_bit13.Q VPWR _0557_ VGND
+ Tile_X0Y0_DSP_top.Inst_DSP_top_ConfigMem.Inst_frame1_bit12.Q Tile_X0Y0_DSP_top.Inst_DSP_top_switch_matrix.bot2top7
+ sg13g2_o21ai_1
X_5794_ Tile_X0Y1_FrameData[25] Tile_X0Y1_FrameStrobe[4] Tile_X0Y1_DSP_bot.Inst_DSP_bot_ConfigMem.Inst_frame4_bit25.Q
+ VPWR VGND sg13g2_dlhq_1
X_5863_ Tile_X0Y1_FrameData[20] Tile_X0Y1_FrameStrobe[6] Tile_X0Y1_DSP_bot.Inst_DSP_bot_ConfigMem.Inst_frame6_bit20.Q
+ VPWR VGND sg13g2_dlhq_1
X_3627_ Tile_X0Y0_DSP_top.Inst_DSP_top_ConfigMem.Inst_frame3_bit24.Q Tile_X0Y0_DSP_top.Inst_DSP_top_switch_matrix.bot2top0
+ Tile_X0Y0_DSP_top.Inst_DSP_top_switch_matrix.bot2top1 Tile_X0Y0_DSP_top.Inst_DSP_top_switch_matrix.bot2top2
+ Tile_X0Y0_DSP_top.Inst_DSP_top_switch_matrix.bot2top3 Tile_X0Y0_DSP_top.Inst_DSP_top_ConfigMem.Inst_frame3_bit25.Q
+ _1966_ VPWR VGND sg13g2_mux4_1
X_4676_ Tile_X0Y1_DSP_bot.Inst_DSP_bot_ConfigMem.Inst_frame4_bit22.Q VPWR _0427_ VGND
+ _0425_ _0426_ sg13g2_o21ai_1
X_6415_ Tile_X0Y1_DSP_bot.Inst_DSP_bot_switch_matrix.S1BEG2 Tile_X0Y1_S1BEG[2] VPWR
+ VGND sg13g2_buf_1
X_6346_ Tile_X0Y1_E2MID[1] Tile_X0Y1_E2BEGb[1] VPWR VGND sg13g2_buf_1
X_3558_ _1910_ VPWR Tile_X0Y1_DSP_bot.C0 VGND _1900_ _1902_ sg13g2_o21ai_1
X_6277_ Tile_X0Y0_DSP_top.NN4BEG_outbuf_9.A Tile_X0Y0_NN4BEG[9] VPWR VGND sg13g2_buf_1
X_5228_ Tile_X0Y0_FrameData[1] Tile_X0Y1_FrameStrobe[0] Tile_X0Y0_DSP_top.Inst_DSP_top_ConfigMem.Inst_frame0_bit1.Q
+ VPWR VGND sg13g2_dlhq_1
X_5159_ Tile_X0Y1_W2END[2] Tile_X0Y1_W6END[0] Tile_X0Y1_DSP_bot.Inst_DSP_bot_ConfigMem.Inst_frame2_bit4.Q
+ _0887_ VPWR VGND sg13g2_mux2_1
X_3489_ Tile_X0Y1_DSP_bot.Inst_DSP_bot_ConfigMem.Inst_frame8_bit12.Q _1844_ _1845_
+ VPWR VGND sg13g2_nor2_1
XFILLER_72_25 VPWR VGND sg13g2_fill_1
XFILLER_71_202 VPWR VGND sg13g2_decap_4
XFILLER_56_276 VPWR VGND sg13g2_fill_1
XFILLER_16_107 VPWR VGND sg13g2_fill_2
XANTENNA_80 VPWR VGND Tile_X0Y0_FrameData[6] sg13g2_antennanp
XANTENNA_91 VPWR VGND Tile_X0Y0_S2MID[4] sg13g2_antennanp
XFILLER_21_40 VPWR VGND sg13g2_decap_4
XFILLER_108_0 VPWR VGND sg13g2_decap_8
XFILLER_62_235 VPWR VGND sg13g2_fill_1
XFILLER_47_265 VPWR VGND sg13g2_fill_2
X_2791_ VGND VPWR Tile_X0Y0_DSP_top.Inst_DSP_top_ConfigMem.Inst_frame2_bit25.Q _1172_
+ _1173_ _0068_ sg13g2_a21oi_1
X_2860_ _1234_ Tile_X0Y1_DSP_bot.Inst_DSP_bot_ConfigMem.Inst_frame3_bit19.Q _1240_
+ VPWR VGND sg13g2_nor2b_1
X_6200_ Tile_X0Y0_FrameData[20] Tile_X0Y0_FrameData_O[20] VPWR VGND sg13g2_buf_1
X_6131_ VPWR VGND _2529_ sg13g2_tiehi
X_4530_ _0278_ VPWR _0287_ VGND Tile_X0Y1_DSP_bot.Inst_DSP_bot_ConfigMem.Inst_frame1_bit11.Q
+ _0286_ sg13g2_o21ai_1
XFILLER_7_42 VPWR VGND sg13g2_fill_2
X_4461_ _0221_ _0220_ Tile_X0Y1_DSP_bot.Inst_DSP_bot_ConfigMem.Inst_frame2_bit14.Q
+ VPWR VGND sg13g2_nand2b_1
X_3412_ _1771_ VPWR _1772_ VGND Tile_X0Y1_N2MID[1] Tile_X0Y1_DSP_bot.Inst_DSP_bot_ConfigMem.Inst_frame6_bit30.Q
+ sg13g2_o21ai_1
X_4392_ _0153_ VPWR _0154_ VGND Tile_X0Y1_DSP_bot.Inst_DSP_bot_ConfigMem.Inst_frame12_bit6.Q
+ _0127_ sg13g2_o21ai_1
X_3343_ Tile_X0Y1_DSP_bot.Inst_DSP_bot_ConfigMem.Inst_frame3_bit26.Q VPWR _1707_ VGND
+ Tile_X0Y1_DSP_bot.Inst_DSP_bot_ConfigMem.Inst_frame3_bit25.Q _1704_ sg13g2_o21ai_1
X_3274_ Tile_X0Y1_DSP_bot.Inst_DSP_bot_ConfigMem.Inst_frame1_bit28.Q Tile_X0Y1_DSP_bot.Inst_DSP_bot_switch_matrix.Q0
+ _1641_ VPWR VGND sg13g2_nor2b_1
X_6062_ Tile_X0Y1_FrameData[13] Tile_X0Y1_FrameStrobe[12] Tile_X0Y1_DSP_bot.Inst_DSP_bot_ConfigMem.Inst_frame12_bit13.Q
+ VPWR VGND sg13g2_dlhq_1
X_5013_ Tile_X0Y1_E2MID[0] Tile_X0Y1_DSP_bot.Inst_DSP_bot_ConfigMem.Inst_frame7_bit6.Q
+ _0748_ VPWR VGND sg13g2_nor2b_1
XFILLER_93_360 VPWR VGND sg13g2_fill_1
X_5915_ Tile_X0Y1_FrameData[0] Tile_X0Y1_FrameStrobe[7] Tile_X0Y1_DSP_bot.Inst_DSP_bot_ConfigMem.Inst_frame7_bit0.Q
+ VPWR VGND sg13g2_dlhq_1
X_5846_ Tile_X0Y1_FrameData[5] Tile_X0Y1_FrameStrobe[5] Tile_X0Y1_DSP_bot.Inst_DSP_bot_ConfigMem.Inst_frame5_bit5.Q
+ VPWR VGND sg13g2_dlhq_1
X_4659_ _0129_ _0134_ Tile_X0Y0_DSP_top.Inst_DSP_top_ConfigMem.Inst_frame3_bit4.Q
+ _0411_ VPWR VGND sg13g2_mux2_1
X_2989_ _1366_ _1365_ _1364_ VPWR VGND sg13g2_nand2b_1
X_4728_ VGND VPWR _0469_ _0473_ _0476_ _0475_ sg13g2_a21oi_1
X_5777_ Tile_X0Y1_FrameData[10] Tile_X0Y1_FrameStrobe[3] Tile_X0Y1_DSP_bot.Inst_DSP_bot_ConfigMem.Inst_frame3_bit10.Q
+ VPWR VGND sg13g2_dlhq_1
XFILLER_21_176 VPWR VGND sg13g2_fill_1
XFILLER_107_21 VPWR VGND sg13g2_fill_2
X_6329_ Tile_X0Y0_DSP_top.Inst_DSP_top_switch_matrix.WW4BEG0 Tile_X0Y0_WW4BEG[12]
+ VPWR VGND sg13g2_buf_1
XFILLER_84_360 VPWR VGND sg13g2_fill_1
XFILLER_32_61 VPWR VGND sg13g2_fill_2
XFILLER_32_94 VPWR VGND sg13g2_fill_2
XFILLER_67_316 VPWR VGND sg13g2_fill_1
X_3961_ Tile_X0Y0_DSP_top.Inst_DSP_top_ConfigMem.Inst_frame11_bit28.Q _2246_ _2247_
+ _2253_ _2252_ Tile_X0Y0_DSP_top.Inst_DSP_top_ConfigMem.Inst_frame11_bit29.Q Tile_X0Y0_DSP_top.Inst_DSP_top_switch_matrix.E6BEG0
+ VPWR VGND sg13g2_mux4_1
X_5700_ Tile_X0Y1_FrameData[23] Tile_X0Y1_FrameStrobe[1] Tile_X0Y1_DSP_bot.Inst_DSP_bot_ConfigMem.Inst_frame1_bit23.Q
+ VPWR VGND sg13g2_dlhq_1
X_2912_ Tile_X0Y1_DSP_bot.Inst_DSP_bot_ConfigMem.Inst_frame5_bit8.Q Tile_X0Y1_NN4END[3]
+ Tile_X0Y1_E2END[6] Tile_X0Y0_S2MID[6] Tile_X0Y1_W2END[6] Tile_X0Y1_DSP_bot.Inst_DSP_bot_ConfigMem.Inst_frame5_bit9.Q
+ _1290_ VPWR VGND sg13g2_mux4_1
XFILLER_35_257 VPWR VGND sg13g2_fill_1
XFILLER_35_235 VPWR VGND sg13g2_fill_1
X_5562_ Tile_X0Y0_FrameData[19] Tile_X0Y1_FrameStrobe[11] Tile_X0Y0_DSP_top.Inst_DSP_top_ConfigMem.Inst_frame11_bit19.Q
+ VPWR VGND sg13g2_dlhq_1
X_3892_ Tile_X0Y0_DSP_top.Inst_DSP_top_ConfigMem.Inst_frame10_bit11.Q Tile_X0Y0_E6END[1]
+ Tile_X0Y0_S4END[1] Tile_X0Y0_S2END[2] Tile_X0Y0_DSP_top.Inst_DSP_top_switch_matrix.bot2top0
+ Tile_X0Y0_DSP_top.Inst_DSP_top_ConfigMem.Inst_frame10_bit10.Q Tile_X0Y0_DSP_top.Inst_DSP_top_switch_matrix.S4BEG0
+ VPWR VGND sg13g2_mux4_1
X_2774_ _1156_ _1154_ _1155_ VPWR VGND sg13g2_nand2_1
X_5631_ _2503_ VGND VPWR Tile_X0Y0_DSP_top.Inst_DSP_top_switch_matrix.inst_cus_mux41_buf_top2bot3.X
+ Tile_X0Y1_DSP_bot.Inst_MULADD.A_reg\[7\] clknet_3_4_0_Tile_X0Y1_UserCLK_regs sg13g2_dfrbpq_1
X_2843_ _1221_ _1198_ _1223_ VPWR VGND sg13g2_xor2_1
X_4513_ _0271_ _0270_ Tile_X0Y1_DSP_bot.Inst_DSP_bot_ConfigMem.Inst_frame4_bit6.Q
+ VPWR VGND sg13g2_nand2b_1
X_4375_ Tile_X0Y0_DSP_top.Inst_DSP_top_ConfigMem.Inst_frame4_bit19.Q VPWR _0138_ VGND
+ Tile_X0Y0_DSP_top.Inst_DSP_top_ConfigMem.Inst_frame4_bit18.Q _0136_ sg13g2_o21ai_1
X_4444_ Tile_X0Y0_DSP_top.Inst_DSP_top_ConfigMem.Inst_frame2_bit30.Q VPWR _0205_ VGND
+ Tile_X0Y0_DSP_top.Inst_DSP_top_ConfigMem.Inst_frame2_bit29.Q _0202_ sg13g2_o21ai_1
X_5493_ Tile_X0Y0_FrameData[24] Tile_X0Y1_FrameStrobe[9] Tile_X0Y0_DSP_top.Inst_DSP_top_ConfigMem.Inst_frame9_bit24.Q
+ VPWR VGND sg13g2_dlhq_1
X_3326_ VPWR _1690_ _1689_ VGND sg13g2_inv_1
X_6114_ VPWR VGND _2512_ sg13g2_tiehi
X_3188_ Tile_X0Y0_DSP_top.Inst_DSP_top_ConfigMem.Inst_frame0_bit16.Q Tile_X0Y1_N4END[7]
+ _1560_ VPWR VGND sg13g2_nor2b_1
X_3257_ _1624_ VPWR _1625_ VGND Tile_X0Y1_DSP_bot.Inst_DSP_bot_ConfigMem.Inst_frame1_bit21.Q
+ _1621_ sg13g2_o21ai_1
X_6045_ Tile_X0Y1_FrameData[30] Tile_X0Y1_FrameStrobe[12] Tile_X0Y1_DSP_bot.Inst_DSP_bot_ConfigMem.Inst_frame12_bit30.Q
+ VPWR VGND sg13g2_dlhq_1
XFILLER_37_17 VPWR VGND sg13g2_fill_2
X_5829_ Tile_X0Y1_FrameData[22] Tile_X0Y1_FrameStrobe[5] Tile_X0Y1_DSP_bot.Inst_DSP_bot_ConfigMem.Inst_frame5_bit22.Q
+ VPWR VGND sg13g2_dlhq_1
XFILLER_76_124 VPWR VGND sg13g2_decap_4
XFILLER_17_202 VPWR VGND sg13g2_fill_2
XFILLER_27_72 VPWR VGND sg13g2_decap_4
X_4160_ Tile_X0Y1_DSP_bot.Inst_DSP_bot_ConfigMem.Inst_frame11_bit28.Q VPWR _2409_
+ VGND Tile_X0Y1_DSP_bot.Inst_DSP_bot_ConfigMem.Inst_frame11_bit27.Q _2408_ sg13g2_o21ai_1
X_3111_ _1486_ VPWR _1487_ VGND Tile_X0Y0_DSP_top.Inst_DSP_top_ConfigMem.Inst_frame7_bit23.Q
+ _1485_ sg13g2_o21ai_1
XFILLER_48_360 VPWR VGND sg13g2_fill_1
X_3042_ _1416_ _1418_ _1405_ _1419_ VPWR VGND sg13g2_nand3_1
X_4091_ _2353_ Tile_X0Y1_DSP_bot.Inst_DSP_bot_ConfigMem.Inst_frame2_bit2.Q _2350_
+ VPWR VGND sg13g2_nand2_1
X_3875_ VGND VPWR _2188_ _2187_ _2181_ sg13g2_or2_1
X_3944_ _2238_ VPWR _2239_ VGND Tile_X0Y0_DSP_top.Inst_DSP_top_ConfigMem.Inst_frame11_bit20.Q
+ _0388_ sg13g2_o21ai_1
X_4993_ VGND VPWR Tile_X0Y1_DSP_bot.Inst_DSP_bot_ConfigMem.Inst_frame0_bit14.Q _0287_
+ _0729_ _0728_ sg13g2_a21oi_1
X_5476_ Tile_X0Y0_FrameData[9] Tile_X0Y1_FrameStrobe[8] Tile_X0Y0_DSP_top.Inst_DSP_top_ConfigMem.Inst_frame8_bit9.Q
+ VPWR VGND sg13g2_dlhq_1
X_5614_ _2481_ VGND VPWR _0010_ Tile_X0Y1_DSP_bot.Inst_MULADD.ACC\[10\] clknet_3_4_0_Tile_X0Y1_UserCLK_regs
+ sg13g2_dfrbpq_1
X_5545_ Tile_X0Y0_FrameData[4] Tile_X0Y1_FrameStrobe[10] Tile_X0Y0_DSP_top.Inst_DSP_top_ConfigMem.Inst_frame10_bit4.Q
+ VPWR VGND sg13g2_dlhq_1
X_2757_ _1139_ _1136_ _1135_ VPWR VGND sg13g2_nand2b_1
X_2826_ _1206_ _1204_ _1205_ VPWR VGND sg13g2_nand2_1
X_2688_ Tile_X0Y1_DSP_bot.A1 _1072_ _1073_ _1067_ Tile_X0Y1_DSP_bot.Inst_DSP_bot_ConfigMem.Inst_frame9_bit24.Q
+ VPWR VGND sg13g2_a22oi_1
X_4289_ VPWR _0052_ Tile_X0Y0_E1END[3] VGND sg13g2_inv_1
X_4358_ VPWR _0121_ Tile_X0Y0_DSP_top.Inst_DSP_top_ConfigMem.Inst_frame10_bit21.Q
+ VGND sg13g2_inv_1
X_3309_ Tile_X0Y1_DSP_bot.Inst_DSP_bot_ConfigMem.Inst_frame2_bit21.Q VPWR _1675_ VGND
+ Tile_X0Y1_DSP_bot.Inst_DSP_bot_ConfigMem.Inst_frame2_bit20.Q Tile_X0Y1_DSP_bot.Inst_DSP_bot_switch_matrix.Q7
+ sg13g2_o21ai_1
X_4427_ _0171_ Tile_X0Y1_DSP_bot.Inst_DSP_bot_ConfigMem.Inst_frame12_bit6.Q _0187_
+ _0188_ VPWR VGND sg13g2_a21o_1
XFILLER_104_77 VPWR VGND sg13g2_decap_4
XFILLER_100_276 VPWR VGND sg13g2_fill_1
XFILLER_81_160 VPWR VGND sg13g2_fill_1
XFILLER_46_308 VPWR VGND sg13g2_fill_2
X_6028_ Tile_X0Y1_FrameData[15] Tile_X0Y1_FrameStrobe[11] Tile_X0Y1_DSP_bot.Inst_DSP_bot_ConfigMem.Inst_frame11_bit15.Q
+ VPWR VGND sg13g2_dlhq_1
XFILLER_13_85 VPWR VGND sg13g2_fill_1
XFILLER_37_308 VPWR VGND sg13g2_fill_2
XFILLER_60_344 VPWR VGND sg13g2_fill_1
XFILLER_60_322 VPWR VGND sg13g2_fill_2
XFILLER_20_208 VPWR VGND sg13g2_decap_4
X_5330_ Tile_X0Y0_FrameData[27] Tile_X0Y1_FrameStrobe[4] Tile_X0Y0_DSP_top.Inst_DSP_top_ConfigMem.Inst_frame4_bit27.Q
+ VPWR VGND sg13g2_dlhq_1
X_3660_ _1995_ _1996_ _1997_ VPWR VGND sg13g2_nor2_1
X_3591_ _1943_ Tile_X0Y1_DSP_bot.Inst_DSP_bot_ConfigMem.Inst_frame12_bit5.Q Tile_X0Y1_DSP_bot.Inst_MULADD.ACC\[14\]
+ VPWR VGND sg13g2_nand2_1
X_2611_ _0974_ _0998_ _0999_ VPWR VGND sg13g2_nor2b_1
XFILLER_9_220 VPWR VGND sg13g2_fill_1
X_2542_ _0935_ _0934_ _0061_ _0931_ _0930_ VPWR VGND sg13g2_a22oi_1
X_5192_ _0917_ VPWR _0918_ VGND Tile_X0Y0_S2END[5] Tile_X0Y0_DSP_top.Inst_DSP_top_ConfigMem.Inst_frame3_bit16.Q
+ sg13g2_o21ai_1
X_5261_ Tile_X0Y0_FrameData[0] Tile_X0Y1_FrameStrobe[1] Tile_X0Y0_DSP_top.Inst_DSP_top_ConfigMem.Inst_frame1_bit0.Q
+ VPWR VGND sg13g2_dlhq_1
XFILLER_48_2 VPWR VGND sg13g2_fill_1
X_4212_ VGND VPWR Tile_X0Y1_DSP_bot.Inst_DSP_bot_ConfigMem.Inst_frame9_bit18.Q _1122_
+ _2451_ _2450_ sg13g2_a21oi_1
X_4143_ Tile_X0Y1_DSP_bot.Inst_DSP_bot_ConfigMem.Inst_frame11_bit21.Q _2393_ _2394_
+ VPWR VGND sg13g2_nor2_1
X_3025_ _1402_ _1386_ _1387_ VPWR VGND sg13g2_xnor2_1
X_4074_ _2341_ Tile_X0Y1_DSP_bot.Inst_DSP_bot_ConfigMem.Inst_frame3_bit1.Q _2344_
+ _2345_ VPWR VGND sg13g2_a21o_1
XFILLER_18_19 VPWR VGND sg13g2_fill_1
X_3858_ _2166_ VPWR _2179_ VGND _2177_ _2178_ sg13g2_o21ai_1
X_3927_ Tile_X0Y0_DSP_top.Inst_DSP_top_ConfigMem.Inst_frame11_bit15.Q Tile_X0Y0_DSP_top.Inst_DSP_top_switch_matrix.N1END2
+ Tile_X0Y0_S1END[2] Tile_X0Y0_E1END[2] Tile_X0Y0_DSP_top.Inst_DSP_top_switch_matrix.bot2top2
+ Tile_X0Y0_DSP_top.Inst_DSP_top_ConfigMem.Inst_frame11_bit14.Q _2224_ VPWR VGND sg13g2_mux4_1
X_4976_ VGND VPWR Tile_X0Y0_DSP_top.Inst_DSP_top_ConfigMem.Inst_frame2_bit1.Q _0711_
+ _0713_ _0712_ sg13g2_a21oi_1
X_3789_ Tile_X0Y0_DSP_top.Inst_DSP_top_ConfigMem.Inst_frame3_bit29.Q VPWR _2118_ VGND
+ _0021_ Tile_X0Y0_DSP_top.Inst_DSP_top_ConfigMem.Inst_frame3_bit28.Q sg13g2_o21ai_1
X_5459_ Tile_X0Y0_FrameData[26] Tile_X0Y1_FrameStrobe[8] Tile_X0Y0_DSP_top.Inst_DSP_top_ConfigMem.Inst_frame8_bit26.Q
+ VPWR VGND sg13g2_dlhq_1
X_5528_ Tile_X0Y0_FrameData[21] Tile_X0Y1_FrameStrobe[10] Tile_X0Y0_DSP_top.Inst_DSP_top_ConfigMem.Inst_frame10_bit21.Q
+ VPWR VGND sg13g2_dlhq_1
X_2809_ _0816_ _1188_ _1189_ VPWR VGND sg13g2_nor2_1
XFILLER_6_223 VPWR VGND sg13g2_fill_2
XFILLER_24_62 VPWR VGND sg13g2_fill_1
X_4761_ Tile_X0Y0_DSP_top.Inst_DSP_top_ConfigMem.Inst_frame4_bit8.Q Tile_X0Y1_N2MID[3]
+ Tile_X0Y1_N4END[7] Tile_X0Y0_E1END[1] Tile_X0Y0_E2END[3] Tile_X0Y0_DSP_top.Inst_DSP_top_ConfigMem.Inst_frame4_bit9.Q
+ _0507_ VPWR VGND sg13g2_mux4_1
X_3712_ VPWR VGND _2045_ Tile_X0Y0_DSP_top.Inst_DSP_top_ConfigMem.Inst_frame1_bit27.Q
+ _2042_ _2037_ _2046_ _2040_ sg13g2_a221oi_1
X_4830_ _0573_ Tile_X0Y0_DSP_top.Inst_DSP_top_ConfigMem.Inst_frame6_bit6.Q Tile_X0Y0_E2MID[1]
+ VPWR VGND sg13g2_nand2b_1
X_4692_ Tile_X0Y1_DSP_bot.Inst_DSP_bot_ConfigMem.Inst_frame4_bit24.Q Tile_X0Y1_N1END[3]
+ Tile_X0Y1_N2END[7] Tile_X0Y1_E1END[3] Tile_X0Y1_E2END[7] Tile_X0Y1_DSP_bot.Inst_DSP_bot_ConfigMem.Inst_frame4_bit25.Q
+ _0442_ VPWR VGND sg13g2_mux4_1
X_6500_ Tile_X0Y1_WW4END[7] Tile_X0Y1_WW4BEG[3] VPWR VGND sg13g2_buf_1
X_3643_ _1970_ _1981_ Tile_X0Y0_DSP_top.Inst_DSP_top_switch_matrix.E2BEG6 VPWR VGND
+ sg13g2_nor2_1
X_5313_ Tile_X0Y0_FrameData[12] Tile_X0Y1_FrameStrobe[3] Tile_X0Y0_DSP_top.Inst_DSP_top_ConfigMem.Inst_frame3_bit12.Q
+ VPWR VGND sg13g2_dlhq_1
X_6293_ Tile_X0Y0_W2END[4] Tile_X0Y0_W2BEG[4] VPWR VGND sg13g2_buf_1
X_3574_ _1809_ VPWR _1926_ VGND _1923_ _1924_ sg13g2_o21ai_1
X_6362_ Tile_X0Y1_E6END[11] Tile_X0Y1_E6BEG[9] VPWR VGND sg13g2_buf_1
X_6431_ Tile_X0Y0_DSP_top.Inst_DSP_top_switch_matrix.JS2BEG6 Tile_X0Y1_S2BEGb[6] VPWR
+ VGND sg13g2_buf_1
X_5244_ Tile_X0Y0_FrameData[17] Tile_X0Y1_FrameStrobe[1] Tile_X0Y0_DSP_top.Inst_DSP_top_ConfigMem.Inst_frame1_bit17.Q
+ VPWR VGND sg13g2_dlhq_1
XFILLER_83_200 VPWR VGND sg13g2_fill_1
XFILLER_68_241 VPWR VGND sg13g2_decap_8
X_5175_ _0901_ _0869_ _0899_ VPWR VGND sg13g2_nand2_1
X_4126_ _2379_ Tile_X0Y1_DSP_bot.Inst_DSP_bot_ConfigMem.Inst_frame11_bit13.Q _1901_
+ VPWR VGND sg13g2_nand2_1
XFILLER_83_288 VPWR VGND sg13g2_decap_8
XFILLER_51_141 VPWR VGND sg13g2_decap_4
X_3008_ _1374_ _1384_ _1385_ VPWR VGND sg13g2_nor2_1
XFILLER_43_108 VPWR VGND sg13g2_fill_2
X_4057_ Tile_X0Y1_DSP_bot.Inst_DSP_bot_ConfigMem.Inst_frame11_bit2.Q Tile_X0Y1_DSP_bot.Inst_DSP_bot_switch_matrix.Q3
+ _0151_ Tile_X0Y0_DSP_top.Inst_DSP_top_switch_matrix.N2BEGb3 _0171_ Tile_X0Y1_DSP_bot.Inst_DSP_bot_ConfigMem.Inst_frame11_bit3.Q
+ Tile_X0Y1_DSP_bot.Inst_DSP_bot_switch_matrix.E1BEG0 VPWR VGND sg13g2_mux4_1
XFILLER_24_344 VPWR VGND sg13g2_fill_2
X_4959_ VGND VPWR _0696_ _0695_ _0694_ sg13g2_or2_1
XFILLER_15_311 VPWR VGND sg13g2_fill_1
XFILLER_42_185 VPWR VGND sg13g2_fill_1
XFILLER_30_347 VPWR VGND sg13g2_fill_1
XFILLER_51_82 VPWR VGND sg13g2_fill_2
X_3290_ VGND VPWR Tile_X0Y1_DSP_bot.Inst_DSP_bot_ConfigMem.Inst_frame8_bit25.Q _0488_
+ _1657_ Tile_X0Y1_DSP_bot.Inst_DSP_bot_ConfigMem.Inst_frame8_bit27.Q sg13g2_a21oi_1
X_5931_ Tile_X0Y1_FrameData[16] Tile_X0Y1_FrameStrobe[8] Tile_X0Y1_DSP_bot.Inst_DSP_bot_ConfigMem.Inst_frame8_bit16.Q
+ VPWR VGND sg13g2_dlhq_1
X_5862_ Tile_X0Y1_FrameData[21] Tile_X0Y1_FrameStrobe[6] Tile_X0Y1_DSP_bot.Inst_DSP_bot_ConfigMem.Inst_frame6_bit21.Q
+ VPWR VGND sg13g2_dlhq_1
XFILLER_18_182 VPWR VGND sg13g2_fill_1
X_4744_ VGND VPWR Tile_X0Y0_DSP_top.Inst_DSP_top_ConfigMem.Inst_frame8_bit18.Q _0490_
+ _0491_ Tile_X0Y0_DSP_top.Inst_DSP_top_ConfigMem.Inst_frame8_bit19.Q sg13g2_a21oi_1
X_4813_ VPWR VGND _0555_ Tile_X0Y0_DSP_top.Inst_DSP_top_ConfigMem.Inst_frame1_bit14.Q
+ _0554_ Tile_X0Y0_DSP_top.Inst_DSP_top_ConfigMem.Inst_frame1_bit13.Q _0556_ _0553_
+ sg13g2_a221oi_1
X_5793_ Tile_X0Y1_FrameData[26] Tile_X0Y1_FrameStrobe[4] Tile_X0Y1_DSP_bot.Inst_DSP_bot_ConfigMem.Inst_frame4_bit26.Q
+ VPWR VGND sg13g2_dlhq_1
X_4675_ Tile_X0Y1_DSP_bot.Inst_DSP_bot_ConfigMem.Inst_frame4_bit21.Q VPWR _0426_ VGND
+ Tile_X0Y1_W1END[0] Tile_X0Y1_DSP_bot.Inst_DSP_bot_ConfigMem.Inst_frame4_bit20.Q
+ sg13g2_o21ai_1
XFILLER_21_336 VPWR VGND sg13g2_fill_2
XFILLER_31_19 VPWR VGND sg13g2_fill_2
X_6276_ Tile_X0Y0_DSP_top.NN4BEG_outbuf_8.A Tile_X0Y0_NN4BEG[8] VPWR VGND sg13g2_buf_1
X_5227_ Tile_X0Y0_FrameData[2] Tile_X0Y1_FrameStrobe[0] Tile_X0Y0_DSP_top.Inst_DSP_top_ConfigMem.Inst_frame0_bit2.Q
+ VPWR VGND sg13g2_dlhq_1
X_3626_ _1965_ Tile_X0Y1_DSP_bot.Inst_DSP_bot_ConfigMem.Inst_frame12_bit3.Q Tile_X0Y1_DSP_bot.Inst_MULADD.ACC\[15\]
+ VPWR VGND sg13g2_nand2_1
X_6414_ Tile_X0Y1_DSP_bot.Inst_DSP_bot_switch_matrix.S1BEG1 Tile_X0Y1_S1BEG[1] VPWR
+ VGND sg13g2_buf_1
X_6345_ Tile_X0Y1_E2MID[0] Tile_X0Y1_E2BEGb[0] VPWR VGND sg13g2_buf_1
X_3488_ Tile_X0Y1_DSP_bot.Inst_DSP_bot_ConfigMem.Inst_frame5_bit22.Q Tile_X0Y1_NN4END[2]
+ Tile_X0Y1_E2END[1] Tile_X0Y0_S2MID[1] Tile_X0Y1_W2END[1] Tile_X0Y1_DSP_bot.Inst_DSP_bot_ConfigMem.Inst_frame5_bit23.Q
+ _1844_ VPWR VGND sg13g2_mux4_1
X_3557_ _1909_ VPWR _1910_ VGND _1904_ _1907_ sg13g2_o21ai_1
X_5089_ Tile_X0Y0_DSP_top.Inst_DSP_top_switch_matrix.bot2top5 Tile_X0Y0_DSP_top.Inst_DSP_top_switch_matrix.bot2top6
+ Tile_X0Y0_DSP_top.Inst_DSP_top_ConfigMem.Inst_frame2_bit8.Q _0820_ VPWR VGND sg13g2_mux2_1
X_4109_ Tile_X0Y1_DSP_bot.Inst_DSP_bot_ConfigMem.Inst_frame12_bit22.Q Tile_X0Y1_DSP_bot.Inst_DSP_bot_switch_matrix.Q6
+ _1019_ _1256_ _1802_ Tile_X0Y1_DSP_bot.Inst_DSP_bot_ConfigMem.Inst_frame12_bit23.Q
+ _2367_ VPWR VGND sg13g2_mux4_1
X_5158_ VGND VPWR Tile_X0Y1_DSP_bot.Inst_DSP_bot_ConfigMem.Inst_frame2_bit4.Q Tile_X0Y0_SS4END[6]
+ _0886_ _0885_ sg13g2_a21oi_1
XFILLER_72_48 VPWR VGND sg13g2_fill_2
XFILLER_12_358 VPWR VGND sg13g2_fill_2
XANTENNA_81 VPWR VGND Tile_X0Y0_FrameData[6] sg13g2_antennanp
XANTENNA_70 VPWR VGND Tile_X0Y0_FrameData[6] sg13g2_antennanp
XANTENNA_92 VPWR VGND Tile_X0Y0_S2MID[4] sg13g2_antennanp
XFILLER_79_303 VPWR VGND sg13g2_fill_1
Xclkbuf_3_2_0_Tile_X0Y1_UserCLK_regs clknet_0_Tile_X0Y1_UserCLK_regs clknet_3_2_0_Tile_X0Y1_UserCLK_regs
+ VPWR VGND sg13g2_buf_8
XFILLER_47_255 VPWR VGND sg13g2_fill_1
X_2790_ _1171_ VPWR _1172_ VGND Tile_X0Y0_W1END[1] Tile_X0Y0_DSP_top.Inst_DSP_top_ConfigMem.Inst_frame2_bit24.Q
+ sg13g2_o21ai_1
XFILLER_30_122 VPWR VGND sg13g2_fill_2
X_6130_ VPWR VGND _2528_ sg13g2_tiehi
X_3342_ VGND VPWR Tile_X0Y1_DSP_bot.Inst_DSP_bot_ConfigMem.Inst_frame3_bit24.Q _0131_
+ _1706_ _1705_ sg13g2_a21oi_1
X_4460_ Tile_X0Y1_DSP_bot.Inst_DSP_bot_ConfigMem.Inst_frame2_bit13.Q Tile_X0Y1_N2END[4]
+ Tile_X0Y1_E2END[4] Tile_X0Y1_E1END[2] Tile_X0Y1_E6END[0] Tile_X0Y1_DSP_bot.Inst_DSP_bot_ConfigMem.Inst_frame2_bit12.Q
+ _0220_ VPWR VGND sg13g2_mux4_1
X_3411_ _1771_ Tile_X0Y1_DSP_bot.Inst_DSP_bot_ConfigMem.Inst_frame6_bit30.Q Tile_X0Y1_E2MID[1]
+ VPWR VGND sg13g2_nand2b_1
X_4391_ _0153_ Tile_X0Y1_DSP_bot.Inst_DSP_bot_ConfigMem.Inst_frame12_bit6.Q _0151_
+ VPWR VGND sg13g2_nand2_1
XFILLER_53_203 VPWR VGND sg13g2_fill_1
XFILLER_38_288 VPWR VGND sg13g2_fill_2
XFILLER_38_222 VPWR VGND sg13g2_fill_2
X_3273_ _1639_ VPWR _1640_ VGND Tile_X0Y1_DSP_bot.Inst_DSP_bot_ConfigMem.Inst_frame1_bit28.Q
+ _0127_ sg13g2_o21ai_1
X_6061_ Tile_X0Y1_FrameData[14] Tile_X0Y1_FrameStrobe[12] Tile_X0Y1_DSP_bot.Inst_DSP_bot_ConfigMem.Inst_frame12_bit14.Q
+ VPWR VGND sg13g2_dlhq_1
X_5012_ VGND VPWR Tile_X0Y1_DSP_bot.Inst_DSP_bot_ConfigMem.Inst_frame7_bit6.Q _0186_
+ _0747_ _0746_ sg13g2_a21oi_1
X_5914_ Tile_X0Y1_FrameData[1] Tile_X0Y1_FrameStrobe[7] Tile_X0Y1_DSP_bot.Inst_DSP_bot_ConfigMem.Inst_frame7_bit1.Q
+ VPWR VGND sg13g2_dlhq_1
X_5845_ Tile_X0Y1_FrameData[6] Tile_X0Y1_FrameStrobe[5] Tile_X0Y1_DSP_bot.Inst_DSP_bot_ConfigMem.Inst_frame5_bit6.Q
+ VPWR VGND sg13g2_dlhq_1
X_4658_ Tile_X0Y0_DSP_top.Inst_DSP_top_switch_matrix.bot2top5 Tile_X0Y0_DSP_top.Inst_DSP_top_switch_matrix.bot2top6
+ Tile_X0Y0_DSP_top.Inst_DSP_top_ConfigMem.Inst_frame3_bit4.Q _0410_ VPWR VGND sg13g2_mux2_1
X_2988_ _1365_ _1339_ _1341_ VPWR VGND sg13g2_xnor2_1
X_4727_ _0038_ VPWR _0475_ VGND Tile_X0Y1_DSP_bot.Inst_DSP_bot_ConfigMem.Inst_frame4_bit30.Q
+ _0474_ sg13g2_o21ai_1
X_3609_ _1929_ _1928_ _1954_ VPWR VGND sg13g2_xor2_1
X_5776_ Tile_X0Y1_FrameData[11] Tile_X0Y1_FrameStrobe[3] Tile_X0Y1_DSP_bot.Inst_DSP_bot_ConfigMem.Inst_frame3_bit11.Q
+ VPWR VGND sg13g2_dlhq_1
X_6259_ Tile_X0Y1_N4END[15] Tile_X0Y0_N4BEG[7] VPWR VGND sg13g2_buf_1
X_4589_ VGND VPWR Tile_X0Y0_DSP_top.Inst_DSP_top_ConfigMem.Inst_frame4_bit4.Q Tile_X0Y0_DSP_top.Inst_DSP_top_switch_matrix.bot2top6
+ _0343_ _0342_ sg13g2_a21oi_1
X_6328_ Tile_X0Y0_WW4END[15] Tile_X0Y0_WW4BEG[11] VPWR VGND sg13g2_buf_1
XFILLER_12_199 VPWR VGND sg13g2_fill_2
XFILLER_16_85 VPWR VGND sg13g2_fill_1
XFILLER_106_260 VPWR VGND sg13g2_fill_1
XFILLER_57_70 VPWR VGND sg13g2_fill_2
X_3960_ Tile_X0Y0_DSP_top.Inst_DSP_top_ConfigMem.Inst_frame11_bit26.Q Tile_X0Y0_DSP_top.Inst_DSP_top_switch_matrix.bot2top6
+ Tile_X0Y0_DSP_top.Inst_DSP_top_switch_matrix.bot2top7 Tile_X0Y0_DSP_top.Inst_DSP_top_switch_matrix.bot2top8
+ Tile_X0Y0_DSP_top.Inst_DSP_top_switch_matrix.bot2top9 Tile_X0Y0_DSP_top.Inst_DSP_top_ConfigMem.Inst_frame11_bit27.Q
+ _2253_ VPWR VGND sg13g2_mux4_1
X_3891_ Tile_X0Y0_DSP_top.Inst_DSP_top_ConfigMem.Inst_frame11_bit12.Q Tile_X0Y0_DSP_top.Inst_DSP_top_switch_matrix.bot2top6
+ _0433_ Tile_X0Y0_DSP_top.Inst_DSP_top_switch_matrix.JN2BEG2 _0357_ Tile_X0Y0_DSP_top.Inst_DSP_top_ConfigMem.Inst_frame11_bit13.Q
+ Tile_X0Y0_DSP_top.Inst_DSP_top_switch_matrix.E1BEG3 VPWR VGND sg13g2_mux4_1
X_2911_ Tile_X0Y1_DSP_bot.Inst_DSP_bot_ConfigMem.Inst_frame9_bit30.Q VPWR _1289_ VGND
+ Tile_X0Y1_DSP_bot.Inst_DSP_bot_ConfigMem.Inst_frame0_bit9.Q _1288_ sg13g2_o21ai_1
X_5561_ Tile_X0Y0_FrameData[20] Tile_X0Y1_FrameStrobe[11] Tile_X0Y0_DSP_top.Inst_DSP_top_ConfigMem.Inst_frame11_bit20.Q
+ VPWR VGND sg13g2_dlhq_1
X_5492_ Tile_X0Y0_FrameData[25] Tile_X0Y1_FrameStrobe[9] Tile_X0Y0_DSP_top.Inst_DSP_top_ConfigMem.Inst_frame9_bit25.Q
+ VPWR VGND sg13g2_dlhq_1
X_2773_ _1015_ VPWR _1155_ VGND _0745_ _1016_ sg13g2_o21ai_1
X_5630_ _2502_ VGND VPWR Tile_X0Y0_DSP_top.Inst_DSP_top_switch_matrix.inst_cus_mux41_buf_top2bot2.X
+ Tile_X0Y1_DSP_bot.Inst_MULADD.A_reg\[6\] clknet_3_4_0_Tile_X0Y1_UserCLK_regs sg13g2_dfrbpq_1
X_2842_ _1222_ _1199_ _1220_ VPWR VGND sg13g2_nand2_1
X_4512_ Tile_X0Y1_DSP_bot.Inst_DSP_bot_ConfigMem.Inst_frame4_bit4.Q Tile_X0Y1_N2END[2]
+ Tile_X0Y1_N4END[2] Tile_X0Y1_E1END[0] Tile_X0Y1_E2END[2] Tile_X0Y1_DSP_bot.Inst_DSP_bot_ConfigMem.Inst_frame4_bit5.Q
+ _0270_ VPWR VGND sg13g2_mux4_1
X_4374_ Tile_X0Y0_DSP_top.Inst_DSP_top_ConfigMem.Inst_frame4_bit16.Q Tile_X0Y0_DSP_top.Inst_DSP_top_switch_matrix.bot2top5
+ Tile_X0Y0_DSP_top.Inst_DSP_top_switch_matrix.bot2top6 Tile_X0Y0_DSP_top.Inst_DSP_top_switch_matrix.bot2top7
+ Tile_X0Y0_DSP_top.Inst_DSP_top_switch_matrix.bot2top9 Tile_X0Y0_DSP_top.Inst_DSP_top_ConfigMem.Inst_frame4_bit17.Q
+ _0137_ VPWR VGND sg13g2_mux4_1
X_4443_ VGND VPWR Tile_X0Y0_DSP_top.Inst_DSP_top_ConfigMem.Inst_frame2_bit28.Q _0132_
+ _0204_ _0203_ sg13g2_a21oi_1
X_6113_ VPWR VGND _2511_ sg13g2_tiehi
X_3256_ _1623_ Tile_X0Y1_DSP_bot.Inst_DSP_bot_ConfigMem.Inst_frame1_bit22.Q _1624_
+ VPWR VGND sg13g2_nor2b_1
X_3325_ _1689_ _1687_ _1688_ Tile_X0Y1_DSP_bot.Inst_MULADD.ACC\[9\] Tile_X0Y1_DSP_bot.Inst_DSP_bot_ConfigMem.Inst_frame12_bit3.Q
+ VPWR VGND sg13g2_a22oi_1
X_6044_ Tile_X0Y1_FrameData[31] Tile_X0Y1_FrameStrobe[12] Tile_X0Y1_DSP_bot.Inst_DSP_bot_ConfigMem.Inst_frame12_bit31.Q
+ VPWR VGND sg13g2_dlhq_1
X_3187_ Tile_X0Y0_W2END[3] Tile_X0Y0_DSP_top.Inst_DSP_top_switch_matrix.JN2BEG3 Tile_X0Y0_DSP_top.Inst_DSP_top_ConfigMem.Inst_frame0_bit16.Q
+ _1559_ VPWR VGND sg13g2_mux2_1
X_5759_ Tile_X0Y1_FrameData[28] Tile_X0Y1_FrameStrobe[3] Tile_X0Y1_DSP_bot.Inst_DSP_bot_ConfigMem.Inst_frame3_bit28.Q
+ VPWR VGND sg13g2_dlhq_1
X_5828_ Tile_X0Y1_FrameData[23] Tile_X0Y1_FrameStrobe[5] Tile_X0Y1_DSP_bot.Inst_DSP_bot_ConfigMem.Inst_frame5_bit23.Q
+ VPWR VGND sg13g2_dlhq_1
XFILLER_25_280 VPWR VGND sg13g2_fill_1
XFILLER_40_283 VPWR VGND sg13g2_fill_2
XFILLER_99_239 VPWR VGND sg13g2_fill_2
X_3110_ VGND VPWR Tile_X0Y0_DSP_top.Inst_DSP_top_ConfigMem.Inst_frame7_bit23.Q _1483_
+ _1486_ Tile_X0Y0_DSP_top.Inst_DSP_top_ConfigMem.Inst_frame8_bit16.Q sg13g2_a21oi_1
XFILLER_4_55 VPWR VGND sg13g2_fill_1
XFILLER_82_117 VPWR VGND sg13g2_fill_1
X_3041_ _1188_ _1260_ _1418_ VPWR VGND sg13g2_nor2_1
X_4090_ VGND VPWR Tile_X0Y1_DSP_bot.Inst_DSP_bot_ConfigMem.Inst_frame2_bit0.Q _0130_
+ _2352_ _2351_ sg13g2_a21oi_1
X_3874_ Tile_X0Y0_DSP_top.Inst_DSP_top_ConfigMem.Inst_frame4_bit3.Q VPWR _2187_ VGND
+ _2185_ _2186_ sg13g2_o21ai_1
X_3943_ _2238_ Tile_X0Y0_DSP_top.Inst_DSP_top_ConfigMem.Inst_frame11_bit20.Q _0517_
+ VPWR VGND sg13g2_nand2_1
X_2825_ _1205_ _1085_ _1133_ VPWR VGND sg13g2_xnor2_1
X_5613_ _2482_ VGND VPWR _0009_ Tile_X0Y1_DSP_bot.Inst_MULADD.ACC\[9\] clknet_3_0_0_Tile_X0Y1_UserCLK_regs
+ sg13g2_dfrbpq_1
X_4992_ Tile_X0Y1_DSP_bot.Inst_DSP_bot_ConfigMem.Inst_frame0_bit15.Q VPWR _0728_ VGND
+ Tile_X0Y1_W6END[0] Tile_X0Y1_DSP_bot.Inst_DSP_bot_ConfigMem.Inst_frame0_bit14.Q
+ sg13g2_o21ai_1
X_5475_ Tile_X0Y0_FrameData[10] Tile_X0Y1_FrameStrobe[8] Tile_X0Y0_DSP_top.Inst_DSP_top_ConfigMem.Inst_frame8_bit10.Q
+ VPWR VGND sg13g2_dlhq_1
X_5544_ Tile_X0Y0_FrameData[5] Tile_X0Y1_FrameStrobe[10] Tile_X0Y0_DSP_top.Inst_DSP_top_ConfigMem.Inst_frame10_bit5.Q
+ VPWR VGND sg13g2_dlhq_1
X_2756_ _1131_ VPWR _1138_ VGND _1128_ _1132_ sg13g2_o21ai_1
X_2687_ VGND VPWR Tile_X0Y1_DSP_bot.Inst_DSP_bot_ConfigMem.Inst_frame9_bit25.Q _1064_
+ _1073_ Tile_X0Y1_DSP_bot.Inst_DSP_bot_ConfigMem.Inst_frame9_bit24.Q sg13g2_a21oi_1
X_4426_ Tile_X0Y1_DSP_bot.Inst_DSP_bot_ConfigMem.Inst_frame12_bit7.Q VPWR _0187_ VGND
+ Tile_X0Y1_DSP_bot.Inst_DSP_bot_ConfigMem.Inst_frame12_bit6.Q _0186_ sg13g2_o21ai_1
XFILLER_104_34 VPWR VGND sg13g2_fill_1
X_4357_ VPWR _0120_ Tile_X0Y0_DSP_top.Inst_DSP_top_ConfigMem.Inst_frame11_bit26.Q
+ VGND sg13g2_inv_1
X_4288_ VPWR _0051_ Tile_X0Y0_S2MID[5] VGND sg13g2_inv_1
X_3308_ _1673_ VPWR _1674_ VGND Tile_X0Y1_DSP_bot.Inst_DSP_bot_ConfigMem.Inst_frame2_bit20.Q
+ Tile_X0Y1_DSP_bot.Inst_DSP_bot_switch_matrix.Q4 sg13g2_o21ai_1
X_6027_ Tile_X0Y1_FrameData[16] Tile_X0Y1_FrameStrobe[11] Tile_X0Y1_DSP_bot.Inst_DSP_bot_ConfigMem.Inst_frame11_bit16.Q
+ VPWR VGND sg13g2_dlhq_1
X_3239_ _1607_ Tile_X0Y1_DSP_bot.Inst_DSP_bot_ConfigMem.Inst_frame3_bit31.Q _1608_
+ VPWR VGND sg13g2_nor2b_1
XFILLER_108_344 VPWR VGND sg13g2_fill_2
X_5260_ Tile_X0Y0_FrameData[1] Tile_X0Y1_FrameStrobe[1] Tile_X0Y0_DSP_top.Inst_DSP_top_ConfigMem.Inst_frame1_bit1.Q
+ VPWR VGND sg13g2_dlhq_1
X_3590_ _1942_ _1461_ _1940_ VPWR VGND sg13g2_xnor2_1
X_2610_ _0997_ _0993_ _0998_ VPWR VGND sg13g2_xor2_1
X_2541_ _0932_ _0933_ _0060_ _0934_ VPWR VGND sg13g2_mux2_1
X_5191_ _0917_ Tile_X0Y0_DSP_top.Inst_DSP_top_ConfigMem.Inst_frame3_bit16.Q Tile_X0Y0_W1END[1]
+ VPWR VGND sg13g2_nand2b_1
X_4073_ Tile_X0Y1_DSP_bot.Inst_DSP_bot_ConfigMem.Inst_frame3_bit2.Q VPWR _2344_ VGND
+ Tile_X0Y1_DSP_bot.Inst_DSP_bot_ConfigMem.Inst_frame3_bit1.Q _2343_ sg13g2_o21ai_1
X_4211_ Tile_X0Y1_DSP_bot.Inst_DSP_bot_ConfigMem.Inst_frame9_bit18.Q _0874_ _2450_
+ VPWR VGND sg13g2_nor2_1
X_4142_ Tile_X0Y1_DSP_bot.Inst_DSP_bot_ConfigMem.Inst_frame11_bit19.Q Tile_X0Y1_N1END[1]
+ Tile_X0Y1_E1END[1] _0669_ Tile_X0Y1_DSP_bot.Inst_DSP_bot_switch_matrix.Q5 Tile_X0Y1_DSP_bot.Inst_DSP_bot_ConfigMem.Inst_frame11_bit20.Q
+ _2393_ VPWR VGND sg13g2_mux4_1
XFILLER_95_286 VPWR VGND sg13g2_fill_2
X_4975_ Tile_X0Y0_DSP_top.Inst_DSP_top_ConfigMem.Inst_frame2_bit2.Q VPWR _0712_ VGND
+ Tile_X0Y0_DSP_top.Inst_DSP_top_ConfigMem.Inst_frame2_bit1.Q _0709_ sg13g2_o21ai_1
X_3024_ VGND VPWR _1396_ _1398_ _1401_ _1399_ sg13g2_a21oi_1
X_3788_ _2116_ VPWR _2117_ VGND Tile_X0Y0_DSP_top.Inst_DSP_top_ConfigMem.Inst_frame3_bit28.Q
+ _0190_ sg13g2_o21ai_1
X_3857_ _2178_ Tile_X0Y0_DSP_top.Inst_DSP_top_ConfigMem.Inst_frame1_bit3.Q _2171_
+ VPWR VGND sg13g2_nand2_1
X_3926_ Tile_X0Y0_DSP_top.Inst_DSP_top_ConfigMem.Inst_frame11_bit15.Q Tile_X0Y0_DSP_top.Inst_DSP_top_switch_matrix.bot2top6
+ _0937_ _0980_ _0254_ Tile_X0Y0_DSP_top.Inst_DSP_top_ConfigMem.Inst_frame11_bit14.Q
+ _2223_ VPWR VGND sg13g2_mux4_1
X_2808_ VPWR _1188_ _1187_ VGND sg13g2_inv_1
X_5458_ Tile_X0Y0_FrameData[27] Tile_X0Y1_FrameStrobe[8] Tile_X0Y0_DSP_top.Inst_DSP_top_ConfigMem.Inst_frame8_bit27.Q
+ VPWR VGND sg13g2_dlhq_1
X_5389_ Tile_X0Y0_FrameData[0] Tile_X0Y1_FrameStrobe[5] Tile_X0Y0_DSP_top.Inst_DSP_top_ConfigMem.Inst_frame5_bit0.Q
+ VPWR VGND sg13g2_dlhq_1
X_5527_ Tile_X0Y0_FrameData[22] Tile_X0Y1_FrameStrobe[10] Tile_X0Y0_DSP_top.Inst_DSP_top_ConfigMem.Inst_frame10_bit22.Q
+ VPWR VGND sg13g2_dlhq_1
X_4409_ VGND VPWR Tile_X0Y1_DSP_bot.Inst_DSP_bot_switch_matrix.E2BEG2 _0170_ _0163_
+ sg13g2_or2_1
X_2739_ VPWR _1122_ _1121_ VGND sg13g2_inv_1
XFILLER_86_220 VPWR VGND sg13g2_fill_1
XFILLER_91_36 VPWR VGND sg13g2_fill_1
XFILLER_24_96 VPWR VGND sg13g2_fill_1
XFILLER_69_209 VPWR VGND sg13g2_decap_8
X_4760_ Tile_X0Y0_DSP_top.Inst_DSP_top_ConfigMem.Inst_frame4_bit11.Q VPWR _0506_ VGND
+ _0504_ _0505_ sg13g2_o21ai_1
X_3642_ VPWR VGND _1980_ Tile_X0Y0_DSP_top.Inst_DSP_top_ConfigMem.Inst_frame3_bit27.Q
+ _1977_ _1972_ _1981_ _1975_ sg13g2_a221oi_1
X_3711_ VGND VPWR Tile_X0Y0_DSP_top.Inst_DSP_top_ConfigMem.Inst_frame1_bit25.Q _2044_
+ _2045_ _0071_ sg13g2_a21oi_1
XFILLER_81_80 VPWR VGND sg13g2_fill_2
X_4691_ _0440_ Tile_X0Y1_DSP_bot.Inst_DSP_bot_ConfigMem.Inst_frame4_bit26.Q _0441_
+ VPWR VGND sg13g2_nor2b_1
X_6430_ Tile_X0Y0_DSP_top.Inst_DSP_top_switch_matrix.JS2BEG5 Tile_X0Y1_S2BEGb[5] VPWR
+ VGND sg13g2_buf_1
X_5243_ Tile_X0Y0_FrameData[18] Tile_X0Y1_FrameStrobe[1] Tile_X0Y0_DSP_top.Inst_DSP_top_ConfigMem.Inst_frame1_bit18.Q
+ VPWR VGND sg13g2_dlhq_1
X_5312_ Tile_X0Y0_FrameData[13] Tile_X0Y1_FrameStrobe[3] Tile_X0Y0_DSP_top.Inst_DSP_top_ConfigMem.Inst_frame3_bit13.Q
+ VPWR VGND sg13g2_dlhq_1
X_6292_ Tile_X0Y0_W2END[3] Tile_X0Y0_W2BEG[3] VPWR VGND sg13g2_buf_1
XFILLER_46_0 VPWR VGND sg13g2_fill_2
X_3573_ _1925_ _1807_ _1808_ VPWR VGND sg13g2_xnor2_1
X_6361_ Tile_X0Y1_E6END[10] Tile_X0Y1_E6BEG[8] VPWR VGND sg13g2_buf_1
XFILLER_102_328 VPWR VGND sg13g2_fill_1
X_5174_ VPWR _0900_ _0899_ VGND sg13g2_inv_1
XFILLER_45_18 VPWR VGND sg13g2_fill_2
X_4056_ Tile_X0Y1_DSP_bot.Inst_DSP_bot_ConfigMem.Inst_frame12_bit20.Q Tile_X0Y1_N2END[1]
+ Tile_X0Y1_N4END[0] Tile_X0Y1_W6END[0] Tile_X0Y1_DSP_bot.Inst_DSP_bot_switch_matrix.Q7
+ Tile_X0Y1_DSP_bot.Inst_DSP_bot_ConfigMem.Inst_frame12_bit21.Q Tile_X0Y0_DSP_top.N4BEG_outbuf_11.A
+ VPWR VGND sg13g2_mux4_1
X_4125_ Tile_X0Y1_DSP_bot.Inst_DSP_bot_ConfigMem.Inst_frame11_bit15.Q _2377_ _2378_
+ VPWR VGND sg13g2_nor2_1
XFILLER_51_186 VPWR VGND sg13g2_fill_1
X_3007_ _1384_ _1375_ _1383_ VPWR VGND sg13g2_nand2_1
X_4958_ Tile_X0Y1_DSP_bot.Inst_DSP_bot_ConfigMem.Inst_frame1_bit18.Q VPWR _0695_ VGND
+ Tile_X0Y1_DSP_bot.Inst_DSP_bot_ConfigMem.Inst_frame1_bit17.Q _0692_ sg13g2_o21ai_1
X_3909_ Tile_X0Y0_DSP_top.Inst_DSP_top_ConfigMem.Inst_frame12_bit30.Q Tile_X0Y0_E1END[3]
+ Tile_X0Y0_DSP_top.Inst_DSP_top_switch_matrix.bot2top3 _0294_ Tile_X0Y0_W1END[3]
+ _0111_ _2209_ VPWR VGND sg13g2_mux4_1
X_4889_ _0630_ _0629_ Tile_X0Y0_DSP_top.Inst_DSP_top_ConfigMem.Inst_frame2_bit14.Q
+ VPWR VGND sg13g2_nand2b_1
XFILLER_86_58 VPWR VGND sg13g2_fill_1
XFILLER_74_212 VPWR VGND sg13g2_fill_1
XFILLER_30_359 VPWR VGND sg13g2_fill_2
XFILLER_51_94 VPWR VGND sg13g2_fill_2
XFILLER_97_359 VPWR VGND sg13g2_fill_2
X_4812_ VGND VPWR Tile_X0Y0_DSP_top.Inst_DSP_top_ConfigMem.Inst_frame1_bit12.Q _0133_
+ _0555_ Tile_X0Y0_DSP_top.Inst_DSP_top_ConfigMem.Inst_frame1_bit13.Q sg13g2_a21oi_1
X_5792_ Tile_X0Y1_FrameData[27] Tile_X0Y1_FrameStrobe[4] Tile_X0Y1_DSP_bot.Inst_DSP_bot_ConfigMem.Inst_frame4_bit27.Q
+ VPWR VGND sg13g2_dlhq_1
X_5930_ Tile_X0Y1_FrameData[17] Tile_X0Y1_FrameStrobe[8] Tile_X0Y1_DSP_bot.Inst_DSP_bot_ConfigMem.Inst_frame8_bit17.Q
+ VPWR VGND sg13g2_dlhq_1
X_5861_ Tile_X0Y1_FrameData[22] Tile_X0Y1_FrameStrobe[6] Tile_X0Y1_DSP_bot.Inst_DSP_bot_ConfigMem.Inst_frame6_bit22.Q
+ VPWR VGND sg13g2_dlhq_1
X_4743_ VPWR _0490_ _0489_ VGND sg13g2_inv_1
X_3625_ _1457_ _1963_ _1450_ _1964_ VPWR VGND sg13g2_nand3_1
X_4674_ Tile_X0Y1_W1END[2] Tile_X0Y1_DSP_bot.Inst_DSP_bot_ConfigMem.Inst_frame4_bit20.Q
+ _0425_ VPWR VGND sg13g2_nor2b_1
X_6413_ Tile_X0Y1_DSP_bot.Inst_DSP_bot_switch_matrix.S1BEG0 Tile_X0Y1_S1BEG[0] VPWR
+ VGND sg13g2_buf_1
XFILLER_21_359 VPWR VGND sg13g2_fill_2
X_5226_ Tile_X0Y0_FrameData[3] Tile_X0Y1_FrameStrobe[0] Tile_X0Y0_DSP_top.Inst_DSP_top_ConfigMem.Inst_frame0_bit3.Q
+ VPWR VGND sg13g2_dlhq_1
X_6275_ Tile_X0Y1_NN4END[15] Tile_X0Y0_NN4BEG[7] VPWR VGND sg13g2_buf_1
X_6344_ Tile_X0Y1_DSP_bot.Inst_DSP_bot_switch_matrix.E2BEG7 Tile_X0Y1_E2BEG[7] VPWR
+ VGND sg13g2_buf_1
X_3487_ _1843_ Tile_X0Y1_DSP_bot.Inst_DSP_bot_ConfigMem.Inst_frame8_bit12.Q _1842_
+ VPWR VGND sg13g2_nand2_1
X_3556_ Tile_X0Y1_DSP_bot.Inst_DSP_bot_ConfigMem.Inst_frame8_bit7.Q _1908_ _1909_
+ VPWR VGND sg13g2_nor2_1
X_5088_ Tile_X0Y0_DSP_top.Inst_DSP_top_ConfigMem.Inst_frame2_bit8.Q Tile_X0Y0_DSP_top.Inst_DSP_top_switch_matrix.bot2top0
+ Tile_X0Y0_DSP_top.Inst_DSP_top_switch_matrix.bot2top1 Tile_X0Y0_DSP_top.Inst_DSP_top_switch_matrix.bot2top3
+ Tile_X0Y0_DSP_top.Inst_DSP_top_switch_matrix.bot2top4 Tile_X0Y0_DSP_top.Inst_DSP_top_ConfigMem.Inst_frame2_bit9.Q
+ _0819_ VPWR VGND sg13g2_mux4_1
X_4039_ VGND VPWR Tile_X0Y0_DSP_top.Inst_DSP_top_ConfigMem.Inst_frame9_bit22.Q _0861_
+ _2321_ Tile_X0Y0_DSP_top.Inst_DSP_top_ConfigMem.Inst_frame9_bit23.Q sg13g2_a21oi_1
X_5157_ Tile_X0Y1_DSP_bot.Inst_DSP_bot_ConfigMem.Inst_frame2_bit4.Q Tile_X0Y0_S4END[6]
+ _0885_ VPWR VGND sg13g2_nor2b_1
X_4108_ Tile_X0Y1_DSP_bot.Inst_DSP_bot_ConfigMem.Inst_frame9_bit0.Q Tile_X0Y1_DSP_bot.Inst_DSP_bot_switch_matrix.Q0
+ _0288_ Tile_X0Y1_DSP_bot.Inst_DSP_bot_switch_matrix.JS2BEG2 _0274_ Tile_X0Y1_DSP_bot.Inst_DSP_bot_ConfigMem.Inst_frame9_bit1.Q
+ Tile_X0Y1_DSP_bot.Inst_DSP_bot_switch_matrix.W1BEG3 VPWR VGND sg13g2_mux4_1
XFILLER_16_109 VPWR VGND sg13g2_fill_1
XANTENNA_71 VPWR VGND Tile_X0Y0_FrameData[6] sg13g2_antennanp
XANTENNA_60 VPWR VGND Tile_X0Y0_FrameData[6] sg13g2_antennanp
XANTENNA_93 VPWR VGND Tile_X0Y0_S2MID[4] sg13g2_antennanp
XANTENNA_82 VPWR VGND Tile_X0Y1_EE4END[13] sg13g2_antennanp
XFILLER_47_267 VPWR VGND sg13g2_fill_1
XFILLER_97_112 VPWR VGND sg13g2_fill_2
X_3341_ Tile_X0Y1_DSP_bot.Inst_DSP_bot_ConfigMem.Inst_frame3_bit25.Q VPWR _1705_ VGND
+ Tile_X0Y1_DSP_bot.Inst_DSP_bot_ConfigMem.Inst_frame3_bit24.Q Tile_X0Y1_DSP_bot.Inst_DSP_bot_switch_matrix.Q7
+ sg13g2_o21ai_1
X_3272_ _1639_ Tile_X0Y1_DSP_bot.Inst_DSP_bot_ConfigMem.Inst_frame1_bit28.Q Tile_X0Y1_DSP_bot.Inst_DSP_bot_switch_matrix.Q3
+ VPWR VGND sg13g2_nand2_1
X_4390_ VPWR _0152_ _0151_ VGND sg13g2_inv_1
X_6060_ Tile_X0Y1_FrameData[15] Tile_X0Y1_FrameStrobe[12] Tile_X0Y1_DSP_bot.Inst_DSP_bot_ConfigMem.Inst_frame12_bit15.Q
+ VPWR VGND sg13g2_dlhq_1
X_3410_ VGND VPWR _0103_ _0150_ _1770_ _1769_ sg13g2_a21oi_1
XFILLER_93_351 VPWR VGND sg13g2_fill_2
XFILLER_53_226 VPWR VGND sg13g2_fill_2
X_5011_ Tile_X0Y1_DSP_bot.Inst_DSP_bot_ConfigMem.Inst_frame7_bit7.Q VPWR _0746_ VGND
+ Tile_X0Y1_DSP_bot.Inst_DSP_bot_ConfigMem.Inst_frame7_bit6.Q Tile_X0Y0_DSP_top.Inst_DSP_top_switch_matrix.JS2BEG0
+ sg13g2_o21ai_1
X_2987_ _1364_ _1351_ _1363_ VPWR VGND sg13g2_nand2_1
X_5775_ Tile_X0Y1_FrameData[12] Tile_X0Y1_FrameStrobe[3] Tile_X0Y1_DSP_bot.Inst_DSP_bot_ConfigMem.Inst_frame3_bit12.Q
+ VPWR VGND sg13g2_dlhq_1
X_5913_ Tile_X0Y1_FrameData[2] Tile_X0Y1_FrameStrobe[7] Tile_X0Y1_DSP_bot.Inst_DSP_bot_ConfigMem.Inst_frame7_bit2.Q
+ VPWR VGND sg13g2_dlhq_1
X_5844_ Tile_X0Y1_FrameData[7] Tile_X0Y1_FrameStrobe[5] Tile_X0Y1_DSP_bot.Inst_DSP_bot_ConfigMem.Inst_frame5_bit7.Q
+ VPWR VGND sg13g2_dlhq_1
X_4588_ Tile_X0Y0_DSP_top.Inst_DSP_top_ConfigMem.Inst_frame4_bit4.Q Tile_X0Y0_DSP_top.Inst_DSP_top_switch_matrix.bot2top5
+ _0342_ VPWR VGND sg13g2_nor2b_1
X_4657_ _0409_ _0408_ Tile_X0Y0_DSP_top.Inst_DSP_top_ConfigMem.Inst_frame3_bit6.Q
+ VPWR VGND sg13g2_nand2b_1
X_6327_ Tile_X0Y0_WW4END[14] Tile_X0Y0_WW4BEG[10] VPWR VGND sg13g2_buf_1
X_4726_ Tile_X0Y1_DSP_bot.Inst_DSP_bot_ConfigMem.Inst_frame4_bit28.Q Tile_X0Y1_N1END[0]
+ Tile_X0Y1_N2END[0] Tile_X0Y1_E1END[0] Tile_X0Y1_EE4END[0] Tile_X0Y1_DSP_bot.Inst_DSP_bot_ConfigMem.Inst_frame4_bit29.Q
+ _0474_ VPWR VGND sg13g2_mux4_1
X_3608_ _1953_ VPWR Tile_X0Y1_DSP_bot.Inst_DSP_bot_switch_matrix.Q6 VGND Tile_X0Y1_DSP_bot.Inst_DSP_bot_ConfigMem.Inst_frame12_bit5.Q
+ _1952_ sg13g2_o21ai_1
X_6258_ Tile_X0Y1_N4END[14] Tile_X0Y0_N4BEG[6] VPWR VGND sg13g2_buf_1
XFILLER_107_45 VPWR VGND sg13g2_fill_1
X_6189_ Tile_X0Y0_FrameData[9] Tile_X0Y0_FrameData_O[9] VPWR VGND sg13g2_buf_1
XFILLER_88_156 VPWR VGND sg13g2_fill_2
X_5209_ Tile_X0Y0_FrameData[20] Tile_X0Y1_FrameStrobe[0] Tile_X0Y0_DSP_top.Inst_DSP_top_ConfigMem.Inst_frame0_bit20.Q
+ VPWR VGND sg13g2_dlhq_1
X_3539_ _1892_ _1890_ _1891_ _0105_ Tile_X0Y1_DSP_bot.Inst_DSP_bot_ConfigMem.Inst_frame12_bit3.Q
+ VPWR VGND sg13g2_a22oi_1
XFILLER_44_204 VPWR VGND sg13g2_fill_1
XFILLER_8_105 VPWR VGND sg13g2_fill_2
XFILLER_79_101 VPWR VGND sg13g2_fill_2
XFILLER_90_354 VPWR VGND sg13g2_fill_1
X_3890_ Tile_X0Y0_DSP_top.Inst_DSP_top_ConfigMem.Inst_frame11_bit11.Q Tile_X0Y0_DSP_top.Inst_DSP_top_switch_matrix.bot2top5
+ Tile_X0Y0_DSP_top.Inst_DSP_top_switch_matrix.JN2BEG1 _0387_ _0407_ Tile_X0Y0_DSP_top.Inst_DSP_top_ConfigMem.Inst_frame11_bit10.Q
+ Tile_X0Y0_DSP_top.Inst_DSP_top_switch_matrix.E1BEG2 VPWR VGND sg13g2_mux4_1
X_2841_ _1221_ _0786_ _0533_ VPWR VGND sg13g2_nand2b_1
X_2910_ VGND VPWR Tile_X0Y0_SS4END[7] Tile_X0Y1_DSP_bot.Inst_DSP_bot_ConfigMem.Inst_frame0_bit8.Q
+ _1288_ _1287_ sg13g2_a21oi_1
X_5560_ Tile_X0Y0_FrameData[21] Tile_X0Y1_FrameStrobe[11] Tile_X0Y0_DSP_top.Inst_DSP_top_ConfigMem.Inst_frame11_bit21.Q
+ VPWR VGND sg13g2_dlhq_1
X_4442_ Tile_X0Y0_DSP_top.Inst_DSP_top_ConfigMem.Inst_frame2_bit29.Q VPWR _0203_ VGND
+ Tile_X0Y0_DSP_top.Inst_DSP_top_ConfigMem.Inst_frame2_bit28.Q Tile_X0Y0_DSP_top.Inst_DSP_top_switch_matrix.bot2top6
+ sg13g2_o21ai_1
X_2772_ _1152_ _1151_ _1154_ VPWR VGND sg13g2_xor2_1
X_5491_ Tile_X0Y0_FrameData[26] Tile_X0Y1_FrameStrobe[9] Tile_X0Y0_DSP_top.Inst_DSP_top_ConfigMem.Inst_frame9_bit26.Q
+ VPWR VGND sg13g2_dlhq_1
X_4511_ _0268_ Tile_X0Y1_DSP_bot.Inst_DSP_bot_ConfigMem.Inst_frame4_bit7.Q _0269_
+ VPWR VGND sg13g2_nor2b_1
X_4373_ VPWR _0136_ _0135_ VGND sg13g2_inv_1
XFILLER_85_159 VPWR VGND sg13g2_fill_2
X_6112_ VPWR VGND _2510_ sg13g2_tiehi
X_3255_ VGND VPWR Tile_X0Y1_DSP_bot.Inst_DSP_bot_ConfigMem.Inst_frame1_bit20.Q _0130_
+ _1623_ _1622_ sg13g2_a21oi_1
X_3324_ VGND VPWR Tile_X0Y1_DSP_bot.Inst_DSP_bot_ConfigMem.Inst_frame12_bit2.Q _0096_
+ _1688_ Tile_X0Y1_DSP_bot.Inst_DSP_bot_ConfigMem.Inst_frame12_bit3.Q sg13g2_a21oi_1
XFILLER_37_19 VPWR VGND sg13g2_fill_1
X_6043_ Tile_X0Y1_FrameData[0] Tile_X0Y1_FrameStrobe[11] Tile_X0Y1_DSP_bot.Inst_DSP_bot_ConfigMem.Inst_frame11_bit0.Q
+ VPWR VGND sg13g2_dlhq_1
X_3186_ _1558_ _1555_ _1557_ VPWR VGND sg13g2_nand2_1
X_4709_ _0457_ VPWR _0458_ VGND Tile_X0Y0_DSP_top.Inst_DSP_top_ConfigMem.Inst_frame3_bit13.Q
+ _0456_ sg13g2_o21ai_1
X_5827_ Tile_X0Y1_FrameData[24] Tile_X0Y1_FrameStrobe[5] Tile_X0Y1_DSP_bot.Inst_DSP_bot_ConfigMem.Inst_frame5_bit24.Q
+ VPWR VGND sg13g2_dlhq_1
X_5758_ Tile_X0Y1_FrameData[29] Tile_X0Y1_FrameStrobe[3] Tile_X0Y1_DSP_bot.Inst_DSP_bot_ConfigMem.Inst_frame3_bit29.Q
+ VPWR VGND sg13g2_dlhq_1
X_5689_ Tile_X0Y1_FrameData[2] Tile_X0Y1_FrameStrobe[0] Tile_X0Y1_DSP_bot.Inst_DSP_bot_ConfigMem.Inst_frame0_bit2.Q
+ VPWR VGND sg13g2_dlhq_1
XFILLER_94_36 VPWR VGND sg13g2_fill_1
Xclkbuf_0_Tile_X0Y1_UserCLK_regs Tile_X0Y1_UserCLK_regs clknet_0_Tile_X0Y1_UserCLK_regs
+ VPWR VGND sg13g2_buf_8
XFILLER_72_332 VPWR VGND sg13g2_fill_2
XFILLER_43_51 VPWR VGND sg13g2_fill_1
XFILLER_99_207 VPWR VGND sg13g2_fill_1
XFILLER_67_104 VPWR VGND sg13g2_fill_2
X_3040_ _1188_ _1308_ _1417_ VPWR VGND sg13g2_nor2_1
X_4991_ VGND VPWR Tile_X0Y1_DSP_bot.Inst_DSP_bot_ConfigMem.Inst_frame8_bit4.Q _0152_
+ _0727_ Tile_X0Y1_DSP_bot.Inst_DSP_bot_ConfigMem.Inst_frame8_bit5.Q sg13g2_a21oi_1
X_3873_ Tile_X0Y0_DSP_top.Inst_DSP_top_ConfigMem.Inst_frame4_bit2.Q VPWR _2186_ VGND
+ Tile_X0Y0_DSP_top.Inst_DSP_top_ConfigMem.Inst_frame4_bit1.Q _2183_ sg13g2_o21ai_1
X_3942_ VGND VPWR Tile_X0Y0_DSP_top.Inst_DSP_top_ConfigMem.Inst_frame11_bit21.Q _2236_
+ _2237_ Tile_X0Y0_DSP_top.Inst_DSP_top_ConfigMem.Inst_frame11_bit22.Q sg13g2_a21oi_1
XFILLER_76_0 VPWR VGND sg13g2_fill_1
X_5543_ Tile_X0Y0_FrameData[6] Tile_X0Y1_FrameStrobe[10] Tile_X0Y0_DSP_top.Inst_DSP_top_ConfigMem.Inst_frame10_bit6.Q
+ VPWR VGND sg13g2_dlhq_1
X_2824_ _1204_ _1195_ _1203_ VPWR VGND sg13g2_nand2_1
X_5612_ _2483_ VGND VPWR _0008_ Tile_X0Y1_DSP_bot.Inst_MULADD.ACC\[8\] clknet_3_0_0_Tile_X0Y1_UserCLK_regs
+ sg13g2_dfrbpq_1
XFILLER_16_270 VPWR VGND sg13g2_fill_1
X_5474_ Tile_X0Y0_FrameData[11] Tile_X0Y1_FrameStrobe[8] Tile_X0Y0_DSP_top.Inst_DSP_top_ConfigMem.Inst_frame8_bit11.Q
+ VPWR VGND sg13g2_dlhq_1
X_4356_ VPWR _0119_ Tile_X0Y1_DSP_bot.Inst_MULADD.C_reg\[19\] VGND sg13g2_inv_1
X_2755_ _1136_ _1135_ _1137_ VPWR VGND sg13g2_nor2b_1
X_2686_ _1070_ VPWR _1072_ VGND Tile_X0Y1_DSP_bot.Inst_DSP_bot_ConfigMem.Inst_frame7_bit3.Q
+ _1071_ sg13g2_o21ai_1
X_4425_ VPWR _0186_ _0185_ VGND sg13g2_inv_1
X_3169_ Tile_X0Y0_DSP_top.Inst_DSP_top_ConfigMem.Inst_frame5_bit18.Q Tile_X0Y1_N2MID[3]
+ Tile_X0Y0_E2END[3] Tile_X0Y0_S2END[3] Tile_X0Y0_WW4END[1] Tile_X0Y0_DSP_top.Inst_DSP_top_ConfigMem.Inst_frame5_bit19.Q
+ _1542_ VPWR VGND sg13g2_mux4_1
XFILLER_98_251 VPWR VGND sg13g2_decap_4
XFILLER_64_17 VPWR VGND sg13g2_fill_1
X_4287_ VPWR _0050_ Tile_X0Y1_DSP_bot.Inst_DSP_bot_ConfigMem.Inst_frame4_bit23.Q VGND
+ sg13g2_inv_1
X_3307_ _1673_ Tile_X0Y1_DSP_bot.Inst_DSP_bot_ConfigMem.Inst_frame2_bit20.Q _0126_
+ VPWR VGND sg13g2_nand2_1
X_6026_ Tile_X0Y1_FrameData[17] Tile_X0Y1_FrameStrobe[11] Tile_X0Y1_DSP_bot.Inst_DSP_bot_ConfigMem.Inst_frame11_bit17.Q
+ VPWR VGND sg13g2_dlhq_1
X_3238_ Tile_X0Y1_DSP_bot.Inst_DSP_bot_ConfigMem.Inst_frame3_bit30.Q _1606_ _1607_
+ VPWR VGND sg13g2_nor2_1
XFILLER_108_323 VPWR VGND sg13g2_decap_8
XFILLER_38_84 VPWR VGND sg13g2_fill_1
XFILLER_54_94 VPWR VGND sg13g2_fill_1
XFILLER_13_284 VPWR VGND sg13g2_fill_2
XFILLER_70_82 VPWR VGND sg13g2_fill_1
X_4210_ _2449_ VPWR Tile_X0Y1_DSP_bot.Inst_DSP_bot_switch_matrix.W6BEG0 VGND Tile_X0Y1_DSP_bot.Inst_DSP_bot_ConfigMem.Inst_frame9_bit17.Q
+ _2445_ sg13g2_o21ai_1
X_2540_ Tile_X0Y1_DSP_bot.Inst_DSP_bot_ConfigMem.Inst_frame4_bit8.Q Tile_X0Y1_N2END[3]
+ Tile_X0Y1_N4END[3] Tile_X0Y1_E1END[1] Tile_X0Y1_E2END[3] Tile_X0Y1_DSP_bot.Inst_DSP_bot_ConfigMem.Inst_frame4_bit9.Q
+ _0933_ VPWR VGND sg13g2_mux4_1
X_5190_ VGND VPWR Tile_X0Y0_S1END[3] Tile_X0Y0_DSP_top.Inst_DSP_top_ConfigMem.Inst_frame3_bit16.Q
+ _0916_ Tile_X0Y0_DSP_top.Inst_DSP_top_ConfigMem.Inst_frame3_bit17.Q sg13g2_a21oi_1
XFILLER_95_243 VPWR VGND sg13g2_decap_4
X_3023_ _1400_ _1398_ _1399_ VPWR VGND sg13g2_xnor2_1
X_4072_ VGND VPWR Tile_X0Y0_S2MID[1] Tile_X0Y1_DSP_bot.Inst_DSP_bot_ConfigMem.Inst_frame3_bit0.Q
+ _2343_ _2342_ sg13g2_a21oi_1
X_4141_ VGND VPWR Tile_X0Y1_DSP_bot.Inst_DSP_bot_ConfigMem.Inst_frame11_bit20.Q _2388_
+ _2392_ _2391_ sg13g2_a21oi_1
X_3925_ _2221_ _2222_ Tile_X0Y0_DSP_top.Inst_DSP_top_ConfigMem.Inst_frame11_bit5.Q
+ Tile_X0Y0_DSP_top.Inst_DSP_top_switch_matrix.NN4BEG3 VPWR VGND sg13g2_mux2_1
X_4974_ _0710_ VPWR _0711_ VGND Tile_X0Y0_DSP_top.Inst_DSP_top_ConfigMem.Inst_frame2_bit0.Q
+ _0129_ sg13g2_o21ai_1
XFILLER_109_109 VPWR VGND sg13g2_fill_1
X_3856_ VGND VPWR Tile_X0Y0_DSP_top.Inst_DSP_top_ConfigMem.Inst_frame1_bit1.Q _2173_
+ _2177_ _2176_ sg13g2_a21oi_1
X_3787_ VGND VPWR Tile_X0Y1_N2MID[0] Tile_X0Y0_DSP_top.Inst_DSP_top_ConfigMem.Inst_frame3_bit28.Q
+ _2116_ Tile_X0Y0_DSP_top.Inst_DSP_top_ConfigMem.Inst_frame3_bit29.Q sg13g2_a21oi_1
X_5526_ Tile_X0Y0_FrameData[23] Tile_X0Y1_FrameStrobe[10] Tile_X0Y0_DSP_top.Inst_DSP_top_ConfigMem.Inst_frame10_bit23.Q
+ VPWR VGND sg13g2_dlhq_1
X_2807_ Tile_X0Y1_DSP_bot.Inst_MULADD.A_reg\[0\] Tile_X0Y1_DSP_bot.A0 _0073_ _1187_
+ VPWR VGND sg13g2_mux2_1
X_2738_ Tile_X0Y1_DSP_bot.Inst_DSP_bot_ConfigMem.Inst_frame7_bit12.Q _0020_ _0075_
+ _0859_ _1120_ Tile_X0Y1_DSP_bot.Inst_DSP_bot_ConfigMem.Inst_frame7_bit13.Q _1121_
+ VPWR VGND sg13g2_mux4_1
XFILLER_105_359 VPWR VGND sg13g2_fill_2
XFILLER_105_337 VPWR VGND sg13g2_fill_1
X_5457_ Tile_X0Y0_FrameData[28] Tile_X0Y1_FrameStrobe[8] Tile_X0Y0_DSP_top.Inst_DSP_top_ConfigMem.Inst_frame8_bit28.Q
+ VPWR VGND sg13g2_dlhq_1
X_5388_ Tile_X0Y0_FrameData[1] Tile_X0Y1_FrameStrobe[5] Tile_X0Y0_DSP_top.Inst_DSP_top_ConfigMem.Inst_frame5_bit1.Q
+ VPWR VGND sg13g2_dlhq_1
X_2669_ Tile_X0Y1_DSP_bot.Inst_DSP_bot_ConfigMem.Inst_frame3_bit4.Q Tile_X0Y1_N1END[0]
+ Tile_X0Y1_N2END[2] Tile_X0Y1_N4END[2] Tile_X0Y1_E2END[2] Tile_X0Y1_DSP_bot.Inst_DSP_bot_ConfigMem.Inst_frame3_bit5.Q
+ _1056_ VPWR VGND sg13g2_mux4_1
X_4408_ VGND VPWR _0166_ _0167_ _0170_ _0169_ sg13g2_a21oi_1
X_4339_ VPWR _0102_ Tile_X0Y1_DSP_bot.Inst_DSP_bot_ConfigMem.Inst_frame7_bit31.Q VGND
+ sg13g2_inv_1
X_6009_ Tile_X0Y1_FrameData[2] Tile_X0Y1_FrameStrobe[10] Tile_X0Y1_DSP_bot.Inst_DSP_bot_ConfigMem.Inst_frame10_bit2.Q
+ VPWR VGND sg13g2_dlhq_1
XFILLER_108_197 VPWR VGND sg13g2_fill_1
XFILLER_40_41 VPWR VGND sg13g2_fill_2
XFILLER_6_0 VPWR VGND sg13g2_fill_1
XFILLER_33_335 VPWR VGND sg13g2_fill_1
XANTENNA_150 VPWR VGND Tile_X0Y0_S4END[6] sg13g2_antennanp
X_3641_ VGND VPWR Tile_X0Y0_DSP_top.Inst_DSP_top_ConfigMem.Inst_frame3_bit25.Q _1979_
+ _1980_ _0067_ sg13g2_a21oi_1
X_3710_ _2043_ VPWR _2044_ VGND Tile_X0Y0_S2END[7] Tile_X0Y0_DSP_top.Inst_DSP_top_ConfigMem.Inst_frame1_bit24.Q
+ sg13g2_o21ai_1
X_4690_ VGND VPWR Tile_X0Y1_DSP_bot.Inst_DSP_bot_ConfigMem.Inst_frame4_bit24.Q _0055_
+ _0440_ _0439_ sg13g2_a21oi_1
X_3572_ _1808_ _1807_ _1924_ VPWR VGND sg13g2_nor2b_1
X_6360_ Tile_X0Y1_E6END[9] Tile_X0Y1_E6BEG[7] VPWR VGND sg13g2_buf_1
X_5242_ Tile_X0Y0_FrameData[19] Tile_X0Y1_FrameStrobe[1] Tile_X0Y0_DSP_top.Inst_DSP_top_ConfigMem.Inst_frame1_bit19.Q
+ VPWR VGND sg13g2_dlhq_1
X_5311_ Tile_X0Y0_FrameData[14] Tile_X0Y1_FrameStrobe[3] Tile_X0Y0_DSP_top.Inst_DSP_top_ConfigMem.Inst_frame3_bit14.Q
+ VPWR VGND sg13g2_dlhq_1
X_6291_ Tile_X0Y0_DSP_top.Inst_DSP_top_switch_matrix.JW2BEG2 Tile_X0Y0_W2BEG[2] VPWR
+ VGND sg13g2_buf_1
X_5173_ _0898_ VPWR _0899_ VGND Tile_X0Y1_DSP_bot.Inst_DSP_bot_ConfigMem.Inst_frame12_bit0.Q
+ _0897_ sg13g2_o21ai_1
X_3006_ _1381_ _1376_ _1383_ VPWR VGND sg13g2_xor2_1
X_4055_ Tile_X0Y1_DSP_bot.Inst_DSP_bot_ConfigMem.Inst_frame12_bit18.Q Tile_X0Y1_N2END[0]
+ Tile_X0Y1_N4END[3] Tile_X0Y1_W6END[1] Tile_X0Y1_DSP_bot.Inst_DSP_bot_switch_matrix.Q6
+ Tile_X0Y1_DSP_bot.Inst_DSP_bot_ConfigMem.Inst_frame12_bit19.Q Tile_X0Y0_DSP_top.N4BEG_outbuf_10.A
+ VPWR VGND sg13g2_mux4_1
X_4124_ Tile_X0Y1_DSP_bot.Inst_DSP_bot_ConfigMem.Inst_frame11_bit13.Q Tile_X0Y1_N1END[3]
+ Tile_X0Y1_E1END[3] _0435_ Tile_X0Y1_DSP_bot.Inst_DSP_bot_switch_matrix.Q3 Tile_X0Y1_DSP_bot.Inst_DSP_bot_ConfigMem.Inst_frame11_bit14.Q
+ _2377_ VPWR VGND sg13g2_mux4_1
X_3908_ _2207_ _2204_ _2208_ VPWR VGND sg13g2_nor2b_1
X_4888_ Tile_X0Y0_DSP_top.Inst_DSP_top_ConfigMem.Inst_frame2_bit13.Q Tile_X0Y1_N2MID[4]
+ Tile_X0Y0_E2END[4] Tile_X0Y0_E1END[2] Tile_X0Y0_E6END[0] Tile_X0Y0_DSP_top.Inst_DSP_top_ConfigMem.Inst_frame2_bit12.Q
+ _0629_ VPWR VGND sg13g2_mux4_1
X_4957_ VGND VPWR Tile_X0Y1_DSP_bot.Inst_DSP_bot_ConfigMem.Inst_frame1_bit16.Q _0131_
+ _0694_ _0693_ sg13g2_a21oi_1
X_3839_ VGND VPWR Tile_X0Y0_DSP_top.Inst_DSP_top_ConfigMem.Inst_frame1_bit0.Q _0043_
+ _2160_ Tile_X0Y0_DSP_top.Inst_DSP_top_ConfigMem.Inst_frame1_bit1.Q sg13g2_a21oi_1
X_5509_ Tile_X0Y0_FrameData[8] Tile_X0Y1_FrameStrobe[9] Tile_X0Y0_DSP_top.Inst_DSP_top_ConfigMem.Inst_frame9_bit8.Q
+ VPWR VGND sg13g2_dlhq_1
X_6489_ Tile_X0Y1_W6END[6] Tile_X0Y1_W6BEG[4] VPWR VGND sg13g2_buf_1
XFILLER_105_178 VPWR VGND sg13g2_fill_1
XFILLER_19_75 VPWR VGND sg13g2_fill_1
XFILLER_30_305 VPWR VGND sg13g2_fill_1
X_4742_ Tile_X0Y0_DSP_top.Inst_DSP_top_ConfigMem.Inst_frame6_bit25.Q Tile_X0Y0_DSP_top.Inst_DSP_top_switch_matrix.N2BEGb7
+ Tile_X0Y0_S2MID[7] Tile_X0Y0_E2MID[7] Tile_X0Y0_W2MID[7] Tile_X0Y0_DSP_top.Inst_DSP_top_ConfigMem.Inst_frame6_bit24.Q
+ _0489_ VPWR VGND sg13g2_mux4_1
X_4811_ VGND VPWR _0554_ Tile_X0Y0_DSP_top.Inst_DSP_top_switch_matrix.bot2top0 Tile_X0Y0_DSP_top.Inst_DSP_top_ConfigMem.Inst_frame1_bit12.Q
+ sg13g2_or2_1
X_5791_ Tile_X0Y1_FrameData[28] Tile_X0Y1_FrameStrobe[4] Tile_X0Y1_DSP_bot.Inst_DSP_bot_ConfigMem.Inst_frame4_bit28.Q
+ VPWR VGND sg13g2_dlhq_1
X_5860_ Tile_X0Y1_FrameData[23] Tile_X0Y1_FrameStrobe[6] Tile_X0Y1_DSP_bot.Inst_DSP_bot_ConfigMem.Inst_frame6_bit23.Q
+ VPWR VGND sg13g2_dlhq_1
X_3624_ _1963_ _1451_ _1453_ _1438_ _1145_ VPWR VGND sg13g2_a22oi_1
X_6412_ Tile_X0Y1_FrameData[31] Tile_X0Y1_FrameData_O[31] VPWR VGND sg13g2_buf_1
X_4673_ _0423_ VPWR _0424_ VGND Tile_X0Y1_DSP_bot.Inst_DSP_bot_ConfigMem.Inst_frame4_bit20.Q
+ _0422_ sg13g2_o21ai_1
X_6343_ Tile_X0Y1_DSP_bot.Inst_DSP_bot_switch_matrix.E2BEG6 Tile_X0Y1_E2BEG[6] VPWR
+ VGND sg13g2_buf_1
X_3555_ _0107_ _0209_ _1908_ VPWR VGND sg13g2_nor2_1
X_5225_ Tile_X0Y0_FrameData[4] Tile_X0Y1_FrameStrobe[0] Tile_X0Y0_DSP_top.Inst_DSP_top_ConfigMem.Inst_frame0_bit4.Q
+ VPWR VGND sg13g2_dlhq_1
XFILLER_56_29 VPWR VGND sg13g2_fill_1
X_5156_ Tile_X0Y1_DSP_bot.Inst_DSP_bot_ConfigMem.Inst_frame2_bit5.Q Tile_X0Y1_NN4END[2]
+ Tile_X0Y1_EE4END[2] Tile_X0Y1_E1END[0] Tile_X0Y1_E6END[0] Tile_X0Y1_DSP_bot.Inst_DSP_bot_ConfigMem.Inst_frame2_bit4.Q
+ _0884_ VPWR VGND sg13g2_mux4_1
X_6274_ Tile_X0Y1_NN4END[14] Tile_X0Y0_NN4BEG[6] VPWR VGND sg13g2_buf_1
XFILLER_0_209 VPWR VGND sg13g2_fill_1
X_3486_ _1841_ VPWR _1842_ VGND Tile_X0Y1_EE4END[3] Tile_X0Y1_DSP_bot.Inst_DSP_bot_ConfigMem.Inst_frame0_bit22.Q
+ sg13g2_o21ai_1
XFILLER_110_181 VPWR VGND sg13g2_fill_2
X_4038_ Tile_X0Y0_DSP_top.Inst_DSP_top_ConfigMem.Inst_frame9_bit20.Q _2313_ _2314_
+ _2320_ _2319_ Tile_X0Y0_DSP_top.Inst_DSP_top_ConfigMem.Inst_frame9_bit21.Q Tile_X0Y0_DSP_top.Inst_DSP_top_switch_matrix.W6BEG0
+ VPWR VGND sg13g2_mux4_1
X_5087_ _0818_ _0786_ _0817_ VPWR VGND sg13g2_nand2_1
X_4107_ Tile_X0Y1_DSP_bot.Inst_DSP_bot_ConfigMem.Inst_frame10_bit31.Q Tile_X0Y1_DSP_bot.Inst_DSP_bot_switch_matrix.Q7
+ Tile_X0Y1_DSP_bot.Inst_DSP_bot_switch_matrix.JS2BEG1 _1793_ _1761_ Tile_X0Y1_DSP_bot.Inst_DSP_bot_ConfigMem.Inst_frame10_bit30.Q
+ Tile_X0Y1_DSP_bot.Inst_DSP_bot_switch_matrix.W1BEG2 VPWR VGND sg13g2_mux4_1
XANTENNA_83 VPWR VGND Tile_X0Y1_FrameStrobe[15] sg13g2_antennanp
XANTENNA_61 VPWR VGND Tile_X0Y0_FrameData[6] sg13g2_antennanp
XANTENNA_50 VPWR VGND Tile_X0Y1_NN4END[7] sg13g2_antennanp
XANTENNA_72 VPWR VGND Tile_X0Y0_FrameData[6] sg13g2_antennanp
X_5989_ Tile_X0Y1_FrameData[22] Tile_X0Y1_FrameStrobe[10] Tile_X0Y1_DSP_bot.Inst_DSP_bot_ConfigMem.Inst_frame10_bit22.Q
+ VPWR VGND sg13g2_dlhq_1
XFILLER_20_360 VPWR VGND sg13g2_fill_1
XANTENNA_94 VPWR VGND Tile_X0Y0_S2MID[4] sg13g2_antennanp
X_5010_ _0682_ _0741_ _0609_ _0745_ VPWR VGND sg13g2_nand3_1
X_3340_ _1703_ VPWR _1704_ VGND Tile_X0Y1_DSP_bot.Inst_DSP_bot_ConfigMem.Inst_frame3_bit24.Q
+ Tile_X0Y1_DSP_bot.Inst_DSP_bot_switch_matrix.Q4 sg13g2_o21ai_1
X_3271_ Tile_X0Y1_DSP_bot.Inst_DSP_bot_ConfigMem.Inst_frame1_bit31.Q _1637_ _1638_
+ VPWR VGND sg13g2_nor2_1
XFILLER_30_4 VPWR VGND sg13g2_fill_2
X_5912_ Tile_X0Y1_FrameData[3] Tile_X0Y1_FrameStrobe[7] Tile_X0Y1_DSP_bot.Inst_DSP_bot_ConfigMem.Inst_frame7_bit3.Q
+ VPWR VGND sg13g2_dlhq_1
XFILLER_61_282 VPWR VGND sg13g2_fill_2
X_2986_ _1363_ _1352_ _1361_ VPWR VGND sg13g2_xnor2_1
X_4725_ VPWR _0473_ _0472_ VGND sg13g2_inv_1
X_5843_ Tile_X0Y1_FrameData[8] Tile_X0Y1_FrameStrobe[5] Tile_X0Y1_DSP_bot.Inst_DSP_bot_ConfigMem.Inst_frame5_bit8.Q
+ VPWR VGND sg13g2_dlhq_1
X_5774_ Tile_X0Y1_FrameData[13] Tile_X0Y1_FrameStrobe[3] Tile_X0Y1_DSP_bot.Inst_DSP_bot_ConfigMem.Inst_frame3_bit13.Q
+ VPWR VGND sg13g2_dlhq_1
X_4587_ _0340_ VPWR _0341_ VGND Tile_X0Y0_DSP_top.Inst_DSP_top_ConfigMem.Inst_frame4_bit5.Q
+ _0339_ sg13g2_o21ai_1
X_6326_ Tile_X0Y0_WW4END[13] Tile_X0Y0_WW4BEG[9] VPWR VGND sg13g2_buf_1
X_4656_ Tile_X0Y0_DSP_top.Inst_DSP_top_ConfigMem.Inst_frame3_bit4.Q Tile_X0Y0_DSP_top.Inst_DSP_top_switch_matrix.bot2top0
+ Tile_X0Y0_DSP_top.Inst_DSP_top_switch_matrix.bot2top2 Tile_X0Y0_DSP_top.Inst_DSP_top_switch_matrix.bot2top3
+ Tile_X0Y0_DSP_top.Inst_DSP_top_switch_matrix.bot2top4 Tile_X0Y0_DSP_top.Inst_DSP_top_ConfigMem.Inst_frame3_bit5.Q
+ _0408_ VPWR VGND sg13g2_mux4_1
X_3607_ _1953_ Tile_X0Y1_DSP_bot.Inst_MULADD.ACC\[6\] Tile_X0Y1_DSP_bot.Inst_DSP_bot_ConfigMem.Inst_frame12_bit5.Q
+ VPWR VGND sg13g2_nand2_1
X_3538_ VGND VPWR Tile_X0Y1_DSP_bot.Inst_DSP_bot_ConfigMem.Inst_frame12_bit2.Q Tile_X0Y1_DSP_bot.Inst_MULADD.C_reg\[1\]
+ _1891_ Tile_X0Y1_DSP_bot.Inst_DSP_bot_ConfigMem.Inst_frame12_bit3.Q sg13g2_a21oi_1
X_6257_ Tile_X0Y1_N4END[13] Tile_X0Y0_N4BEG[5] VPWR VGND sg13g2_buf_1
XFILLER_107_68 VPWR VGND sg13g2_fill_2
X_6188_ Tile_X0Y0_FrameData[8] Tile_X0Y0_FrameData_O[8] VPWR VGND sg13g2_buf_1
XFILLER_76_308 VPWR VGND sg13g2_fill_1
X_5208_ Tile_X0Y0_FrameData[21] Tile_X0Y1_FrameStrobe[0] Tile_X0Y0_DSP_top.Inst_DSP_top_ConfigMem.Inst_frame0_bit21.Q
+ VPWR VGND sg13g2_dlhq_1
X_5139_ VPWR Tile_X0Y0_DSP_top.Inst_DSP_top_switch_matrix.inst_cus_mux41_buf_top2bot6.X
+ _0867_ VGND sg13g2_inv_1
X_3469_ Tile_X0Y1_DSP_bot.Inst_DSP_bot_ConfigMem.Inst_frame0_bit24.Q Tile_X0Y1_N4END[3]
+ _1826_ VPWR VGND sg13g2_nor2b_1
XFILLER_12_179 VPWR VGND sg13g2_fill_2
XFILLER_106_0 VPWR VGND sg13g2_fill_2
XFILLER_79_179 VPWR VGND sg13g2_decap_4
XFILLER_79_113 VPWR VGND sg13g2_decap_8
XFILLER_73_82 VPWR VGND sg13g2_fill_1
X_2771_ _1153_ _1151_ _1152_ VPWR VGND sg13g2_nand2_1
X_2840_ _0742_ _0787_ _1220_ VPWR VGND sg13g2_nor2_1
X_4372_ Tile_X0Y0_DSP_top.Inst_DSP_top_ConfigMem.Inst_frame4_bit16.Q Tile_X0Y0_DSP_top.Inst_DSP_top_switch_matrix.bot2top0
+ Tile_X0Y0_DSP_top.Inst_DSP_top_switch_matrix.bot2top1 Tile_X0Y0_DSP_top.Inst_DSP_top_switch_matrix.bot2top2
+ Tile_X0Y0_DSP_top.Inst_DSP_top_switch_matrix.bot2top3 Tile_X0Y0_DSP_top.Inst_DSP_top_ConfigMem.Inst_frame4_bit17.Q
+ _0135_ VPWR VGND sg13g2_mux4_1
X_4441_ _0201_ VPWR _0202_ VGND Tile_X0Y0_DSP_top.Inst_DSP_top_ConfigMem.Inst_frame2_bit28.Q
+ Tile_X0Y0_DSP_top.Inst_DSP_top_switch_matrix.bot2top4 sg13g2_o21ai_1
X_6111_ VPWR VGND _2509_ sg13g2_tiehi
X_5490_ Tile_X0Y0_FrameData[27] Tile_X0Y1_FrameStrobe[9] Tile_X0Y0_DSP_top.Inst_DSP_top_ConfigMem.Inst_frame9_bit27.Q
+ VPWR VGND sg13g2_dlhq_1
X_4510_ VGND VPWR Tile_X0Y1_DSP_bot.Inst_DSP_bot_ConfigMem.Inst_frame4_bit5.Q _0266_
+ _0268_ _0267_ sg13g2_a21oi_1
X_3185_ _1434_ _1556_ _1557_ VPWR VGND sg13g2_and2_1
X_3254_ Tile_X0Y1_DSP_bot.Inst_DSP_bot_ConfigMem.Inst_frame1_bit21.Q VPWR _1622_ VGND
+ Tile_X0Y1_DSP_bot.Inst_DSP_bot_ConfigMem.Inst_frame1_bit20.Q Tile_X0Y1_DSP_bot.Inst_DSP_bot_switch_matrix.Q7
+ sg13g2_o21ai_1
X_3323_ VGND VPWR _1687_ Tile_X0Y1_DSP_bot.C9 Tile_X0Y1_DSP_bot.Inst_DSP_bot_ConfigMem.Inst_frame12_bit2.Q
+ sg13g2_or2_1
X_6042_ Tile_X0Y1_FrameData[1] Tile_X0Y1_FrameStrobe[11] Tile_X0Y1_DSP_bot.Inst_DSP_bot_ConfigMem.Inst_frame11_bit1.Q
+ VPWR VGND sg13g2_dlhq_1
XFILLER_93_182 VPWR VGND sg13g2_fill_2
XFILLER_41_219 VPWR VGND sg13g2_fill_1
X_4708_ VGND VPWR Tile_X0Y0_DSP_top.Inst_DSP_top_ConfigMem.Inst_frame3_bit13.Q _0454_
+ _0457_ Tile_X0Y0_DSP_top.Inst_DSP_top_ConfigMem.Inst_frame3_bit14.Q sg13g2_a21oi_1
X_2969_ _1343_ _1342_ _1346_ VPWR VGND sg13g2_xor2_1
X_5826_ Tile_X0Y1_FrameData[25] Tile_X0Y1_FrameStrobe[5] Tile_X0Y1_DSP_bot.Inst_DSP_bot_ConfigMem.Inst_frame5_bit25.Q
+ VPWR VGND sg13g2_dlhq_1
X_5757_ Tile_X0Y1_FrameData[30] Tile_X0Y1_FrameStrobe[3] Tile_X0Y1_DSP_bot.Inst_DSP_bot_ConfigMem.Inst_frame3_bit30.Q
+ VPWR VGND sg13g2_dlhq_1
X_5688_ Tile_X0Y1_FrameData[3] Tile_X0Y1_FrameStrobe[0] Tile_X0Y1_DSP_bot.Inst_DSP_bot_ConfigMem.Inst_frame0_bit3.Q
+ VPWR VGND sg13g2_dlhq_1
X_4639_ _0391_ Tile_X0Y0_DSP_top.Inst_DSP_top_ConfigMem.Inst_frame1_bit16.Q Tile_X0Y0_DSP_top.Inst_DSP_top_switch_matrix.bot2top6
+ VPWR VGND sg13g2_nand2b_1
X_6309_ Tile_X0Y0_W6END[6] Tile_X0Y0_W6BEG[4] VPWR VGND sg13g2_buf_1
XFILLER_1_359 VPWR VGND sg13g2_fill_2
XFILLER_40_285 VPWR VGND sg13g2_fill_1
XFILLER_4_164 VPWR VGND sg13g2_fill_2
X_3941_ Tile_X0Y0_S1END[0] Tile_X0Y0_DSP_top.Inst_DSP_top_switch_matrix.bot2top4 Tile_X0Y0_DSP_top.Inst_DSP_top_ConfigMem.Inst_frame11_bit20.Q
+ _2236_ VPWR VGND sg13g2_mux2_1
XFILLER_90_196 VPWR VGND sg13g2_fill_1
XFILLER_90_185 VPWR VGND sg13g2_decap_8
X_4990_ _0725_ VPWR _0726_ VGND _0705_ _0706_ sg13g2_o21ai_1
X_3872_ VGND VPWR Tile_X0Y0_DSP_top.Inst_DSP_top_ConfigMem.Inst_frame4_bit0.Q _0134_
+ _2185_ _2184_ sg13g2_a21oi_1
XFILLER_69_0 VPWR VGND sg13g2_fill_1
X_5542_ Tile_X0Y0_FrameData[7] Tile_X0Y1_FrameStrobe[10] Tile_X0Y0_DSP_top.Inst_DSP_top_ConfigMem.Inst_frame10_bit7.Q
+ VPWR VGND sg13g2_dlhq_1
X_2754_ _1136_ _1001_ _1002_ VPWR VGND sg13g2_xnor2_1
X_2823_ _1203_ _1202_ _1196_ VPWR VGND sg13g2_nand2b_1
X_5611_ _2484_ VGND VPWR _0007_ Tile_X0Y1_DSP_bot.Inst_MULADD.ACC\[7\] clknet_3_2_0_Tile_X0Y1_UserCLK_regs
+ sg13g2_dfrbpq_1
X_4355_ VPWR _0118_ Tile_X0Y0_DSP_top.Inst_DSP_top_ConfigMem.Inst_frame1_bit30.Q VGND
+ sg13g2_inv_1
XFILLER_98_230 VPWR VGND sg13g2_decap_4
X_5473_ Tile_X0Y0_FrameData[12] Tile_X0Y1_FrameStrobe[8] Tile_X0Y0_DSP_top.Inst_DSP_top_ConfigMem.Inst_frame8_bit12.Q
+ VPWR VGND sg13g2_dlhq_1
X_3306_ Tile_X0Y1_DSP_bot.Inst_DSP_bot_ConfigMem.Inst_frame2_bit22.Q _1671_ _1672_
+ VPWR VGND sg13g2_nor2_1
X_4424_ _0178_ VPWR _0185_ VGND Tile_X0Y1_DSP_bot.Inst_DSP_bot_ConfigMem.Inst_frame1_bit15.Q
+ _0184_ sg13g2_o21ai_1
X_2685_ Tile_X0Y1_E2MID[2] Tile_X0Y0_DSP_top.Inst_DSP_top_switch_matrix.JS2BEG2 Tile_X0Y1_DSP_bot.Inst_DSP_bot_ConfigMem.Inst_frame7_bit2.Q
+ _1071_ VPWR VGND sg13g2_mux2_1
X_3168_ _1540_ VPWR _1541_ VGND Tile_X0Y1_NN4END[6] Tile_X0Y0_DSP_top.Inst_DSP_top_ConfigMem.Inst_frame0_bit18.Q
+ sg13g2_o21ai_1
X_4286_ VPWR _0049_ Tile_X0Y0_S2MID[6] VGND sg13g2_inv_1
X_6025_ Tile_X0Y1_FrameData[18] Tile_X0Y1_FrameStrobe[11] Tile_X0Y1_DSP_bot.Inst_DSP_bot_ConfigMem.Inst_frame11_bit18.Q
+ VPWR VGND sg13g2_dlhq_1
X_3237_ Tile_X0Y1_DSP_bot.Inst_DSP_bot_ConfigMem.Inst_frame3_bit28.Q Tile_X0Y1_DSP_bot.Inst_DSP_bot_switch_matrix.Q0
+ Tile_X0Y1_DSP_bot.Inst_DSP_bot_switch_matrix.Q1 Tile_X0Y1_DSP_bot.Inst_DSP_bot_switch_matrix.Q2
+ Tile_X0Y1_DSP_bot.Inst_DSP_bot_switch_matrix.Q3 Tile_X0Y1_DSP_bot.Inst_DSP_bot_ConfigMem.Inst_frame3_bit29.Q
+ _1606_ VPWR VGND sg13g2_mux4_1
X_3099_ _1476_ Tile_X0Y0_DSP_top.Inst_DSP_top_ConfigMem.Inst_frame1_bit20.Q Tile_X0Y0_W1END[2]
+ VPWR VGND sg13g2_nand2b_1
XFILLER_80_39 VPWR VGND sg13g2_fill_2
X_5809_ Tile_X0Y1_FrameData[10] Tile_X0Y1_FrameStrobe[4] Tile_X0Y1_DSP_bot.Inst_DSP_bot_ConfigMem.Inst_frame4_bit10.Q
+ VPWR VGND sg13g2_dlhq_1
XFILLER_108_346 VPWR VGND sg13g2_fill_1
XFILLER_1_134 VPWR VGND sg13g2_fill_2
X_4140_ Tile_X0Y1_DSP_bot.Inst_DSP_bot_ConfigMem.Inst_frame11_bit21.Q VPWR _2391_
+ VGND Tile_X0Y1_DSP_bot.Inst_DSP_bot_ConfigMem.Inst_frame11_bit20.Q _2390_ sg13g2_o21ai_1
XFILLER_95_91 VPWR VGND sg13g2_decap_8
X_3022_ _1399_ _1375_ _1383_ VPWR VGND sg13g2_xnor2_1
X_4071_ Tile_X0Y1_DSP_bot.Inst_DSP_bot_ConfigMem.Inst_frame3_bit0.Q Tile_X0Y1_E6END[1]
+ _2342_ VPWR VGND sg13g2_nor2b_1
X_3924_ Tile_X0Y0_DSP_top.Inst_DSP_top_ConfigMem.Inst_frame11_bit3.Q Tile_X0Y0_DSP_top.Inst_DSP_top_switch_matrix.bot2top9
+ _1510_ _2015_ _0989_ Tile_X0Y0_DSP_top.Inst_DSP_top_ConfigMem.Inst_frame11_bit4.Q
+ _2222_ VPWR VGND sg13g2_mux4_1
X_4973_ _0710_ Tile_X0Y0_DSP_top.Inst_DSP_top_ConfigMem.Inst_frame2_bit0.Q Tile_X0Y0_DSP_top.Inst_DSP_top_switch_matrix.bot2top9
+ VPWR VGND sg13g2_nand2_1
XFILLER_63_185 VPWR VGND sg13g2_fill_2
X_3786_ VGND VPWR Tile_X0Y0_DSP_top.Inst_DSP_top_ConfigMem.Inst_frame3_bit30.Q _2114_
+ _2115_ _2113_ sg13g2_a21oi_1
X_3855_ Tile_X0Y0_DSP_top.Inst_DSP_top_ConfigMem.Inst_frame1_bit2.Q VPWR _2176_ VGND
+ Tile_X0Y0_DSP_top.Inst_DSP_top_ConfigMem.Inst_frame1_bit1.Q _2175_ sg13g2_o21ai_1
X_5456_ Tile_X0Y0_FrameData[29] Tile_X0Y1_FrameStrobe[8] Tile_X0Y0_DSP_top.Inst_DSP_top_ConfigMem.Inst_frame8_bit29.Q
+ VPWR VGND sg13g2_dlhq_1
X_5525_ Tile_X0Y0_FrameData[24] Tile_X0Y1_FrameStrobe[10] Tile_X0Y0_DSP_top.Inst_DSP_top_ConfigMem.Inst_frame10_bit24.Q
+ VPWR VGND sg13g2_dlhq_1
X_2806_ _1183_ VPWR Tile_X0Y1_DSP_bot.A0 VGND _1184_ _1186_ sg13g2_o21ai_1
X_2668_ VGND VPWR _1051_ _1054_ _1055_ _0083_ sg13g2_a21oi_1
X_2737_ VPWR Tile_X0Y1_DSP_bot.Inst_DSP_bot_switch_matrix.JS2BEG4 _1120_ VGND sg13g2_inv_1
X_4269_ VPWR _0032_ Tile_X0Y0_S1END[0] VGND sg13g2_inv_1
XFILLER_86_266 VPWR VGND sg13g2_fill_2
X_5387_ Tile_X0Y0_FrameData[2] Tile_X0Y1_FrameStrobe[5] Tile_X0Y0_DSP_top.Inst_DSP_top_ConfigMem.Inst_frame5_bit2.Q
+ VPWR VGND sg13g2_dlhq_1
X_2599_ VGND VPWR Tile_X0Y0_DSP_top.Inst_DSP_top_ConfigMem.Inst_frame0_bit3.Q _0984_
+ _0988_ _0987_ sg13g2_a21oi_1
X_4338_ VPWR _0101_ Tile_X0Y1_DSP_bot.Inst_MULADD.C_reg\[8\] VGND sg13g2_inv_1
X_4407_ _0030_ VPWR _0169_ VGND Tile_X0Y1_DSP_bot.Inst_DSP_bot_ConfigMem.Inst_frame3_bit10.Q
+ _0168_ sg13g2_o21ai_1
XFILLER_54_152 VPWR VGND sg13g2_fill_1
X_6008_ Tile_X0Y1_FrameData[3] Tile_X0Y1_FrameStrobe[10] Tile_X0Y1_DSP_bot.Inst_DSP_bot_ConfigMem.Inst_frame10_bit3.Q
+ VPWR VGND sg13g2_dlhq_1
XFILLER_92_247 VPWR VGND sg13g2_fill_1
XFILLER_65_50 VPWR VGND sg13g2_fill_1
XFILLER_49_95 VPWR VGND sg13g2_fill_2
XFILLER_1_25 VPWR VGND sg13g2_decap_4
XFILLER_18_333 VPWR VGND sg13g2_fill_1
XFILLER_45_185 VPWR VGND sg13g2_decap_8
XANTENNA_151 VPWR VGND Tile_X0Y0_S4END[6] sg13g2_antennanp
XANTENNA_140 VPWR VGND Tile_X0Y0_S4END[6] sg13g2_antennanp
X_3640_ _1978_ VPWR _1979_ VGND Tile_X0Y0_S2END[7] Tile_X0Y0_DSP_top.Inst_DSP_top_ConfigMem.Inst_frame3_bit24.Q
+ sg13g2_o21ai_1
XFILLER_81_93 VPWR VGND sg13g2_decap_4
XFILLER_81_82 VPWR VGND sg13g2_fill_1
X_5310_ Tile_X0Y0_FrameData[15] Tile_X0Y1_FrameStrobe[3] Tile_X0Y0_DSP_top.Inst_DSP_top_ConfigMem.Inst_frame3_bit15.Q
+ VPWR VGND sg13g2_dlhq_1
X_6290_ Tile_X0Y0_DSP_top.Inst_DSP_top_switch_matrix.JW2BEG1 Tile_X0Y0_W2BEG[1] VPWR
+ VGND sg13g2_buf_1
X_3571_ VGND VPWR _1921_ _1922_ _1923_ _1837_ sg13g2_a21oi_1
XFILLER_110_341 VPWR VGND sg13g2_fill_2
X_5241_ Tile_X0Y0_FrameData[20] Tile_X0Y1_FrameStrobe[1] Tile_X0Y0_DSP_top.Inst_DSP_top_ConfigMem.Inst_frame1_bit20.Q
+ VPWR VGND sg13g2_dlhq_1
X_5172_ _0898_ Tile_X0Y1_DSP_bot.Inst_DSP_bot_ConfigMem.Inst_frame12_bit0.Q Tile_X0Y1_DSP_bot.Inst_MULADD.A_reg\[2\]
+ VPWR VGND sg13g2_nand2_1
X_4123_ _2376_ _2375_ Tile_X0Y1_DSP_bot.Inst_DSP_bot_ConfigMem.Inst_frame11_bit12.Q
+ Tile_X0Y1_DSP_bot.Inst_DSP_bot_switch_matrix.EE4BEG0 VPWR VGND sg13g2_mux2_1
X_3005_ _1376_ _1381_ _1382_ VPWR VGND sg13g2_and2_1
X_4054_ Tile_X0Y1_DSP_bot.Inst_DSP_bot_ConfigMem.Inst_frame12_bit17.Q Tile_X0Y1_N2END[3]
+ Tile_X0Y1_E6END[0] Tile_X0Y1_N4END[2] Tile_X0Y1_DSP_bot.Inst_DSP_bot_switch_matrix.Q5
+ Tile_X0Y1_DSP_bot.Inst_DSP_bot_ConfigMem.Inst_frame12_bit16.Q Tile_X0Y0_DSP_top.N4BEG_outbuf_9.A
+ VPWR VGND sg13g2_mux4_1
X_3907_ Tile_X0Y0_DSP_top.Inst_DSP_top_ConfigMem.Inst_frame12_bit31.Q VPWR _2207_
+ VGND _2205_ _2206_ sg13g2_o21ai_1
X_3838_ _2158_ VPWR _2159_ VGND Tile_X0Y0_DSP_top.Inst_DSP_top_ConfigMem.Inst_frame1_bit1.Q
+ _2156_ sg13g2_o21ai_1
X_4887_ Tile_X0Y0_DSP_top.Inst_DSP_top_ConfigMem.Inst_frame2_bit15.Q VPWR _0628_ VGND
+ _0626_ _0627_ sg13g2_o21ai_1
X_4956_ Tile_X0Y1_DSP_bot.Inst_DSP_bot_ConfigMem.Inst_frame1_bit17.Q VPWR _0693_ VGND
+ Tile_X0Y1_DSP_bot.Inst_DSP_bot_ConfigMem.Inst_frame1_bit16.Q Tile_X0Y1_DSP_bot.Inst_DSP_bot_switch_matrix.Q7
+ sg13g2_o21ai_1
X_3769_ VPWR _2099_ _2098_ VGND sg13g2_inv_1
X_5508_ Tile_X0Y0_FrameData[9] Tile_X0Y1_FrameStrobe[9] Tile_X0Y0_DSP_top.Inst_DSP_top_ConfigMem.Inst_frame9_bit9.Q
+ VPWR VGND sg13g2_dlhq_1
X_5439_ Tile_X0Y0_FrameData[14] Tile_X0Y1_FrameStrobe[7] Tile_X0Y0_DSP_top.Inst_DSP_top_ConfigMem.Inst_frame7_bit14.Q
+ VPWR VGND sg13g2_dlhq_1
X_6488_ Tile_X0Y1_W6END[5] Tile_X0Y1_W6BEG[3] VPWR VGND sg13g2_buf_1
XFILLER_59_266 VPWR VGND sg13g2_fill_1
XFILLER_59_255 VPWR VGND sg13g2_fill_1
XFILLER_27_174 VPWR VGND sg13g2_fill_2
XFILLER_51_96 VPWR VGND sg13g2_fill_1
XFILLER_42_199 VPWR VGND sg13g2_fill_2
XFILLER_76_82 VPWR VGND sg13g2_fill_2
X_4741_ VPWR Tile_X0Y0_DSP_top.Inst_DSP_top_switch_matrix.N2BEGb7 _0488_ VGND sg13g2_inv_1
X_4810_ Tile_X0Y0_DSP_top.Inst_DSP_top_switch_matrix.bot2top2 Tile_X0Y0_DSP_top.Inst_DSP_top_switch_matrix.bot2top4
+ Tile_X0Y0_DSP_top.Inst_DSP_top_ConfigMem.Inst_frame1_bit12.Q _0553_ VPWR VGND sg13g2_mux2_1
X_4672_ VGND VPWR Tile_X0Y1_DSP_bot.Inst_DSP_bot_ConfigMem.Inst_frame4_bit20.Q _0049_
+ _0423_ Tile_X0Y1_DSP_bot.Inst_DSP_bot_ConfigMem.Inst_frame4_bit21.Q sg13g2_a21oi_1
X_5790_ Tile_X0Y1_FrameData[29] Tile_X0Y1_FrameStrobe[4] Tile_X0Y1_DSP_bot.Inst_DSP_bot_ConfigMem.Inst_frame4_bit29.Q
+ VPWR VGND sg13g2_dlhq_1
X_3623_ _1962_ _1459_ _1941_ VPWR VGND sg13g2_nand2_1
X_6411_ Tile_X0Y1_FrameData[30] Tile_X0Y1_FrameData_O[30] VPWR VGND sg13g2_buf_1
XFILLER_51_0 VPWR VGND sg13g2_fill_1
X_6342_ Tile_X0Y1_DSP_bot.Inst_DSP_bot_switch_matrix.E2BEG5 Tile_X0Y1_E2BEG[5] VPWR
+ VGND sg13g2_buf_1
X_6273_ Tile_X0Y1_NN4END[13] Tile_X0Y0_NN4BEG[5] VPWR VGND sg13g2_buf_1
X_3485_ VGND VPWR _0025_ Tile_X0Y1_DSP_bot.Inst_DSP_bot_ConfigMem.Inst_frame0_bit22.Q
+ _1841_ Tile_X0Y1_DSP_bot.Inst_DSP_bot_ConfigMem.Inst_frame0_bit23.Q sg13g2_a21oi_1
X_3554_ _0107_ VPWR _1907_ VGND Tile_X0Y1_DSP_bot.Inst_DSP_bot_ConfigMem.Inst_frame7_bit17.Q
+ _1906_ sg13g2_o21ai_1
XFILLER_102_149 VPWR VGND sg13g2_decap_4
XFILLER_88_339 VPWR VGND sg13g2_fill_2
X_5224_ Tile_X0Y0_FrameData[5] Tile_X0Y1_FrameStrobe[0] Tile_X0Y0_DSP_top.Inst_DSP_top_ConfigMem.Inst_frame0_bit5.Q
+ VPWR VGND sg13g2_dlhq_1
X_5086_ VPWR _0817_ _0816_ VGND sg13g2_inv_1
X_5155_ Tile_X0Y1_DSP_bot.Inst_DSP_bot_ConfigMem.Inst_frame2_bit7.Q VPWR _0883_ VGND
+ Tile_X0Y1_DSP_bot.Inst_DSP_bot_ConfigMem.Inst_frame2_bit6.Q _0878_ sg13g2_o21ai_1
X_4106_ Tile_X0Y1_DSP_bot.Inst_DSP_bot_ConfigMem.Inst_frame10_bit28.Q Tile_X0Y1_DSP_bot.Inst_DSP_bot_switch_matrix.Q6
+ _0209_ Tile_X0Y1_DSP_bot.Inst_DSP_bot_switch_matrix.JS2BEG0 _0223_ Tile_X0Y1_DSP_bot.Inst_DSP_bot_ConfigMem.Inst_frame10_bit29.Q
+ Tile_X0Y1_DSP_bot.Inst_DSP_bot_switch_matrix.W1BEG1 VPWR VGND sg13g2_mux4_1
X_4037_ Tile_X0Y0_DSP_top.Inst_DSP_top_ConfigMem.Inst_frame9_bit18.Q Tile_X0Y0_DSP_top.Inst_DSP_top_switch_matrix.bot2top6
+ Tile_X0Y0_DSP_top.Inst_DSP_top_switch_matrix.bot2top7 Tile_X0Y0_DSP_top.Inst_DSP_top_switch_matrix.bot2top8
+ Tile_X0Y0_DSP_top.Inst_DSP_top_switch_matrix.bot2top9 Tile_X0Y0_DSP_top.Inst_DSP_top_ConfigMem.Inst_frame9_bit19.Q
+ _2320_ VPWR VGND sg13g2_mux4_1
XFILLER_64_291 VPWR VGND sg13g2_fill_1
X_5988_ Tile_X0Y1_FrameData[23] Tile_X0Y1_FrameStrobe[10] Tile_X0Y1_DSP_bot.Inst_DSP_bot_ConfigMem.Inst_frame10_bit23.Q
+ VPWR VGND sg13g2_dlhq_1
XANTENNA_84 VPWR VGND Tile_X0Y1_FrameStrobe[17] sg13g2_antennanp
XANTENNA_40 VPWR VGND Tile_X0Y1_N4END[12] sg13g2_antennanp
XANTENNA_51 VPWR VGND Tile_X0Y1_NN4END[7] sg13g2_antennanp
XANTENNA_73 VPWR VGND Tile_X0Y0_FrameData[6] sg13g2_antennanp
XANTENNA_62 VPWR VGND Tile_X0Y0_FrameData[6] sg13g2_antennanp
XANTENNA_95 VPWR VGND Tile_X0Y0_S2MID[4] sg13g2_antennanp
X_4939_ VGND VPWR _0641_ _0642_ _0678_ _0677_ sg13g2_a21oi_1
XFILLER_21_66 VPWR VGND sg13g2_fill_2
XFILLER_62_217 VPWR VGND sg13g2_fill_1
XFILLER_62_206 VPWR VGND sg13g2_fill_2
XFILLER_102_80 VPWR VGND sg13g2_fill_2
XFILLER_62_51 VPWR VGND sg13g2_fill_2
XFILLER_38_203 VPWR VGND sg13g2_fill_2
X_3270_ Tile_X0Y1_DSP_bot.Inst_DSP_bot_ConfigMem.Inst_frame1_bit30.Q _1636_ _1637_
+ VPWR VGND sg13g2_nor2_1
XFILLER_93_353 VPWR VGND sg13g2_fill_1
XFILLER_38_258 VPWR VGND sg13g2_fill_2
X_5842_ Tile_X0Y1_FrameData[9] Tile_X0Y1_FrameStrobe[5] Tile_X0Y1_DSP_bot.Inst_DSP_bot_ConfigMem.Inst_frame5_bit9.Q
+ VPWR VGND sg13g2_dlhq_1
X_5911_ Tile_X0Y1_FrameData[4] Tile_X0Y1_FrameStrobe[7] Tile_X0Y1_DSP_bot.Inst_DSP_bot_ConfigMem.Inst_frame7_bit4.Q
+ VPWR VGND sg13g2_dlhq_1
X_4655_ Tile_X0Y0_DSP_top.Inst_DSP_top_ConfigMem.Inst_frame0_bit31.Q Tile_X0Y1_NN4END[4]
+ Tile_X0Y0_W2END[0] Tile_X0Y0_E6END[0] _0406_ Tile_X0Y0_DSP_top.Inst_DSP_top_ConfigMem.Inst_frame0_bit30.Q
+ _0407_ VPWR VGND sg13g2_mux4_1
X_2985_ _0969_ _1260_ _1361_ _1362_ VPWR VGND sg13g2_nor3_1
X_4724_ Tile_X0Y1_DSP_bot.Inst_DSP_bot_ConfigMem.Inst_frame4_bit30.Q VPWR _0472_ VGND
+ _0470_ _0471_ sg13g2_o21ai_1
X_5773_ Tile_X0Y1_FrameData[14] Tile_X0Y1_FrameStrobe[3] Tile_X0Y1_DSP_bot.Inst_DSP_bot_ConfigMem.Inst_frame3_bit14.Q
+ VPWR VGND sg13g2_dlhq_1
X_6256_ Tile_X0Y1_N4END[12] Tile_X0Y0_N4BEG[4] VPWR VGND sg13g2_buf_1
XFILLER_107_14 VPWR VGND sg13g2_decap_8
XFILLER_88_158 VPWR VGND sg13g2_fill_1
XFILLER_88_114 VPWR VGND sg13g2_decap_4
X_4586_ VGND VPWR Tile_X0Y0_DSP_top.Inst_DSP_top_ConfigMem.Inst_frame4_bit5.Q _0337_
+ _0340_ Tile_X0Y0_DSP_top.Inst_DSP_top_ConfigMem.Inst_frame4_bit6.Q sg13g2_a21oi_1
X_6325_ Tile_X0Y0_WW4END[12] Tile_X0Y0_WW4BEG[8] VPWR VGND sg13g2_buf_1
X_3468_ VGND VPWR Tile_X0Y1_DSP_bot.Inst_DSP_bot_ConfigMem.Inst_frame0_bit24.Q _0678_
+ _1825_ _1824_ sg13g2_a21oi_1
X_3606_ _1952_ _1926_ _1927_ VPWR VGND sg13g2_xnor2_1
X_3537_ _1890_ _0072_ Tile_X0Y1_DSP_bot.C1 VPWR VGND sg13g2_nand2_1
X_6187_ Tile_X0Y0_FrameData[7] Tile_X0Y0_FrameData_O[7] VPWR VGND sg13g2_buf_1
X_5069_ Tile_X0Y0_W6END[0] Tile_X0Y0_DSP_top.Inst_DSP_top_switch_matrix.JW2BEG2 Tile_X0Y0_DSP_top.Inst_DSP_top_ConfigMem.Inst_frame0_bit14.Q
+ _0801_ VPWR VGND sg13g2_mux2_1
X_5207_ Tile_X0Y0_FrameData[22] Tile_X0Y1_FrameStrobe[0] Tile_X0Y0_DSP_top.Inst_DSP_top_ConfigMem.Inst_frame0_bit22.Q
+ VPWR VGND sg13g2_dlhq_1
X_5138_ Tile_X0Y0_DSP_top.Inst_DSP_top_ConfigMem.Inst_frame8_bit6.Q _0861_ _0866_
+ _0842_ _0840_ Tile_X0Y0_DSP_top.Inst_DSP_top_ConfigMem.Inst_frame8_bit7.Q _0867_
+ VPWR VGND sg13g2_mux4_1
X_3399_ _1759_ _1758_ _1428_ VPWR VGND sg13g2_nand2b_1
XFILLER_8_107 VPWR VGND sg13g2_fill_1
XFILLER_90_334 VPWR VGND sg13g2_fill_2
X_2770_ _1012_ VPWR _1152_ VGND _0610_ _1013_ sg13g2_o21ai_1
XFILLER_11_180 VPWR VGND sg13g2_decap_8
X_4371_ VPWR _0134_ Tile_X0Y0_DSP_top.Inst_DSP_top_switch_matrix.bot2top9 VGND sg13g2_inv_1
XFILLER_98_80 VPWR VGND sg13g2_fill_2
X_4440_ _0201_ Tile_X0Y0_DSP_top.Inst_DSP_top_ConfigMem.Inst_frame2_bit28.Q Tile_X0Y0_DSP_top.Inst_DSP_top_switch_matrix.bot2top5
+ VPWR VGND sg13g2_nand2b_1
X_6110_ VPWR VGND _2508_ sg13g2_tiehi
X_3322_ VGND VPWR _1611_ _1655_ Tile_X0Y1_DSP_bot.C9 _1686_ sg13g2_a21oi_1
XFILLER_85_106 VPWR VGND sg13g2_fill_1
X_3184_ _1271_ _1432_ _1433_ _1556_ VPWR VGND sg13g2_or3_1
X_3253_ _1620_ VPWR _1621_ VGND Tile_X0Y1_DSP_bot.Inst_DSP_bot_ConfigMem.Inst_frame1_bit20.Q
+ Tile_X0Y1_DSP_bot.Inst_DSP_bot_switch_matrix.Q4 sg13g2_o21ai_1
XFILLER_14_0 VPWR VGND sg13g2_fill_1
X_6041_ Tile_X0Y1_FrameData[2] Tile_X0Y1_FrameStrobe[11] Tile_X0Y1_DSP_bot.Inst_DSP_bot_ConfigMem.Inst_frame11_bit2.Q
+ VPWR VGND sg13g2_dlhq_1
XFILLER_26_217 VPWR VGND sg13g2_decap_8
X_5825_ Tile_X0Y1_FrameData[26] Tile_X0Y1_FrameStrobe[5] Tile_X0Y1_DSP_bot.Inst_DSP_bot_ConfigMem.Inst_frame5_bit26.Q
+ VPWR VGND sg13g2_dlhq_1
X_4638_ Tile_X0Y0_DSP_top.Inst_DSP_top_ConfigMem.Inst_frame1_bit18.Q _0389_ _0390_
+ VPWR VGND sg13g2_nor2_1
X_4707_ VGND VPWR Tile_X0Y0_DSP_top.Inst_DSP_top_ConfigMem.Inst_frame3_bit12.Q _0133_
+ _0456_ _0455_ sg13g2_a21oi_1
X_2899_ _1277_ _1220_ _1276_ VPWR VGND sg13g2_nand2_1
X_2968_ _1337_ VPWR _1345_ VGND _1334_ _1338_ sg13g2_o21ai_1
X_5756_ Tile_X0Y1_FrameData[31] Tile_X0Y1_FrameStrobe[3] Tile_X0Y1_DSP_bot.Inst_DSP_bot_ConfigMem.Inst_frame3_bit31.Q
+ VPWR VGND sg13g2_dlhq_1
X_5687_ Tile_X0Y1_FrameData[4] Tile_X0Y1_FrameStrobe[0] Tile_X0Y1_DSP_bot.Inst_DSP_bot_ConfigMem.Inst_frame0_bit4.Q
+ VPWR VGND sg13g2_dlhq_1
X_6239_ Tile_X0Y0_DSP_top.Inst_DSP_top_switch_matrix.JN2BEG3 Tile_X0Y0_N2BEG[3] VPWR
+ VGND sg13g2_buf_1
XFILLER_103_266 VPWR VGND sg13g2_fill_1
XFILLER_103_200 VPWR VGND sg13g2_fill_2
X_4569_ Tile_X0Y0_DSP_top.Inst_DSP_top_ConfigMem.Inst_frame3_bit10.Q VPWR _0324_ VGND
+ Tile_X0Y0_DSP_top.Inst_DSP_top_ConfigMem.Inst_frame3_bit9.Q _0321_ sg13g2_o21ai_1
X_6308_ Tile_X0Y0_W6END[5] Tile_X0Y0_W6BEG[3] VPWR VGND sg13g2_buf_1
XFILLER_76_128 VPWR VGND sg13g2_fill_2
XFILLER_76_106 VPWR VGND sg13g2_fill_1
XFILLER_1_338 VPWR VGND sg13g2_fill_1
XFILLER_4_47 VPWR VGND sg13g2_fill_2
XFILLER_0_360 VPWR VGND sg13g2_fill_1
X_3871_ Tile_X0Y0_DSP_top.Inst_DSP_top_ConfigMem.Inst_frame4_bit1.Q VPWR _2184_ VGND
+ Tile_X0Y0_DSP_top.Inst_DSP_top_ConfigMem.Inst_frame4_bit0.Q Tile_X0Y0_DSP_top.Inst_DSP_top_switch_matrix.bot2top7
+ sg13g2_o21ai_1
X_3940_ _2234_ VPWR _2235_ VGND Tile_X0Y0_DSP_top.Inst_DSP_top_ConfigMem.Inst_frame11_bit20.Q
+ _0189_ sg13g2_o21ai_1
XFILLER_84_71 VPWR VGND sg13g2_fill_2
X_5472_ Tile_X0Y0_FrameData[13] Tile_X0Y1_FrameStrobe[8] Tile_X0Y0_DSP_top.Inst_DSP_top_ConfigMem.Inst_frame8_bit13.Q
+ VPWR VGND sg13g2_dlhq_1
X_5541_ Tile_X0Y0_FrameData[8] Tile_X0Y1_FrameStrobe[10] Tile_X0Y0_DSP_top.Inst_DSP_top_ConfigMem.Inst_frame10_bit8.Q
+ VPWR VGND sg13g2_dlhq_1
X_2753_ _1084_ VPWR _1135_ VGND _1085_ _1134_ sg13g2_o21ai_1
X_2822_ _1200_ _1197_ _1202_ VPWR VGND sg13g2_xor2_1
X_2684_ VGND VPWR Tile_X0Y1_DSP_bot.Inst_DSP_bot_ConfigMem.Inst_frame7_bit3.Q _1069_
+ _1070_ Tile_X0Y1_DSP_bot.Inst_DSP_bot_ConfigMem.Inst_frame9_bit25.Q sg13g2_a21oi_1
X_5610_ _2485_ VGND VPWR _0006_ Tile_X0Y1_DSP_bot.Inst_MULADD.ACC\[6\] clknet_3_2_0_Tile_X0Y1_UserCLK_regs
+ sg13g2_dfrbpq_1
X_4285_ VPWR _0048_ Tile_X0Y0_S1END[1] VGND sg13g2_inv_1
X_4354_ VPWR _0117_ Tile_X0Y0_DSP_top.Inst_DSP_top_ConfigMem.Inst_frame8_bit30.Q VGND
+ sg13g2_inv_1
X_3305_ Tile_X0Y1_DSP_bot.Inst_DSP_bot_ConfigMem.Inst_frame2_bit20.Q Tile_X0Y1_DSP_bot.Inst_DSP_bot_switch_matrix.Q0
+ Tile_X0Y1_DSP_bot.Inst_DSP_bot_switch_matrix.Q1 Tile_X0Y1_DSP_bot.Inst_DSP_bot_switch_matrix.Q2
+ Tile_X0Y1_DSP_bot.Inst_DSP_bot_switch_matrix.Q3 Tile_X0Y1_DSP_bot.Inst_DSP_bot_ConfigMem.Inst_frame2_bit21.Q
+ _1671_ VPWR VGND sg13g2_mux4_1
X_4423_ _0183_ VPWR _0184_ VGND Tile_X0Y1_DSP_bot.Inst_DSP_bot_ConfigMem.Inst_frame1_bit14.Q
+ _0179_ sg13g2_o21ai_1
X_6024_ Tile_X0Y1_FrameData[19] Tile_X0Y1_FrameStrobe[11] Tile_X0Y1_DSP_bot.Inst_DSP_bot_ConfigMem.Inst_frame11_bit19.Q
+ VPWR VGND sg13g2_dlhq_1
X_3098_ _1474_ VPWR _1475_ VGND _0032_ Tile_X0Y0_DSP_top.Inst_DSP_top_ConfigMem.Inst_frame1_bit20.Q
+ sg13g2_o21ai_1
X_3167_ _1540_ Tile_X0Y0_DSP_top.Inst_DSP_top_ConfigMem.Inst_frame0_bit18.Q Tile_X0Y0_E2END[2]
+ VPWR VGND sg13g2_nand2b_1
XFILLER_66_150 VPWR VGND sg13g2_fill_2
XFILLER_54_323 VPWR VGND sg13g2_fill_1
X_3236_ _1604_ VPWR _1605_ VGND Tile_X0Y1_DSP_bot.Inst_DSP_bot_ConfigMem.Inst_frame3_bit29.Q
+ _1601_ sg13g2_o21ai_1
X_5739_ Tile_X0Y1_FrameData[16] Tile_X0Y1_FrameStrobe[2] Tile_X0Y1_DSP_bot.Inst_DSP_bot_ConfigMem.Inst_frame2_bit16.Q
+ VPWR VGND sg13g2_dlhq_1
X_5808_ Tile_X0Y1_FrameData[11] Tile_X0Y1_FrameStrobe[4] Tile_X0Y1_DSP_bot.Inst_DSP_bot_ConfigMem.Inst_frame4_bit11.Q
+ VPWR VGND sg13g2_dlhq_1
XFILLER_108_314 VPWR VGND sg13g2_decap_4
XFILLER_89_286 VPWR VGND sg13g2_fill_1
XFILLER_72_153 VPWR VGND sg13g2_fill_2
XFILLER_54_41 VPWR VGND sg13g2_fill_2
XFILLER_45_323 VPWR VGND sg13g2_fill_1
XFILLER_95_81 VPWR VGND sg13g2_fill_1
XFILLER_63_142 VPWR VGND sg13g2_fill_1
X_3021_ VGND VPWR _1398_ _1397_ _1392_ sg13g2_or2_1
X_4070_ Tile_X0Y1_W2END[1] Tile_X0Y1_W6END[1] Tile_X0Y1_DSP_bot.Inst_DSP_bot_ConfigMem.Inst_frame3_bit0.Q
+ _2341_ VPWR VGND sg13g2_mux2_1
X_3923_ Tile_X0Y0_DSP_top.Inst_DSP_top_ConfigMem.Inst_frame11_bit4.Q _0237_ Tile_X0Y0_W1END[1]
+ Tile_X0Y0_E1END[1] Tile_X0Y0_DSP_top.Inst_DSP_top_switch_matrix.bot2top5 Tile_X0Y0_DSP_top.Inst_DSP_top_ConfigMem.Inst_frame11_bit3.Q
+ _2221_ VPWR VGND sg13g2_mux4_1
X_3854_ VGND VPWR Tile_X0Y0_DSP_top.Inst_DSP_top_ConfigMem.Inst_frame1_bit0.Q Tile_X0Y0_DSP_top.Inst_DSP_top_switch_matrix.bot2top6
+ _2175_ _2174_ sg13g2_a21oi_1
XFILLER_81_0 VPWR VGND sg13g2_fill_1
X_4972_ VGND VPWR Tile_X0Y0_DSP_top.Inst_DSP_top_ConfigMem.Inst_frame2_bit0.Q Tile_X0Y0_DSP_top.Inst_DSP_top_switch_matrix.bot2top6
+ _0709_ _0708_ sg13g2_a21oi_1
X_2805_ Tile_X0Y1_DSP_bot.Inst_DSP_bot_ConfigMem.Inst_frame9_bit23.Q VPWR _1186_ VGND
+ Tile_X0Y1_DSP_bot.Inst_DSP_bot_ConfigMem.Inst_frame9_bit22.Q _1185_ sg13g2_o21ai_1
X_3785_ Tile_X0Y0_DSP_top.Inst_DSP_top_ConfigMem.Inst_frame3_bit29.Q Tile_X0Y0_DSP_top.Inst_DSP_top_switch_matrix.bot2top4
+ Tile_X0Y0_DSP_top.Inst_DSP_top_switch_matrix.bot2top6 Tile_X0Y0_DSP_top.Inst_DSP_top_switch_matrix.bot2top5
+ Tile_X0Y0_DSP_top.Inst_DSP_top_switch_matrix.bot2top9 Tile_X0Y0_DSP_top.Inst_DSP_top_ConfigMem.Inst_frame3_bit28.Q
+ _2114_ VPWR VGND sg13g2_mux4_1
X_5455_ Tile_X0Y0_FrameData[30] Tile_X0Y1_FrameStrobe[8] Tile_X0Y0_DSP_top.Inst_DSP_top_ConfigMem.Inst_frame8_bit30.Q
+ VPWR VGND sg13g2_dlhq_1
X_5524_ Tile_X0Y0_FrameData[25] Tile_X0Y1_FrameStrobe[10] Tile_X0Y0_DSP_top.Inst_DSP_top_ConfigMem.Inst_frame10_bit25.Q
+ VPWR VGND sg13g2_dlhq_1
X_2736_ VGND VPWR _1110_ _1111_ _1120_ _1119_ sg13g2_a21oi_1
X_4406_ Tile_X0Y1_DSP_bot.Inst_DSP_bot_ConfigMem.Inst_frame3_bit8.Q Tile_X0Y1_N1END[1]
+ Tile_X0Y1_N2END[3] Tile_X0Y1_N4END[3] Tile_X0Y1_E2END[3] Tile_X0Y1_DSP_bot.Inst_DSP_bot_ConfigMem.Inst_frame3_bit9.Q
+ _0168_ VPWR VGND sg13g2_mux4_1
X_2667_ _0082_ _1053_ _1054_ VPWR VGND sg13g2_nor2_1
X_4268_ VPWR _0031_ Tile_X0Y1_N2MID[0] VGND sg13g2_inv_1
X_2598_ _0987_ Tile_X0Y0_DSP_top.Inst_DSP_top_ConfigMem.Inst_frame9_bit28.Q _0986_
+ VPWR VGND sg13g2_nand2_1
X_5386_ Tile_X0Y0_FrameData[3] Tile_X0Y1_FrameStrobe[5] Tile_X0Y0_DSP_top.Inst_DSP_top_ConfigMem.Inst_frame5_bit3.Q
+ VPWR VGND sg13g2_dlhq_1
X_4337_ VPWR _0100_ Tile_X0Y1_DSP_bot.Inst_DSP_bot_ConfigMem.Inst_frame1_bit26.Q VGND
+ sg13g2_inv_1
X_3219_ Tile_X0Y1_DSP_bot.Inst_DSP_bot_ConfigMem.Inst_frame3_bit20.Q Tile_X0Y1_DSP_bot.Inst_DSP_bot_switch_matrix.Q4
+ Tile_X0Y1_DSP_bot.Inst_DSP_bot_switch_matrix.Q6 Tile_X0Y1_DSP_bot.Inst_DSP_bot_switch_matrix.Q7
+ Tile_X0Y1_DSP_bot.Inst_DSP_bot_switch_matrix.Q8 Tile_X0Y1_DSP_bot.Inst_DSP_bot_ConfigMem.Inst_frame3_bit21.Q
+ _1589_ VPWR VGND sg13g2_mux4_1
X_6007_ Tile_X0Y1_FrameData[4] Tile_X0Y1_FrameStrobe[10] Tile_X0Y1_DSP_bot.Inst_DSP_bot_ConfigMem.Inst_frame10_bit4.Q
+ VPWR VGND sg13g2_dlhq_1
X_4199_ Tile_X0Y1_DSP_bot.Inst_DSP_bot_ConfigMem.Inst_frame9_bit13.Q VPWR _2440_ VGND
+ Tile_X0Y1_DSP_bot.Inst_DSP_bot_ConfigMem.Inst_frame9_bit12.Q _2439_ sg13g2_o21ai_1
XFILLER_24_88 VPWR VGND sg13g2_fill_2
XFILLER_105_91 VPWR VGND sg13g2_fill_2
XFILLER_1_48 VPWR VGND sg13g2_fill_2
XFILLER_33_359 VPWR VGND sg13g2_fill_2
XANTENNA_141 VPWR VGND Tile_X0Y0_S4END[6] sg13g2_antennanp
XANTENNA_130 VPWR VGND Tile_X0Y0_S4END[6] sg13g2_antennanp
XANTENNA_152 VPWR VGND Tile_X0Y0_S4END[6] sg13g2_antennanp
X_5240_ Tile_X0Y0_FrameData[21] Tile_X0Y1_FrameStrobe[1] Tile_X0Y0_DSP_top.Inst_DSP_top_ConfigMem.Inst_frame1_bit21.Q
+ VPWR VGND sg13g2_dlhq_1
X_3570_ _1922_ _1835_ _1836_ VPWR VGND sg13g2_xnor2_1
XFILLER_5_260 VPWR VGND sg13g2_fill_2
XFILLER_110_320 VPWR VGND sg13g2_decap_8
XFILLER_102_309 VPWR VGND sg13g2_fill_1
X_5171_ VPWR Tile_X0Y1_DSP_bot.A2 _0897_ VGND sg13g2_inv_1
X_4122_ Tile_X0Y1_DSP_bot.Inst_DSP_bot_ConfigMem.Inst_frame11_bit10.Q Tile_X0Y1_N1END[2]
+ Tile_X0Y1_E1END[2] _0422_ Tile_X0Y1_DSP_bot.Inst_DSP_bot_switch_matrix.Q2 Tile_X0Y1_DSP_bot.Inst_DSP_bot_ConfigMem.Inst_frame11_bit11.Q
+ _2376_ VPWR VGND sg13g2_mux4_1
X_4053_ Tile_X0Y1_DSP_bot.Inst_DSP_bot_ConfigMem.Inst_frame12_bit15.Q Tile_X0Y1_N2END[2]
+ Tile_X0Y1_E6END[1] Tile_X0Y1_N4END[1] Tile_X0Y1_DSP_bot.Inst_DSP_bot_switch_matrix.Q4
+ Tile_X0Y1_DSP_bot.Inst_DSP_bot_ConfigMem.Inst_frame12_bit14.Q Tile_X0Y0_DSP_top.N4BEG_outbuf_8.A
+ VPWR VGND sg13g2_mux4_1
X_3004_ _1381_ _1379_ _1380_ VPWR VGND sg13g2_xnor2_1
X_4955_ _0125_ _0126_ Tile_X0Y1_DSP_bot.Inst_DSP_bot_ConfigMem.Inst_frame1_bit16.Q
+ _0692_ VPWR VGND sg13g2_mux2_1
XFILLER_24_359 VPWR VGND sg13g2_fill_2
X_3768_ Tile_X0Y0_DSP_top.Inst_DSP_top_ConfigMem.Inst_frame4_bit28.Q Tile_X0Y0_DSP_top.Inst_DSP_top_switch_matrix.bot2top0
+ Tile_X0Y0_DSP_top.Inst_DSP_top_switch_matrix.bot2top1 Tile_X0Y0_DSP_top.Inst_DSP_top_switch_matrix.bot2top2
+ Tile_X0Y0_DSP_top.Inst_DSP_top_switch_matrix.bot2top3 Tile_X0Y0_DSP_top.Inst_DSP_top_ConfigMem.Inst_frame4_bit29.Q
+ _2098_ VPWR VGND sg13g2_mux4_1
X_3906_ Tile_X0Y0_DSP_top.Inst_DSP_top_ConfigMem.Inst_frame12_bit30.Q VPWR _2206_
+ VGND _0111_ _1542_ sg13g2_o21ai_1
X_3837_ VGND VPWR Tile_X0Y0_DSP_top.Inst_DSP_top_ConfigMem.Inst_frame1_bit1.Q _2157_
+ _2158_ Tile_X0Y0_DSP_top.Inst_DSP_top_ConfigMem.Inst_frame1_bit2.Q sg13g2_a21oi_1
X_4886_ Tile_X0Y0_DSP_top.Inst_DSP_top_ConfigMem.Inst_frame2_bit14.Q VPWR _0627_ VGND
+ Tile_X0Y0_DSP_top.Inst_DSP_top_ConfigMem.Inst_frame2_bit13.Q _0624_ sg13g2_o21ai_1
X_3699_ Tile_X0Y0_DSP_top.Inst_DSP_top_ConfigMem.Inst_frame1_bit25.Q Tile_X0Y0_DSP_top.Inst_DSP_top_switch_matrix.bot2top4
+ Tile_X0Y0_DSP_top.Inst_DSP_top_switch_matrix.bot2top7 Tile_X0Y0_DSP_top.Inst_DSP_top_switch_matrix.bot2top5
+ Tile_X0Y0_DSP_top.Inst_DSP_top_switch_matrix.bot2top8 Tile_X0Y0_DSP_top.Inst_DSP_top_ConfigMem.Inst_frame1_bit24.Q
+ _2033_ VPWR VGND sg13g2_mux4_1
X_5438_ Tile_X0Y0_FrameData[15] Tile_X0Y1_FrameStrobe[7] Tile_X0Y0_DSP_top.Inst_DSP_top_ConfigMem.Inst_frame7_bit15.Q
+ VPWR VGND sg13g2_dlhq_1
X_5507_ Tile_X0Y0_FrameData[10] Tile_X0Y1_FrameStrobe[9] Tile_X0Y0_DSP_top.Inst_DSP_top_ConfigMem.Inst_frame9_bit10.Q
+ VPWR VGND sg13g2_dlhq_1
X_5369_ Tile_X0Y0_FrameData[20] Tile_X0Y1_FrameStrobe[5] Tile_X0Y0_DSP_top.Inst_DSP_top_ConfigMem.Inst_frame5_bit20.Q
+ VPWR VGND sg13g2_dlhq_1
X_6487_ Tile_X0Y1_W6END[4] Tile_X0Y1_W6BEG[2] VPWR VGND sg13g2_buf_1
X_2719_ VPWR _1103_ _1102_ VGND sg13g2_inv_1
XFILLER_27_131 VPWR VGND sg13g2_fill_1
XFILLER_42_167 VPWR VGND sg13g2_fill_1
XFILLER_35_65 VPWR VGND sg13g2_fill_2
XFILLER_15_359 VPWR VGND sg13g2_fill_2
XFILLER_2_274 VPWR VGND sg13g2_decap_4
XFILLER_92_93 VPWR VGND sg13g2_fill_2
X_3622_ _1961_ Tile_X0Y1_DSP_bot.Inst_MULADD.ACC\[12\] Tile_X0Y1_DSP_bot.Inst_DSP_bot_ConfigMem.Inst_frame12_bit5.Q
+ Tile_X0Y0_DSP_top.Inst_DSP_top_switch_matrix.bot2top2 VPWR VGND sg13g2_mux2_1
X_4671_ Tile_X0Y0_DSP_top.Inst_DSP_top_ConfigMem.Inst_frame10_bit6.Q Tile_X0Y0_DSP_top.Inst_DSP_top_switch_matrix.bot2top6
+ _0387_ Tile_X0Y0_DSP_top.Inst_DSP_top_switch_matrix.E2BEG1 _0407_ Tile_X0Y0_DSP_top.Inst_DSP_top_ConfigMem.Inst_frame10_bit7.Q
+ _0422_ VPWR VGND sg13g2_mux4_1
X_6410_ Tile_X0Y1_FrameData[29] Tile_X0Y1_FrameData_O[29] VPWR VGND sg13g2_buf_1
X_4740_ VGND VPWR _0481_ _0487_ _0488_ _0476_ sg13g2_a21oi_1
Xclkbuf_3_5_0_Tile_X0Y1_UserCLK_regs clknet_0_Tile_X0Y1_UserCLK_regs clknet_3_5_0_Tile_X0Y1_UserCLK_regs
+ VPWR VGND sg13g2_buf_8
X_5223_ Tile_X0Y0_FrameData[6] Tile_X0Y1_FrameStrobe[0] Tile_X0Y0_DSP_top.Inst_DSP_top_ConfigMem.Inst_frame0_bit6.Q
+ VPWR VGND sg13g2_dlhq_1
XFILLER_44_0 VPWR VGND sg13g2_decap_8
X_6272_ Tile_X0Y1_NN4END[12] Tile_X0Y0_NN4BEG[4] VPWR VGND sg13g2_buf_1
X_3484_ VGND VPWR Tile_X0Y1_DSP_bot.Inst_DSP_bot_ConfigMem.Inst_frame0_bit22.Q _0186_
+ _1840_ _1839_ sg13g2_a21oi_1
X_6341_ Tile_X0Y1_DSP_bot.Inst_DSP_bot_switch_matrix.E2BEG4 Tile_X0Y1_E2BEG[4] VPWR
+ VGND sg13g2_buf_1
X_3553_ _1905_ VPWR _1906_ VGND Tile_X0Y1_N2MID[6] Tile_X0Y1_DSP_bot.Inst_DSP_bot_ConfigMem.Inst_frame7_bit16.Q
+ sg13g2_o21ai_1
XFILLER_110_161 VPWR VGND sg13g2_decap_4
X_4036_ _2319_ _2317_ _2318_ _2316_ Tile_X0Y0_DSP_top.Inst_DSP_top_ConfigMem.Inst_frame9_bit19.Q
+ VPWR VGND sg13g2_a22oi_1
X_5085_ _0815_ VPWR _0816_ VGND Tile_X0Y1_DSP_bot.Inst_DSP_bot_ConfigMem.Inst_frame12_bit1.Q
+ Tile_X0Y0_DSP_top.Inst_DSP_top_switch_matrix.inst_cus_mux41_buf_top2bot7.X sg13g2_o21ai_1
X_4105_ _2355_ VPWR Tile_X0Y1_DSP_bot.Inst_DSP_bot_switch_matrix.JS2BEG0 VGND Tile_X0Y1_DSP_bot.Inst_DSP_bot_ConfigMem.Inst_frame2_bit3.Q
+ _2366_ sg13g2_o21ai_1
X_5154_ VGND VPWR Tile_X0Y1_DSP_bot.Inst_DSP_bot_ConfigMem.Inst_frame2_bit5.Q _0879_
+ _0882_ _0881_ sg13g2_a21oi_1
X_4938_ VGND VPWR _0671_ _0674_ _0677_ _0676_ sg13g2_a21oi_1
X_5987_ Tile_X0Y1_FrameData[24] Tile_X0Y1_FrameStrobe[10] Tile_X0Y1_DSP_bot.Inst_DSP_bot_ConfigMem.Inst_frame10_bit24.Q
+ VPWR VGND sg13g2_dlhq_1
XANTENNA_41 VPWR VGND Tile_X0Y1_N4END[13] sg13g2_antennanp
XANTENNA_52 VPWR VGND Tile_X0Y1_NN4END[7] sg13g2_antennanp
XANTENNA_85 VPWR VGND Tile_X0Y0_S2MID[4] sg13g2_antennanp
XANTENNA_74 VPWR VGND Tile_X0Y0_FrameData[6] sg13g2_antennanp
X_4869_ VPWR _0610_ _0609_ VGND sg13g2_inv_1
XANTENNA_63 VPWR VGND Tile_X0Y0_FrameData[6] sg13g2_antennanp
XANTENNA_96 VPWR VGND Tile_X0Y0_S2MID[4] sg13g2_antennanp
XANTENNA_30 VPWR VGND Tile_X0Y1_EE4END[9] sg13g2_antennanp
XFILLER_47_248 VPWR VGND sg13g2_decap_8
XFILLER_15_145 VPWR VGND sg13g2_fill_1
XFILLER_109_261 VPWR VGND sg13g2_fill_2
XFILLER_61_284 VPWR VGND sg13g2_fill_1
X_2984_ _1361_ _1358_ _1360_ VPWR VGND sg13g2_xnor2_1
X_5841_ Tile_X0Y1_FrameData[10] Tile_X0Y1_FrameStrobe[5] Tile_X0Y1_DSP_bot.Inst_DSP_bot_ConfigMem.Inst_frame5_bit10.Q
+ VPWR VGND sg13g2_dlhq_1
X_5772_ Tile_X0Y1_FrameData[15] Tile_X0Y1_FrameStrobe[3] Tile_X0Y1_DSP_bot.Inst_DSP_bot_ConfigMem.Inst_frame3_bit15.Q
+ VPWR VGND sg13g2_dlhq_1
X_5910_ Tile_X0Y1_FrameData[5] Tile_X0Y1_FrameStrobe[7] Tile_X0Y1_DSP_bot.Inst_DSP_bot_ConfigMem.Inst_frame7_bit5.Q
+ VPWR VGND sg13g2_dlhq_1
X_4654_ _0397_ _0396_ _0404_ _0406_ VPWR VGND sg13g2_a21o_1
X_4585_ VGND VPWR Tile_X0Y0_DSP_top.Inst_DSP_top_ConfigMem.Inst_frame4_bit4.Q Tile_X0Y0_DSP_top.Inst_DSP_top_switch_matrix.bot2top2
+ _0339_ _0338_ sg13g2_a21oi_1
X_4723_ Tile_X0Y1_DSP_bot.Inst_DSP_bot_ConfigMem.Inst_frame4_bit29.Q VPWR _0471_ VGND
+ Tile_X0Y1_DSP_bot.Inst_DSP_bot_ConfigMem.Inst_frame4_bit28.Q Tile_X0Y1_W1END[0]
+ sg13g2_o21ai_1
X_3605_ _1951_ Tile_X0Y1_DSP_bot.Inst_MULADD.ACC\[5\] Tile_X0Y1_DSP_bot.Inst_DSP_bot_ConfigMem.Inst_frame12_bit5.Q
+ Tile_X0Y1_DSP_bot.Inst_DSP_bot_switch_matrix.Q5 VPWR VGND sg13g2_mux2_1
X_6255_ Tile_X0Y1_N4END[11] Tile_X0Y0_N4BEG[3] VPWR VGND sg13g2_buf_1
X_6186_ Tile_X0Y0_FrameData[6] Tile_X0Y0_FrameData_O[6] VPWR VGND sg13g2_buf_1
X_6324_ Tile_X0Y0_WW4END[11] Tile_X0Y0_WW4BEG[7] VPWR VGND sg13g2_buf_1
X_5206_ Tile_X0Y0_FrameData[23] Tile_X0Y1_FrameStrobe[0] Tile_X0Y0_DSP_top.Inst_DSP_top_ConfigMem.Inst_frame0_bit23.Q
+ VPWR VGND sg13g2_dlhq_1
X_3398_ _1350_ VPWR _1758_ VGND _1373_ _1427_ sg13g2_o21ai_1
X_3467_ Tile_X0Y1_DSP_bot.Inst_DSP_bot_ConfigMem.Inst_frame0_bit25.Q VPWR _1824_ VGND
+ Tile_X0Y0_S4END[7] Tile_X0Y1_DSP_bot.Inst_DSP_bot_ConfigMem.Inst_frame0_bit24.Q
+ sg13g2_o21ai_1
X_3536_ VGND VPWR Tile_X0Y1_DSP_bot.Inst_DSP_bot_ConfigMem.Inst_frame8_bit9.Q _1879_
+ Tile_X0Y1_DSP_bot.C1 _1889_ sg13g2_a21oi_1
X_5068_ _0796_ VPWR Tile_X0Y0_DSP_top.Inst_DSP_top_switch_matrix.JW2BEG2 VGND Tile_X0Y0_DSP_top.Inst_DSP_top_ConfigMem.Inst_frame1_bit11.Q
+ _0800_ sg13g2_o21ai_1
X_4019_ VGND VPWR Tile_X0Y0_DSP_top.Inst_DSP_top_ConfigMem.Inst_frame9_bit13.Q _2303_
+ _2304_ Tile_X0Y0_DSP_top.Inst_DSP_top_ConfigMem.Inst_frame9_bit14.Q sg13g2_a21oi_1
X_5137_ _0866_ _0863_ _0865_ VPWR VGND sg13g2_nand2_1
XFILLER_16_78 VPWR VGND sg13g2_decap_4
XFILLER_94_129 VPWR VGND sg13g2_fill_1
XFILLER_43_295 VPWR VGND sg13g2_fill_2
X_4370_ VPWR _0133_ Tile_X0Y0_DSP_top.Inst_DSP_top_switch_matrix.bot2top1 VGND sg13g2_inv_1
X_3252_ _1620_ Tile_X0Y1_DSP_bot.Inst_DSP_bot_ConfigMem.Inst_frame1_bit20.Q _0126_
+ VPWR VGND sg13g2_nand2_1
X_3321_ VPWR VGND Tile_X0Y1_DSP_bot.Inst_DSP_bot_ConfigMem.Inst_frame8_bit27.Q Tile_X0Y1_DSP_bot.Inst_DSP_bot_ConfigMem.Inst_frame8_bit26.Q
+ _1685_ _1656_ _1686_ _1657_ sg13g2_a221oi_1
X_6040_ Tile_X0Y1_FrameData[3] Tile_X0Y1_FrameStrobe[11] Tile_X0Y1_DSP_bot.Inst_DSP_bot_ConfigMem.Inst_frame11_bit3.Q
+ VPWR VGND sg13g2_dlhq_1
X_3183_ _1519_ VPWR _1555_ VGND Tile_X0Y1_DSP_bot.Inst_DSP_bot_ConfigMem.Inst_frame12_bit3.Q
+ _1554_ sg13g2_o21ai_1
X_2967_ _1342_ _1343_ _1344_ VPWR VGND sg13g2_nor2_1
X_5755_ Tile_X0Y1_FrameData[0] Tile_X0Y1_FrameStrobe[2] Tile_X0Y1_DSP_bot.Inst_DSP_bot_ConfigMem.Inst_frame2_bit0.Q
+ VPWR VGND sg13g2_dlhq_1
X_5824_ Tile_X0Y1_FrameData[27] Tile_X0Y1_FrameStrobe[5] Tile_X0Y1_DSP_bot.Inst_DSP_bot_ConfigMem.Inst_frame5_bit27.Q
+ VPWR VGND sg13g2_dlhq_1
X_4637_ Tile_X0Y0_DSP_top.Inst_DSP_top_ConfigMem.Inst_frame1_bit16.Q Tile_X0Y0_DSP_top.Inst_DSP_top_switch_matrix.bot2top0
+ Tile_X0Y0_DSP_top.Inst_DSP_top_switch_matrix.bot2top1 Tile_X0Y0_DSP_top.Inst_DSP_top_switch_matrix.bot2top2
+ Tile_X0Y0_DSP_top.Inst_DSP_top_switch_matrix.bot2top3 Tile_X0Y0_DSP_top.Inst_DSP_top_ConfigMem.Inst_frame1_bit17.Q
+ _0389_ VPWR VGND sg13g2_mux4_1
X_4568_ VGND VPWR Tile_X0Y0_DSP_top.Inst_DSP_top_ConfigMem.Inst_frame3_bit8.Q _0132_
+ _0323_ _0322_ sg13g2_a21oi_1
X_4706_ Tile_X0Y0_DSP_top.Inst_DSP_top_ConfigMem.Inst_frame3_bit12.Q Tile_X0Y0_DSP_top.Inst_DSP_top_switch_matrix.bot2top0
+ _0455_ VPWR VGND sg13g2_nor2_1
X_2898_ _0533_ _0900_ _1276_ VPWR VGND sg13g2_nor2_1
X_5686_ Tile_X0Y1_FrameData[5] Tile_X0Y1_FrameStrobe[0] Tile_X0Y1_DSP_bot.Inst_DSP_bot_ConfigMem.Inst_frame0_bit5.Q
+ VPWR VGND sg13g2_dlhq_1
X_6238_ Tile_X0Y0_DSP_top.Inst_DSP_top_switch_matrix.JN2BEG2 Tile_X0Y0_N2BEG[2] VPWR
+ VGND sg13g2_buf_1
X_4499_ VPWR _0257_ _0256_ VGND sg13g2_inv_1
X_6169_ Tile_X0Y0_EE4END[9] Tile_X0Y0_EE4BEG[5] VPWR VGND sg13g2_buf_1
X_6307_ Tile_X0Y0_W6END[4] Tile_X0Y0_W6BEG[2] VPWR VGND sg13g2_buf_1
X_3519_ _1418_ _1405_ _1416_ _1873_ VPWR VGND sg13g2_a21o_1
XFILLER_43_76 VPWR VGND sg13g2_fill_2
XFILLER_4_100 VPWR VGND sg13g2_fill_2
X_3870_ VGND VPWR Tile_X0Y0_DSP_top.Inst_DSP_top_ConfigMem.Inst_frame4_bit0.Q Tile_X0Y0_DSP_top.Inst_DSP_top_switch_matrix.bot2top6
+ _2183_ _2182_ sg13g2_a21oi_1
X_2821_ _1197_ _1200_ _1201_ VPWR VGND sg13g2_nor2_1
XFILLER_16_240 VPWR VGND sg13g2_fill_1
XFILLER_16_295 VPWR VGND sg13g2_decap_4
X_5540_ Tile_X0Y0_FrameData[9] Tile_X0Y1_FrameStrobe[10] Tile_X0Y0_DSP_top.Inst_DSP_top_ConfigMem.Inst_frame10_bit9.Q
+ VPWR VGND sg13g2_dlhq_1
X_5471_ Tile_X0Y0_FrameData[14] Tile_X0Y1_FrameStrobe[8] Tile_X0Y0_DSP_top.Inst_DSP_top_ConfigMem.Inst_frame8_bit14.Q
+ VPWR VGND sg13g2_dlhq_1
X_2752_ VPWR _1134_ _1133_ VGND sg13g2_inv_1
X_4422_ _0182_ VPWR _0183_ VGND Tile_X0Y1_DSP_bot.Inst_DSP_bot_ConfigMem.Inst_frame1_bit13.Q
+ _0181_ sg13g2_o21ai_1
X_2683_ VGND VPWR Tile_X0Y1_DSP_bot.Inst_DSP_bot_ConfigMem.Inst_frame7_bit2.Q Tile_X0Y1_DSP_bot.Inst_DSP_bot_switch_matrix.E2BEG3
+ _1069_ _1068_ sg13g2_a21oi_1
X_4284_ VPWR _0047_ Tile_X0Y0_S1END[3] VGND sg13g2_inv_1
XFILLER_100_237 VPWR VGND sg13g2_fill_1
X_4353_ VPWR _0116_ Tile_X0Y0_DSP_top.Inst_DSP_top_ConfigMem.Inst_frame8_bit29.Q VGND
+ sg13g2_inv_1
X_3304_ VPWR Tile_X0Y1_DSP_bot.Inst_DSP_bot_switch_matrix.JS2BEG7 _1670_ VGND sg13g2_inv_1
X_6023_ Tile_X0Y1_FrameData[20] Tile_X0Y1_FrameStrobe[11] Tile_X0Y1_DSP_bot.Inst_DSP_bot_ConfigMem.Inst_frame11_bit20.Q
+ VPWR VGND sg13g2_dlhq_1
X_3235_ _1603_ Tile_X0Y1_DSP_bot.Inst_DSP_bot_ConfigMem.Inst_frame3_bit30.Q _1604_
+ VPWR VGND sg13g2_nor2b_1
X_3097_ _1474_ Tile_X0Y0_S1END[2] Tile_X0Y0_DSP_top.Inst_DSP_top_ConfigMem.Inst_frame1_bit20.Q
+ VPWR VGND sg13g2_nand2_1
X_3166_ VGND VPWR Tile_X0Y0_DSP_top.Inst_DSP_top_ConfigMem.Inst_frame0_bit18.Q _0464_
+ _1539_ _1538_ sg13g2_a21oi_1
X_3999_ Tile_X0Y0_W1END[2] Tile_X0Y0_DSP_top.Inst_DSP_top_switch_matrix.bot2top2 Tile_X0Y0_DSP_top.Inst_DSP_top_ConfigMem.Inst_frame9_bit6.Q
+ _2286_ VPWR VGND sg13g2_mux2_1
X_5738_ Tile_X0Y1_FrameData[17] Tile_X0Y1_FrameStrobe[2] Tile_X0Y1_DSP_bot.Inst_DSP_bot_ConfigMem.Inst_frame2_bit17.Q
+ VPWR VGND sg13g2_dlhq_1
X_5807_ Tile_X0Y1_FrameData[12] Tile_X0Y1_FrameStrobe[4] Tile_X0Y1_DSP_bot.Inst_DSP_bot_ConfigMem.Inst_frame4_bit12.Q
+ VPWR VGND sg13g2_dlhq_1
XFILLER_22_265 VPWR VGND sg13g2_fill_2
XFILLER_108_359 VPWR VGND sg13g2_fill_2
XFILLER_108_337 VPWR VGND sg13g2_decap_8
XFILLER_89_17 VPWR VGND sg13g2_fill_1
XFILLER_1_136 VPWR VGND sg13g2_fill_1
X_5669_ Tile_X0Y1_FrameData[22] Tile_X0Y1_FrameStrobe[0] Tile_X0Y1_DSP_bot.Inst_DSP_bot_ConfigMem.Inst_frame0_bit22.Q
+ VPWR VGND sg13g2_dlhq_1
XFILLER_72_176 VPWR VGND sg13g2_decap_4
XFILLER_9_258 VPWR VGND sg13g2_decap_4
XFILLER_79_94 VPWR VGND sg13g2_decap_8
X_4971_ Tile_X0Y0_DSP_top.Inst_DSP_top_ConfigMem.Inst_frame2_bit0.Q Tile_X0Y0_DSP_top.Inst_DSP_top_switch_matrix.bot2top5
+ _0708_ VPWR VGND sg13g2_nor2b_1
XFILLER_63_187 VPWR VGND sg13g2_fill_1
XFILLER_51_327 VPWR VGND sg13g2_fill_2
X_3020_ _1397_ _1394_ _1395_ VPWR VGND sg13g2_xnor2_1
X_3784_ Tile_X0Y0_DSP_top.Inst_DSP_top_ConfigMem.Inst_frame3_bit30.Q _2112_ _2113_
+ VPWR VGND sg13g2_nor2b_1
X_3853_ Tile_X0Y0_DSP_top.Inst_DSP_top_ConfigMem.Inst_frame1_bit0.Q Tile_X0Y0_DSP_top.Inst_DSP_top_switch_matrix.bot2top5
+ _2174_ VPWR VGND sg13g2_nor2b_1
X_3922_ Tile_X0Y0_DSP_top.Inst_DSP_top_switch_matrix.NN4BEG2 _2217_ _2220_ _2214_
+ _2212_ VPWR VGND sg13g2_a22oi_1
X_2804_ Tile_X0Y1_DSP_bot.Inst_DSP_bot_ConfigMem.Inst_frame5_bit0.Q Tile_X0Y1_N2END[6]
+ Tile_X0Y1_E2END[6] Tile_X0Y0_SS4END[7] Tile_X0Y1_W2END[6] Tile_X0Y1_DSP_bot.Inst_DSP_bot_ConfigMem.Inst_frame5_bit1.Q
+ _1185_ VPWR VGND sg13g2_mux4_1
X_5454_ Tile_X0Y0_FrameData[31] Tile_X0Y1_FrameStrobe[8] Tile_X0Y0_DSP_top.Inst_DSP_top_ConfigMem.Inst_frame8_bit31.Q
+ VPWR VGND sg13g2_dlhq_1
X_5385_ Tile_X0Y0_FrameData[4] Tile_X0Y1_FrameStrobe[5] Tile_X0Y0_DSP_top.Inst_DSP_top_ConfigMem.Inst_frame5_bit4.Q
+ VPWR VGND sg13g2_dlhq_1
X_5523_ Tile_X0Y0_FrameData[26] Tile_X0Y1_FrameStrobe[10] Tile_X0Y0_DSP_top.Inst_DSP_top_ConfigMem.Inst_frame10_bit26.Q
+ VPWR VGND sg13g2_dlhq_1
X_2597_ _0985_ VPWR _0986_ VGND Tile_X0Y0_EE4END[2] Tile_X0Y0_DSP_top.Inst_DSP_top_ConfigMem.Inst_frame0_bit2.Q
+ sg13g2_o21ai_1
X_4336_ VPWR _0099_ Tile_X0Y1_DSP_bot.Inst_DSP_bot_ConfigMem.Inst_frame1_bit25.Q VGND
+ sg13g2_inv_1
X_2735_ VGND VPWR _1113_ _1116_ _1119_ _1118_ sg13g2_a21oi_1
X_2666_ VGND VPWR Tile_X0Y1_DSP_bot.Inst_DSP_bot_ConfigMem.Inst_frame3_bit4.Q _0130_
+ _1053_ _1052_ sg13g2_a21oi_1
X_4405_ VGND VPWR Tile_X0Y1_DSP_bot.Inst_DSP_bot_ConfigMem.Inst_frame3_bit9.Q _0164_
+ _0167_ _0029_ sg13g2_a21oi_1
X_3149_ _1522_ VPWR _1523_ VGND Tile_X0Y0_DSP_top.Inst_DSP_top_ConfigMem.Inst_frame3_bit22.Q
+ _1521_ sg13g2_o21ai_1
X_3218_ Tile_X0Y1_DSP_bot.Inst_DSP_bot_ConfigMem.Inst_frame3_bit20.Q Tile_X0Y1_DSP_bot.Inst_DSP_bot_switch_matrix.Q0
+ Tile_X0Y1_DSP_bot.Inst_DSP_bot_switch_matrix.Q1 Tile_X0Y1_DSP_bot.Inst_DSP_bot_switch_matrix.Q2
+ Tile_X0Y1_DSP_bot.Inst_DSP_bot_switch_matrix.Q3 Tile_X0Y1_DSP_bot.Inst_DSP_bot_ConfigMem.Inst_frame3_bit21.Q
+ _1588_ VPWR VGND sg13g2_mux4_1
XFILLER_39_151 VPWR VGND sg13g2_fill_2
X_4267_ VPWR _0030_ Tile_X0Y1_DSP_bot.Inst_DSP_bot_ConfigMem.Inst_frame3_bit11.Q VGND
+ sg13g2_inv_1
X_6006_ Tile_X0Y1_FrameData[5] Tile_X0Y1_FrameStrobe[10] Tile_X0Y1_DSP_bot.Inst_DSP_bot_ConfigMem.Inst_frame10_bit5.Q
+ VPWR VGND sg13g2_dlhq_1
X_4198_ _2438_ VPWR _2439_ VGND Tile_X0Y1_DSP_bot.Inst_DSP_bot_ConfigMem.Inst_frame9_bit11.Q
+ Tile_X0Y1_DSP_bot.Inst_DSP_bot_switch_matrix.Q9 sg13g2_o21ai_1
XFILLER_91_18 VPWR VGND sg13g2_fill_2
XFILLER_24_34 VPWR VGND sg13g2_fill_2
XFILLER_27_346 VPWR VGND sg13g2_fill_1
XFILLER_10_235 VPWR VGND sg13g2_fill_2
XFILLER_65_85 VPWR VGND sg13g2_fill_2
XANTENNA_131 VPWR VGND Tile_X0Y0_S4END[6] sg13g2_antennanp
XANTENNA_142 VPWR VGND Tile_X0Y0_S4END[6] sg13g2_antennanp
XANTENNA_120 VPWR VGND Tile_X0Y0_S2MID[4] sg13g2_antennanp
X_4052_ Tile_X0Y0_DSP_top.Inst_DSP_top_ConfigMem.Inst_frame12_bit10.Q Tile_X0Y0_DSP_top.Inst_DSP_top_switch_matrix.bot2top2
+ _0465_ _0568_ _0447_ Tile_X0Y0_DSP_top.Inst_DSP_top_ConfigMem.Inst_frame12_bit11.Q
+ Tile_X0Y0_DSP_top.Inst_DSP_top_switch_matrix.N1BEG0 VPWR VGND sg13g2_mux4_1
XFILLER_68_279 VPWR VGND sg13g2_fill_2
X_3003_ VGND VPWR _0967_ _0968_ _1380_ _1308_ sg13g2_a21oi_1
X_4121_ Tile_X0Y1_DSP_bot.Inst_DSP_bot_ConfigMem.Inst_frame11_bit10.Q Tile_X0Y1_DSP_bot.Inst_DSP_bot_switch_matrix.Q6
+ _1019_ _1256_ _1830_ Tile_X0Y1_DSP_bot.Inst_DSP_bot_ConfigMem.Inst_frame11_bit11.Q
+ _2375_ VPWR VGND sg13g2_mux4_1
X_5170_ _0897_ _0877_ _0896_ VPWR VGND sg13g2_nand2_1
XFILLER_101_17 VPWR VGND sg13g2_fill_2
X_3905_ Tile_X0Y0_DSP_top.Inst_DSP_top_ConfigMem.Inst_frame12_bit29.Q _0860_ _2205_
+ VPWR VGND sg13g2_nor2_1
XFILLER_51_102 VPWR VGND sg13g2_decap_8
X_4954_ Tile_X0Y1_DSP_bot.Inst_DSP_bot_ConfigMem.Inst_frame1_bit19.Q _0690_ _0691_
+ VPWR VGND sg13g2_nor2_1
X_3767_ Tile_X0Y0_DSP_top.Inst_DSP_top_ConfigMem.Inst_frame8_bit29.Q Tile_X0Y0_DSP_top.Inst_DSP_top_switch_matrix.JS2BEG5
+ Tile_X0Y0_DSP_top.Inst_DSP_top_switch_matrix.JS2BEG7 Tile_X0Y0_DSP_top.Inst_DSP_top_switch_matrix.JW2BEG5
+ _2096_ Tile_X0Y0_DSP_top.Inst_DSP_top_ConfigMem.Inst_frame8_bit30.Q _2097_ VPWR
+ VGND sg13g2_mux4_1
X_3836_ Tile_X0Y0_E2END[1] Tile_X0Y0_E6END[1] Tile_X0Y0_DSP_top.Inst_DSP_top_ConfigMem.Inst_frame1_bit0.Q
+ _2157_ VPWR VGND sg13g2_mux2_1
X_5506_ Tile_X0Y0_FrameData[11] Tile_X0Y1_FrameStrobe[9] Tile_X0Y0_DSP_top.Inst_DSP_top_ConfigMem.Inst_frame9_bit11.Q
+ VPWR VGND sg13g2_dlhq_1
X_4885_ VGND VPWR Tile_X0Y0_DSP_top.Inst_DSP_top_ConfigMem.Inst_frame2_bit12.Q Tile_X0Y0_DSP_top.Inst_DSP_top_switch_matrix.bot2top8
+ _0626_ _0625_ sg13g2_a21oi_1
X_2718_ Tile_X0Y1_DSP_bot.Inst_DSP_bot_ConfigMem.Inst_frame5_bit12.Q Tile_X0Y1_N2END[4]
+ Tile_X0Y1_E2END[4] Tile_X0Y0_SS4END[6] Tile_X0Y1_W2END[4] Tile_X0Y1_DSP_bot.Inst_DSP_bot_ConfigMem.Inst_frame5_bit13.Q
+ _1102_ VPWR VGND sg13g2_mux4_1
XFILLER_105_137 VPWR VGND sg13g2_fill_1
X_3698_ VPWR _2032_ _2031_ VGND sg13g2_inv_1
X_5299_ Tile_X0Y0_FrameData[26] Tile_X0Y1_FrameStrobe[3] Tile_X0Y0_DSP_top.Inst_DSP_top_ConfigMem.Inst_frame3_bit26.Q
+ VPWR VGND sg13g2_dlhq_1
X_5437_ Tile_X0Y0_FrameData[16] Tile_X0Y1_FrameStrobe[7] Tile_X0Y0_DSP_top.Inst_DSP_top_ConfigMem.Inst_frame7_bit16.Q
+ VPWR VGND sg13g2_dlhq_1
X_5368_ Tile_X0Y0_FrameData[21] Tile_X0Y1_FrameStrobe[5] Tile_X0Y0_DSP_top.Inst_DSP_top_ConfigMem.Inst_frame5_bit21.Q
+ VPWR VGND sg13g2_dlhq_1
X_4319_ VPWR _0082_ Tile_X0Y1_DSP_bot.Inst_DSP_bot_ConfigMem.Inst_frame3_bit6.Q VGND
+ sg13g2_inv_1
X_2649_ VGND VPWR Tile_X0Y1_DSP_bot.Inst_DSP_bot_ConfigMem.Inst_frame3_bit13.Q _1036_
+ _1037_ _0079_ sg13g2_a21oi_1
X_6486_ Tile_X0Y1_W6END[3] Tile_X0Y1_W6BEG[1] VPWR VGND sg13g2_buf_1
XFILLER_42_102 VPWR VGND sg13g2_fill_2
XFILLER_15_316 VPWR VGND sg13g2_fill_1
XFILLER_19_89 VPWR VGND sg13g2_decap_4
XFILLER_35_88 VPWR VGND sg13g2_fill_1
XFILLER_30_319 VPWR VGND sg13g2_fill_2
XFILLER_4_0 VPWR VGND sg13g2_fill_2
XFILLER_76_84 VPWR VGND sg13g2_fill_1
XFILLER_80_219 VPWR VGND sg13g2_fill_1
XFILLER_18_121 VPWR VGND sg13g2_fill_1
X_3621_ _1937_ _1936_ _1961_ VPWR VGND sg13g2_xor2_1
X_4670_ VGND VPWR _0409_ _0414_ Tile_X0Y0_DSP_top.Inst_DSP_top_switch_matrix.E2BEG1
+ _0421_ sg13g2_a21oi_1
X_6340_ Tile_X0Y1_DSP_bot.Inst_DSP_bot_switch_matrix.E2BEG3 Tile_X0Y1_E2BEG[3] VPWR
+ VGND sg13g2_buf_1
X_3552_ _1905_ Tile_X0Y1_DSP_bot.Inst_DSP_bot_ConfigMem.Inst_frame7_bit16.Q Tile_X0Y1_E2MID[6]
+ VPWR VGND sg13g2_nand2b_1
X_5222_ Tile_X0Y0_FrameData[7] Tile_X0Y1_FrameStrobe[0] Tile_X0Y0_DSP_top.Inst_DSP_top_ConfigMem.Inst_frame0_bit7.Q
+ VPWR VGND sg13g2_dlhq_1
X_6271_ Tile_X0Y1_NN4END[11] Tile_X0Y0_NN4BEG[3] VPWR VGND sg13g2_buf_1
X_5153_ Tile_X0Y1_DSP_bot.Inst_DSP_bot_ConfigMem.Inst_frame2_bit6.Q VPWR _0881_ VGND
+ Tile_X0Y1_DSP_bot.Inst_DSP_bot_ConfigMem.Inst_frame2_bit5.Q _0880_ sg13g2_o21ai_1
X_3483_ Tile_X0Y1_DSP_bot.Inst_DSP_bot_ConfigMem.Inst_frame0_bit23.Q VPWR _1839_ VGND
+ Tile_X0Y1_WW4END[1] Tile_X0Y1_DSP_bot.Inst_DSP_bot_ConfigMem.Inst_frame0_bit22.Q
+ sg13g2_o21ai_1
X_4035_ VGND VPWR Tile_X0Y0_DSP_top.Inst_DSP_top_ConfigMem.Inst_frame9_bit18.Q _0937_
+ _2318_ Tile_X0Y0_DSP_top.Inst_DSP_top_ConfigMem.Inst_frame9_bit19.Q sg13g2_a21oi_1
X_5084_ _0815_ Tile_X0Y1_DSP_bot.Inst_DSP_bot_ConfigMem.Inst_frame12_bit1.Q Tile_X0Y1_DSP_bot.Inst_MULADD.B_reg\[7\]
+ VPWR VGND sg13g2_nand2b_1
X_4104_ _2360_ VPWR _2366_ VGND _2362_ _2365_ sg13g2_o21ai_1
XANTENNA_31 VPWR VGND Tile_X0Y1_FrameStrobe[13] sg13g2_antennanp
X_4868_ _0533_ _0608_ _0609_ VPWR VGND sg13g2_nor2_1
X_4937_ _0057_ VPWR _0676_ VGND Tile_X0Y1_DSP_bot.Inst_DSP_bot_ConfigMem.Inst_frame4_bit18.Q
+ _0675_ sg13g2_o21ai_1
XFILLER_12_319 VPWR VGND sg13g2_fill_2
X_5986_ Tile_X0Y1_FrameData[25] Tile_X0Y1_FrameStrobe[10] Tile_X0Y1_DSP_bot.Inst_DSP_bot_ConfigMem.Inst_frame10_bit25.Q
+ VPWR VGND sg13g2_dlhq_1
XANTENNA_20 VPWR VGND Tile_X0Y1_E6END[5] sg13g2_antennanp
XANTENNA_42 VPWR VGND Tile_X0Y1_N4END[14] sg13g2_antennanp
X_3819_ Tile_X0Y0_DSP_top.Inst_DSP_top_ConfigMem.Inst_frame2_bit21.Q VPWR _2141_ VGND
+ Tile_X0Y0_DSP_top.Inst_DSP_top_ConfigMem.Inst_frame2_bit20.Q _0129_ sg13g2_o21ai_1
XANTENNA_53 VPWR VGND Tile_X0Y1_NN4END[7] sg13g2_antennanp
XANTENNA_97 VPWR VGND Tile_X0Y0_S2MID[4] sg13g2_antennanp
XANTENNA_86 VPWR VGND Tile_X0Y0_S2MID[4] sg13g2_antennanp
XANTENNA_75 VPWR VGND Tile_X0Y0_FrameData[6] sg13g2_antennanp
XANTENNA_64 VPWR VGND Tile_X0Y0_FrameData[6] sg13g2_antennanp
X_4799_ Tile_X0Y1_DSP_bot.Inst_DSP_bot_ConfigMem.Inst_frame4_bit0.Q Tile_X0Y1_N2END[1]
+ Tile_X0Y1_N4END[1] Tile_X0Y1_E1END[3] Tile_X0Y1_E2END[1] Tile_X0Y1_DSP_bot.Inst_DSP_bot_ConfigMem.Inst_frame4_bit1.Q
+ _0543_ VPWR VGND sg13g2_mux4_1
X_6469_ Tile_X0Y1_W2END[0] Tile_X0Y1_W2BEG[0] VPWR VGND sg13g2_buf_1
XFILLER_21_68 VPWR VGND sg13g2_fill_1
XFILLER_46_54 VPWR VGND sg13g2_fill_1
XFILLER_109_273 VPWR VGND sg13g2_fill_1
XFILLER_87_61 VPWR VGND sg13g2_fill_1
X_2983_ VPWR _1360_ _1359_ VGND sg13g2_inv_1
X_5771_ Tile_X0Y1_FrameData[16] Tile_X0Y1_FrameStrobe[3] Tile_X0Y1_DSP_bot.Inst_DSP_bot_ConfigMem.Inst_frame3_bit16.Q
+ VPWR VGND sg13g2_dlhq_1
X_4722_ Tile_X0Y1_W1END[2] Tile_X0Y1_DSP_bot.Inst_DSP_bot_ConfigMem.Inst_frame4_bit28.Q
+ _0470_ VPWR VGND sg13g2_nor2b_1
X_5840_ Tile_X0Y1_FrameData[11] Tile_X0Y1_FrameStrobe[5] Tile_X0Y1_DSP_bot.Inst_DSP_bot_ConfigMem.Inst_frame5_bit11.Q
+ VPWR VGND sg13g2_dlhq_1
X_4653_ VGND VPWR _0396_ _0397_ _0405_ _0404_ sg13g2_a21oi_1
X_4584_ Tile_X0Y0_DSP_top.Inst_DSP_top_ConfigMem.Inst_frame4_bit4.Q Tile_X0Y0_DSP_top.Inst_DSP_top_switch_matrix.bot2top0
+ _0338_ VPWR VGND sg13g2_nor2b_1
X_6323_ Tile_X0Y0_WW4END[10] Tile_X0Y0_WW4BEG[6] VPWR VGND sg13g2_buf_1
X_3604_ _1951_ _1923_ _1925_ VPWR VGND sg13g2_xnor2_1
X_3535_ VPWR _1889_ _1888_ VGND sg13g2_inv_1
X_6254_ Tile_X0Y1_N4END[10] Tile_X0Y0_N4BEG[2] VPWR VGND sg13g2_buf_1
X_6185_ Tile_X0Y0_FrameData[5] Tile_X0Y0_FrameData_O[5] VPWR VGND sg13g2_buf_1
X_5205_ Tile_X0Y0_FrameData[24] Tile_X0Y1_FrameStrobe[0] Tile_X0Y0_DSP_top.Inst_DSP_top_ConfigMem.Inst_frame0_bit24.Q
+ VPWR VGND sg13g2_dlhq_1
XFILLER_84_300 VPWR VGND sg13g2_decap_4
X_5136_ Tile_X0Y0_DSP_top.Inst_DSP_top_ConfigMem.Inst_frame6_bit12.Q Tile_X0Y0_W2MID[5]
+ _0864_ _0865_ VPWR VGND sg13g2_a21o_1
X_3397_ _1757_ _1755_ _1756_ Tile_X0Y1_DSP_bot.Inst_MULADD.ACC\[8\] Tile_X0Y1_DSP_bot.Inst_DSP_bot_ConfigMem.Inst_frame12_bit3.Q
+ VPWR VGND sg13g2_a22oi_1
X_3466_ Tile_X0Y1_DSP_bot.Inst_DSP_bot_ConfigMem.Inst_frame8_bit15.Q _1816_ _1822_
+ _1823_ VPWR VGND sg13g2_nor3_1
X_5067_ VGND VPWR Tile_X0Y0_DSP_top.Inst_DSP_top_ConfigMem.Inst_frame1_bit10.Q _0797_
+ _0800_ _0799_ sg13g2_a21oi_1
X_4018_ Tile_X0Y0_W1END[0] Tile_X0Y0_DSP_top.Inst_DSP_top_switch_matrix.bot2top4 Tile_X0Y0_DSP_top.Inst_DSP_top_ConfigMem.Inst_frame9_bit12.Q
+ _2303_ VPWR VGND sg13g2_mux2_1
X_5969_ Tile_X0Y1_FrameData[10] Tile_X0Y1_FrameStrobe[9] Tile_X0Y1_DSP_bot.Inst_DSP_bot_ConfigMem.Inst_frame9_bit10.Q
+ VPWR VGND sg13g2_dlhq_1
XFILLER_79_127 VPWR VGND sg13g2_fill_1
XFILLER_90_336 VPWR VGND sg13g2_fill_1
XFILLER_7_164 VPWR VGND sg13g2_fill_2
XFILLER_98_82 VPWR VGND sg13g2_fill_1
X_3182_ VGND VPWR _0072_ Tile_X0Y0_DSP_top.Inst_DSP_top_switch_matrix.inst_cus_mux41_buf_top2bot9.X
+ _1554_ _1553_ sg13g2_a21oi_1
X_3251_ Tile_X0Y1_DSP_bot.Inst_DSP_bot_ConfigMem.Inst_frame1_bit23.Q _1616_ _1618_
+ _1619_ VPWR VGND sg13g2_nor3_1
X_3320_ VGND VPWR Tile_X0Y1_DSP_bot.Inst_DSP_bot_ConfigMem.Inst_frame8_bit25.Q _1670_
+ _1685_ _1684_ sg13g2_a21oi_1
XFILLER_78_193 VPWR VGND sg13g2_fill_1
X_4705_ _0453_ VPWR _0454_ VGND Tile_X0Y0_DSP_top.Inst_DSP_top_ConfigMem.Inst_frame3_bit12.Q
+ Tile_X0Y0_DSP_top.Inst_DSP_top_switch_matrix.bot2top2 sg13g2_o21ai_1
X_2966_ _1313_ _1312_ _1343_ VPWR VGND sg13g2_xor2_1
X_2897_ _0739_ _0740_ _0900_ _1275_ VPWR VGND sg13g2_nor3_1
X_5754_ Tile_X0Y1_FrameData[1] Tile_X0Y1_FrameStrobe[2] Tile_X0Y1_DSP_bot.Inst_DSP_bot_ConfigMem.Inst_frame2_bit1.Q
+ VPWR VGND sg13g2_dlhq_1
X_5823_ Tile_X0Y1_FrameData[28] Tile_X0Y1_FrameStrobe[5] Tile_X0Y1_DSP_bot.Inst_DSP_bot_ConfigMem.Inst_frame5_bit28.Q
+ VPWR VGND sg13g2_dlhq_1
X_5685_ Tile_X0Y1_FrameData[6] Tile_X0Y1_FrameStrobe[0] Tile_X0Y1_DSP_bot.Inst_DSP_bot_ConfigMem.Inst_frame0_bit6.Q
+ VPWR VGND sg13g2_dlhq_1
X_4498_ Tile_X0Y0_DSP_top.Inst_DSP_top_ConfigMem.Inst_frame4_bit24.Q Tile_X0Y0_DSP_top.Inst_DSP_top_switch_matrix.bot2top0
+ Tile_X0Y0_DSP_top.Inst_DSP_top_switch_matrix.bot2top1 Tile_X0Y0_DSP_top.Inst_DSP_top_switch_matrix.bot2top2
+ Tile_X0Y0_DSP_top.Inst_DSP_top_switch_matrix.bot2top3 Tile_X0Y0_DSP_top.Inst_DSP_top_ConfigMem.Inst_frame4_bit25.Q
+ _0256_ VPWR VGND sg13g2_mux4_1
X_4567_ Tile_X0Y0_DSP_top.Inst_DSP_top_ConfigMem.Inst_frame3_bit9.Q VPWR _0322_ VGND
+ Tile_X0Y0_DSP_top.Inst_DSP_top_ConfigMem.Inst_frame3_bit8.Q Tile_X0Y0_DSP_top.Inst_DSP_top_switch_matrix.bot2top7
+ sg13g2_o21ai_1
X_4636_ VPWR _0388_ _0387_ VGND sg13g2_inv_1
X_6306_ Tile_X0Y0_W6END[3] Tile_X0Y0_W6BEG[1] VPWR VGND sg13g2_buf_1
X_3518_ VGND VPWR Tile_X0Y1_DSP_bot.Inst_DSP_bot_ConfigMem.Inst_frame12_bit3.Q Tile_X0Y1_DSP_bot.Inst_MULADD.ACC\[2\]
+ _1872_ _1871_ sg13g2_a21oi_1
X_6237_ Tile_X0Y0_DSP_top.Inst_DSP_top_switch_matrix.JN2BEG1 Tile_X0Y0_N2BEG[1] VPWR
+ VGND sg13g2_buf_1
X_5119_ VGND VPWR Tile_X0Y1_N2MID[5] Tile_X0Y0_DSP_top.Inst_DSP_top_ConfigMem.Inst_frame2_bit16.Q
+ _0849_ Tile_X0Y0_DSP_top.Inst_DSP_top_ConfigMem.Inst_frame2_bit17.Q sg13g2_a21oi_1
X_6168_ Tile_X0Y0_EE4END[8] Tile_X0Y0_EE4BEG[4] VPWR VGND sg13g2_buf_1
X_6099_ VPWR VGND _2497_ sg13g2_tiehi
X_3449_ VGND VPWR Tile_X0Y1_DSP_bot.Inst_DSP_bot_ConfigMem.Inst_frame12_bit2.Q _0104_
+ _1806_ Tile_X0Y1_DSP_bot.Inst_DSP_bot_ConfigMem.Inst_frame12_bit3.Q sg13g2_a21oi_1
XFILLER_4_49 VPWR VGND sg13g2_fill_1
XFILLER_48_322 VPWR VGND sg13g2_fill_1
X_2751_ _1132_ _1128_ _1133_ VPWR VGND sg13g2_xor2_1
X_2820_ _1200_ _1129_ _1199_ VPWR VGND sg13g2_xnor2_1
X_4352_ VPWR _0115_ Tile_X0Y0_DSP_top.Inst_DSP_top_ConfigMem.Inst_frame11_bit1.Q VGND
+ sg13g2_inv_1
X_5470_ Tile_X0Y0_FrameData[15] Tile_X0Y1_FrameStrobe[8] Tile_X0Y0_DSP_top.Inst_DSP_top_ConfigMem.Inst_frame8_bit15.Q
+ VPWR VGND sg13g2_dlhq_1
X_2682_ Tile_X0Y1_DSP_bot.Inst_DSP_bot_ConfigMem.Inst_frame7_bit2.Q Tile_X0Y1_W2MID[2]
+ _1068_ VPWR VGND sg13g2_nor2b_1
X_4421_ VGND VPWR Tile_X0Y1_DSP_bot.Inst_DSP_bot_ConfigMem.Inst_frame1_bit13.Q _0180_
+ _0182_ _0026_ sg13g2_a21oi_1
X_3165_ Tile_X0Y0_DSP_top.Inst_DSP_top_ConfigMem.Inst_frame0_bit19.Q VPWR _1538_ VGND
+ Tile_X0Y0_S4END[2] Tile_X0Y0_DSP_top.Inst_DSP_top_ConfigMem.Inst_frame0_bit18.Q
+ sg13g2_o21ai_1
X_3303_ _1670_ _1669_ _0093_ _1666_ _1665_ VPWR VGND sg13g2_a22oi_1
X_4283_ VPWR _0046_ Tile_X0Y1_DSP_bot.Inst_DSP_bot_ConfigMem.Inst_frame4_bit15.Q VGND
+ sg13g2_inv_1
X_6022_ Tile_X0Y1_FrameData[21] Tile_X0Y1_FrameStrobe[11] Tile_X0Y1_DSP_bot.Inst_DSP_bot_ConfigMem.Inst_frame11_bit21.Q
+ VPWR VGND sg13g2_dlhq_1
X_3234_ VGND VPWR Tile_X0Y1_DSP_bot.Inst_DSP_bot_ConfigMem.Inst_frame3_bit28.Q _0130_
+ _1603_ _1602_ sg13g2_a21oi_1
X_3096_ _1472_ Tile_X0Y0_DSP_top.Inst_DSP_top_ConfigMem.Inst_frame1_bit23.Q _1473_
+ VPWR VGND sg13g2_nor2b_1
XFILLER_66_174 VPWR VGND sg13g2_fill_1
XFILLER_54_358 VPWR VGND sg13g2_fill_2
XFILLER_22_200 VPWR VGND sg13g2_fill_1
X_3998_ Tile_X0Y0_DSP_top.Inst_DSP_top_switch_matrix.N1END2 Tile_X0Y0_S1END[2] Tile_X0Y0_DSP_top.Inst_DSP_top_ConfigMem.Inst_frame9_bit6.Q
+ _2285_ VPWR VGND sg13g2_mux2_1
X_5737_ Tile_X0Y1_FrameData[18] Tile_X0Y1_FrameStrobe[2] Tile_X0Y1_DSP_bot.Inst_DSP_bot_ConfigMem.Inst_frame2_bit18.Q
+ VPWR VGND sg13g2_dlhq_1
X_2949_ _1326_ _0741_ _1076_ VPWR VGND sg13g2_nand2_1
X_5806_ Tile_X0Y1_FrameData[13] Tile_X0Y1_FrameStrobe[4] Tile_X0Y1_DSP_bot.Inst_DSP_bot_ConfigMem.Inst_frame4_bit13.Q
+ VPWR VGND sg13g2_dlhq_1
X_5668_ Tile_X0Y1_FrameData[23] Tile_X0Y1_FrameStrobe[0] Tile_X0Y1_DSP_bot.Inst_DSP_bot_ConfigMem.Inst_frame0_bit23.Q
+ VPWR VGND sg13g2_dlhq_1
XFILLER_89_266 VPWR VGND sg13g2_fill_2
X_5599_ Tile_X0Y0_FrameData[14] Tile_X0Y1_FrameStrobe[12] Tile_X0Y0_DSP_top.Inst_DSP_top_ConfigMem.Inst_frame12_bit14.Q
+ VPWR VGND sg13g2_dlhq_1
X_4619_ _0371_ VPWR _0372_ VGND Tile_X0Y1_DSP_bot.Inst_DSP_bot_ConfigMem.Inst_frame4_bit13.Q
+ _0370_ sg13g2_o21ai_1
XFILLER_72_199 VPWR VGND sg13g2_decap_8
XFILLER_13_244 VPWR VGND sg13g2_decap_4
XFILLER_95_247 VPWR VGND sg13g2_fill_2
X_3921_ _2219_ Tile_X0Y0_DSP_top.Inst_DSP_top_ConfigMem.Inst_frame11_bit2.Q _2220_
+ VPWR VGND sg13g2_nor2b_1
X_4970_ Tile_X0Y0_DSP_top.Inst_DSP_top_ConfigMem.Inst_frame2_bit0.Q Tile_X0Y0_DSP_top.Inst_DSP_top_switch_matrix.bot2top1
+ Tile_X0Y0_DSP_top.Inst_DSP_top_switch_matrix.bot2top2 Tile_X0Y0_DSP_top.Inst_DSP_top_switch_matrix.bot2top3
+ Tile_X0Y0_DSP_top.Inst_DSP_top_switch_matrix.bot2top4 Tile_X0Y0_DSP_top.Inst_DSP_top_ConfigMem.Inst_frame2_bit1.Q
+ _0707_ VPWR VGND sg13g2_mux4_1
XFILLER_36_358 VPWR VGND sg13g2_fill_2
X_3783_ Tile_X0Y0_DSP_top.Inst_DSP_top_ConfigMem.Inst_frame3_bit28.Q Tile_X0Y0_DSP_top.Inst_DSP_top_switch_matrix.bot2top0
+ Tile_X0Y0_DSP_top.Inst_DSP_top_switch_matrix.bot2top1 Tile_X0Y0_DSP_top.Inst_DSP_top_switch_matrix.bot2top2
+ Tile_X0Y0_DSP_top.Inst_DSP_top_switch_matrix.bot2top3 Tile_X0Y0_DSP_top.Inst_DSP_top_ConfigMem.Inst_frame3_bit29.Q
+ _2112_ VPWR VGND sg13g2_mux4_1
X_3852_ _2172_ VPWR _2173_ VGND Tile_X0Y0_DSP_top.Inst_DSP_top_ConfigMem.Inst_frame1_bit0.Q
+ _0129_ sg13g2_o21ai_1
X_5522_ Tile_X0Y0_FrameData[27] Tile_X0Y1_FrameStrobe[10] Tile_X0Y0_DSP_top.Inst_DSP_top_ConfigMem.Inst_frame10_bit27.Q
+ VPWR VGND sg13g2_dlhq_1
X_2734_ _0084_ VPWR _1118_ VGND Tile_X0Y1_DSP_bot.Inst_DSP_bot_ConfigMem.Inst_frame2_bit18.Q
+ _1117_ sg13g2_o21ai_1
X_2803_ _0085_ _0274_ _1184_ VPWR VGND sg13g2_nor2_1
X_5384_ Tile_X0Y0_FrameData[5] Tile_X0Y1_FrameStrobe[5] Tile_X0Y0_DSP_top.Inst_DSP_top_ConfigMem.Inst_frame5_bit5.Q
+ VPWR VGND sg13g2_dlhq_1
X_2596_ VGND VPWR _0022_ Tile_X0Y0_DSP_top.Inst_DSP_top_ConfigMem.Inst_frame0_bit2.Q
+ _0985_ Tile_X0Y0_DSP_top.Inst_DSP_top_ConfigMem.Inst_frame0_bit3.Q sg13g2_a21oi_1
X_5453_ Tile_X0Y0_FrameData[0] Tile_X0Y1_FrameStrobe[7] Tile_X0Y0_DSP_top.Inst_DSP_top_ConfigMem.Inst_frame7_bit0.Q
+ VPWR VGND sg13g2_dlhq_1
X_4335_ VPWR _0098_ Tile_X0Y1_DSP_bot.Inst_DSP_bot_ConfigMem.Inst_frame2_bit27.Q VGND
+ sg13g2_inv_1
X_4404_ _0166_ _0027_ _0165_ VPWR VGND sg13g2_nand2_1
X_2665_ Tile_X0Y1_DSP_bot.Inst_DSP_bot_ConfigMem.Inst_frame3_bit5.Q VPWR _1052_ VGND
+ Tile_X0Y1_DSP_bot.Inst_DSP_bot_ConfigMem.Inst_frame3_bit4.Q Tile_X0Y1_DSP_bot.Inst_DSP_bot_switch_matrix.Q7
+ sg13g2_o21ai_1
X_3148_ _1522_ Tile_X0Y0_DSP_top.Inst_DSP_top_ConfigMem.Inst_frame3_bit22.Q _1520_
+ VPWR VGND sg13g2_nand2b_1
XFILLER_94_291 VPWR VGND sg13g2_decap_4
X_3217_ _1585_ _1583_ _1587_ VPWR VGND sg13g2_xor2_1
X_4266_ VPWR _0029_ Tile_X0Y1_DSP_bot.Inst_DSP_bot_ConfigMem.Inst_frame3_bit10.Q VGND
+ sg13g2_inv_1
X_6005_ Tile_X0Y1_FrameData[6] Tile_X0Y1_FrameStrobe[10] Tile_X0Y1_DSP_bot.Inst_DSP_bot_ConfigMem.Inst_frame10_bit6.Q
+ VPWR VGND sg13g2_dlhq_1
X_4197_ _2438_ Tile_X0Y1_DSP_bot.Inst_DSP_bot_ConfigMem.Inst_frame9_bit11.Q _1865_
+ VPWR VGND sg13g2_nand2_1
X_3079_ _1447_ _1454_ _1456_ VPWR VGND _1446_ sg13g2_nand3b_1
XFILLER_92_206 VPWR VGND sg13g2_fill_2
XANTENNA_121 VPWR VGND Tile_X0Y0_W2MID[7] sg13g2_antennanp
XANTENNA_110 VPWR VGND Tile_X0Y0_S2MID[4] sg13g2_antennanp
XFILLER_45_199 VPWR VGND sg13g2_decap_4
XANTENNA_132 VPWR VGND Tile_X0Y0_S4END[6] sg13g2_antennanp
XANTENNA_143 VPWR VGND Tile_X0Y0_S4END[6] sg13g2_antennanp
XFILLER_18_303 VPWR VGND sg13g2_fill_1
XFILLER_5_284 VPWR VGND sg13g2_fill_1
X_4051_ _2332_ VPWR Tile_X0Y0_DSP_top.Inst_DSP_top_switch_matrix.W6BEG1 VGND _2325_
+ _2327_ sg13g2_o21ai_1
X_3002_ _1076_ _1127_ _0741_ _1379_ VPWR VGND _1187_ sg13g2_nand4_1
XFILLER_36_144 VPWR VGND sg13g2_decap_4
X_4120_ _2374_ _2373_ Tile_X0Y1_DSP_bot.Inst_DSP_bot_ConfigMem.Inst_frame11_bit1.Q
+ Tile_X0Y0_DSP_top.NN4BEG_outbuf_11.A VPWR VGND sg13g2_mux2_1
XFILLER_101_29 VPWR VGND sg13g2_fill_2
X_3904_ _2203_ VPWR _2204_ VGND _0111_ _0679_ sg13g2_o21ai_1
X_4884_ Tile_X0Y0_DSP_top.Inst_DSP_top_ConfigMem.Inst_frame2_bit13.Q VPWR _0625_ VGND
+ Tile_X0Y0_DSP_top.Inst_DSP_top_ConfigMem.Inst_frame2_bit12.Q _0129_ sg13g2_o21ai_1
X_4953_ Tile_X0Y1_DSP_bot.Inst_DSP_bot_ConfigMem.Inst_frame1_bit18.Q _0689_ _0690_
+ VPWR VGND sg13g2_nor2_1
XFILLER_36_166 VPWR VGND sg13g2_decap_4
X_3766_ VGND VPWR _2089_ _2095_ _2096_ _2083_ sg13g2_a21oi_1
X_3697_ Tile_X0Y0_DSP_top.Inst_DSP_top_ConfigMem.Inst_frame1_bit24.Q Tile_X0Y0_DSP_top.Inst_DSP_top_switch_matrix.bot2top0
+ Tile_X0Y0_DSP_top.Inst_DSP_top_switch_matrix.bot2top1 Tile_X0Y0_DSP_top.Inst_DSP_top_switch_matrix.bot2top2
+ Tile_X0Y0_DSP_top.Inst_DSP_top_switch_matrix.bot2top3 Tile_X0Y0_DSP_top.Inst_DSP_top_ConfigMem.Inst_frame1_bit25.Q
+ _2031_ VPWR VGND sg13g2_mux4_1
X_5436_ Tile_X0Y0_FrameData[17] Tile_X0Y1_FrameStrobe[7] Tile_X0Y0_DSP_top.Inst_DSP_top_ConfigMem.Inst_frame7_bit17.Q
+ VPWR VGND sg13g2_dlhq_1
X_3835_ VGND VPWR Tile_X0Y1_N2MID[1] Tile_X0Y0_DSP_top.Inst_DSP_top_ConfigMem.Inst_frame1_bit0.Q
+ _2156_ _2155_ sg13g2_a21oi_1
X_5505_ Tile_X0Y0_FrameData[12] Tile_X0Y1_FrameStrobe[9] Tile_X0Y0_DSP_top.Inst_DSP_top_ConfigMem.Inst_frame9_bit12.Q
+ VPWR VGND sg13g2_dlhq_1
X_6485_ Tile_X0Y1_W6END[2] Tile_X0Y1_W6BEG[0] VPWR VGND sg13g2_buf_1
X_2717_ VPWR _1101_ _1100_ VGND sg13g2_inv_1
X_5298_ Tile_X0Y0_FrameData[27] Tile_X0Y1_FrameStrobe[3] Tile_X0Y0_DSP_top.Inst_DSP_top_ConfigMem.Inst_frame3_bit27.Q
+ VPWR VGND sg13g2_dlhq_1
X_4249_ Tile_X0Y1_DSP_bot.Inst_DSP_bot_switch_matrix.clr _1961_ _0012_ VPWR VGND sg13g2_nor2b_1
X_5367_ Tile_X0Y0_FrameData[22] Tile_X0Y1_FrameStrobe[5] Tile_X0Y0_DSP_top.Inst_DSP_top_ConfigMem.Inst_frame5_bit22.Q
+ VPWR VGND sg13g2_dlhq_1
X_2579_ _0073_ VPWR _0968_ VGND _0963_ _0966_ sg13g2_o21ai_1
X_4318_ VPWR _0081_ Tile_X0Y1_W2MID[3] VGND sg13g2_inv_1
X_2648_ _1035_ VPWR _1036_ VGND Tile_X0Y1_W2END[4] Tile_X0Y1_DSP_bot.Inst_DSP_bot_ConfigMem.Inst_frame3_bit12.Q
+ sg13g2_o21ai_1
XFILLER_74_228 VPWR VGND sg13g2_fill_2
XFILLER_104_182 VPWR VGND sg13g2_fill_2
X_3620_ _1960_ VPWR Tile_X0Y0_DSP_top.Inst_DSP_top_switch_matrix.bot2top1 VGND Tile_X0Y1_DSP_bot.Inst_DSP_bot_ConfigMem.Inst_frame12_bit5.Q
+ _1959_ sg13g2_o21ai_1
X_3551_ VGND VPWR Tile_X0Y1_DSP_bot.Inst_DSP_bot_ConfigMem.Inst_frame7_bit16.Q _0432_
+ _1904_ _1903_ sg13g2_a21oi_1
X_5221_ Tile_X0Y0_FrameData[8] Tile_X0Y1_FrameStrobe[0] Tile_X0Y0_DSP_top.Inst_DSP_top_ConfigMem.Inst_frame0_bit8.Q
+ VPWR VGND sg13g2_dlhq_1
X_4103_ Tile_X0Y1_DSP_bot.Inst_DSP_bot_ConfigMem.Inst_frame2_bit2.Q VPWR _2365_ VGND
+ Tile_X0Y1_DSP_bot.Inst_DSP_bot_ConfigMem.Inst_frame2_bit1.Q _2364_ sg13g2_o21ai_1
X_5152_ _0125_ _0126_ Tile_X0Y1_DSP_bot.Inst_DSP_bot_ConfigMem.Inst_frame2_bit4.Q
+ _0880_ VPWR VGND sg13g2_mux2_1
X_6270_ Tile_X0Y1_NN4END[10] Tile_X0Y0_NN4BEG[2] VPWR VGND sg13g2_buf_1
X_3482_ _1838_ Tile_X0Y1_DSP_bot.Inst_DSP_bot_ConfigMem.Inst_frame12_bit3.Q Tile_X0Y1_DSP_bot.Inst_MULADD.ACC\[3\]
+ VPWR VGND sg13g2_nand2_1
X_4034_ VGND VPWR _2317_ _0979_ Tile_X0Y0_DSP_top.Inst_DSP_top_ConfigMem.Inst_frame9_bit18.Q
+ sg13g2_or2_1
X_5083_ _0814_ VPWR Tile_X0Y0_DSP_top.Inst_DSP_top_switch_matrix.inst_cus_mux41_buf_top2bot7.X
+ VGND _0805_ _0807_ sg13g2_o21ai_1
XANTENNA_43 VPWR VGND Tile_X0Y1_N4END[14] sg13g2_antennanp
XANTENNA_32 VPWR VGND Tile_X0Y1_FrameStrobe[18] sg13g2_antennanp
XANTENNA_54 VPWR VGND Tile_X0Y0_E6END[4] sg13g2_antennanp
XANTENNA_10 VPWR VGND Tile_X0Y0_EE4END[13] sg13g2_antennanp
XANTENNA_65 VPWR VGND Tile_X0Y0_FrameData[6] sg13g2_antennanp
X_4867_ VGND VPWR Tile_X0Y1_DSP_bot.Inst_DSP_bot_ConfigMem.Inst_frame12_bit0.Q Tile_X0Y1_DSP_bot.Inst_MULADD.A_reg\[7\]
+ _0608_ _0607_ sg13g2_a21oi_1
X_4936_ Tile_X0Y1_DSP_bot.Inst_DSP_bot_ConfigMem.Inst_frame4_bit16.Q Tile_X0Y1_N1END[1]
+ Tile_X0Y1_N2END[5] Tile_X0Y1_E1END[1] Tile_X0Y1_E2END[5] Tile_X0Y1_DSP_bot.Inst_DSP_bot_ConfigMem.Inst_frame4_bit17.Q
+ _0675_ VPWR VGND sg13g2_mux4_1
X_3818_ _2140_ VPWR Tile_X0Y1_DSP_bot.Inst_DSP_bot_switch_matrix.Q8 VGND Tile_X0Y1_DSP_bot.Inst_DSP_bot_ConfigMem.Inst_frame12_bit5.Q
+ _2139_ sg13g2_o21ai_1
X_5985_ Tile_X0Y1_FrameData[26] Tile_X0Y1_FrameStrobe[10] Tile_X0Y1_DSP_bot.Inst_DSP_bot_ConfigMem.Inst_frame10_bit26.Q
+ VPWR VGND sg13g2_dlhq_1
XANTENNA_21 VPWR VGND Tile_X0Y1_E6END[7] sg13g2_antennanp
XFILLER_108_7 VPWR VGND sg13g2_decap_8
X_3749_ _2078_ VPWR _2079_ VGND _0032_ Tile_X0Y0_DSP_top.Inst_DSP_top_ConfigMem.Inst_frame1_bit28.Q
+ sg13g2_o21ai_1
X_5419_ Tile_X0Y0_FrameData[2] Tile_X0Y1_FrameStrobe[6] Tile_X0Y0_DSP_top.Inst_DSP_top_ConfigMem.Inst_frame6_bit2.Q
+ VPWR VGND sg13g2_dlhq_1
XFILLER_79_309 VPWR VGND sg13g2_fill_1
XANTENNA_98 VPWR VGND Tile_X0Y0_S2MID[4] sg13g2_antennanp
XANTENNA_76 VPWR VGND Tile_X0Y0_FrameData[6] sg13g2_antennanp
XANTENNA_87 VPWR VGND Tile_X0Y0_S2MID[4] sg13g2_antennanp
X_6399_ Tile_X0Y1_FrameData[18] Tile_X0Y1_FrameData_O[18] VPWR VGND sg13g2_buf_1
X_4798_ _0541_ Tile_X0Y1_DSP_bot.Inst_DSP_bot_ConfigMem.Inst_frame4_bit3.Q _0542_
+ VPWR VGND sg13g2_nor2b_1
X_6468_ Tile_X0Y1_DSP_bot.Inst_DSP_bot_switch_matrix.W1BEG3 Tile_X0Y1_W1BEG[3] VPWR
+ VGND sg13g2_buf_1
XFILLER_7_335 VPWR VGND sg13g2_fill_1
XFILLER_87_40 VPWR VGND sg13g2_fill_2
XFILLER_93_334 VPWR VGND sg13g2_fill_1
XFILLER_46_294 VPWR VGND sg13g2_fill_2
X_4652_ VPWR VGND Tile_X0Y0_DSP_top.Inst_DSP_top_ConfigMem.Inst_frame1_bit18.Q Tile_X0Y0_DSP_top.Inst_DSP_top_ConfigMem.Inst_frame1_bit19.Q
+ _0403_ _0399_ _0404_ _0401_ sg13g2_a221oi_1
X_5770_ Tile_X0Y1_FrameData[17] Tile_X0Y1_FrameStrobe[3] Tile_X0Y1_DSP_bot.Inst_DSP_bot_ConfigMem.Inst_frame3_bit17.Q
+ VPWR VGND sg13g2_dlhq_1
X_2982_ _1359_ _0991_ _1307_ VPWR VGND sg13g2_nand2_1
X_4721_ _0468_ VPWR _0469_ VGND Tile_X0Y1_DSP_bot.Inst_DSP_bot_ConfigMem.Inst_frame4_bit28.Q
+ _0467_ sg13g2_o21ai_1
X_6253_ Tile_X0Y1_N4END[9] Tile_X0Y0_N4BEG[1] VPWR VGND sg13g2_buf_1
X_4583_ Tile_X0Y0_DSP_top.Inst_DSP_top_switch_matrix.bot2top3 Tile_X0Y0_DSP_top.Inst_DSP_top_switch_matrix.bot2top4
+ Tile_X0Y0_DSP_top.Inst_DSP_top_ConfigMem.Inst_frame4_bit4.Q _0337_ VPWR VGND sg13g2_mux2_1
X_6322_ Tile_X0Y0_WW4END[9] Tile_X0Y0_WW4BEG[5] VPWR VGND sg13g2_buf_1
X_3465_ VGND VPWR Tile_X0Y1_DSP_bot.Inst_DSP_bot_ConfigMem.Inst_frame6_bit25.Q _1818_
+ _1822_ _1821_ sg13g2_a21oi_1
X_3603_ _1950_ Tile_X0Y1_DSP_bot.Inst_MULADD.ACC\[3\] Tile_X0Y1_DSP_bot.Inst_DSP_bot_ConfigMem.Inst_frame12_bit5.Q
+ Tile_X0Y1_DSP_bot.Inst_DSP_bot_switch_matrix.Q3 VPWR VGND sg13g2_mux2_1
X_3534_ _1888_ _1887_ _1884_ VPWR VGND sg13g2_nand2b_1
X_6184_ Tile_X0Y0_FrameData[4] Tile_X0Y0_FrameData_O[4] VPWR VGND sg13g2_buf_1
X_5066_ Tile_X0Y0_DSP_top.Inst_DSP_top_ConfigMem.Inst_frame1_bit10.Q _0798_ _0799_
+ VPWR VGND sg13g2_nor2b_1
X_5204_ Tile_X0Y0_FrameData[25] Tile_X0Y1_FrameStrobe[0] Tile_X0Y0_DSP_top.Inst_DSP_top_ConfigMem.Inst_frame0_bit25.Q
+ VPWR VGND sg13g2_dlhq_1
X_5135_ Tile_X0Y0_DSP_top.Inst_DSP_top_ConfigMem.Inst_frame6_bit13.Q VPWR _0864_ VGND
+ _0051_ Tile_X0Y0_DSP_top.Inst_DSP_top_ConfigMem.Inst_frame6_bit12.Q sg13g2_o21ai_1
X_3396_ VGND VPWR Tile_X0Y1_DSP_bot.Inst_DSP_bot_ConfigMem.Inst_frame12_bit2.Q _0101_
+ _1756_ Tile_X0Y1_DSP_bot.Inst_DSP_bot_ConfigMem.Inst_frame12_bit3.Q sg13g2_a21oi_1
X_4017_ _2301_ VPWR _2302_ VGND Tile_X0Y0_DSP_top.Inst_DSP_top_ConfigMem.Inst_frame9_bit12.Q
+ _0189_ sg13g2_o21ai_1
X_5968_ Tile_X0Y1_FrameData[11] Tile_X0Y1_FrameStrobe[9] Tile_X0Y1_DSP_bot.Inst_DSP_bot_ConfigMem.Inst_frame9_bit11.Q
+ VPWR VGND sg13g2_dlhq_1
X_4919_ _0658_ VPWR _0659_ VGND Tile_X0Y0_DSP_top.Inst_DSP_top_ConfigMem.Inst_frame3_bit1.Q
+ _0656_ sg13g2_o21ai_1
X_5899_ Tile_X0Y1_FrameData[16] Tile_X0Y1_FrameStrobe[7] Tile_X0Y1_DSP_bot.Inst_DSP_bot_ConfigMem.Inst_frame7_bit16.Q
+ VPWR VGND sg13g2_dlhq_1
XFILLER_106_299 VPWR VGND sg13g2_fill_2
XFILLER_28_261 VPWR VGND sg13g2_fill_1
XFILLER_90_359 VPWR VGND sg13g2_fill_2
XFILLER_73_42 VPWR VGND sg13g2_fill_2
XFILLER_43_297 VPWR VGND sg13g2_fill_1
XFILLER_7_198 VPWR VGND sg13g2_decap_4
XFILLER_11_194 VPWR VGND sg13g2_fill_2
X_3181_ Tile_X0Y1_DSP_bot.Inst_DSP_bot_ConfigMem.Inst_frame12_bit2.Q Tile_X0Y1_DSP_bot.Inst_MULADD.C_reg\[11\]
+ _1553_ VPWR VGND sg13g2_and2_1
X_3250_ Tile_X0Y1_DSP_bot.Inst_DSP_bot_ConfigMem.Inst_frame1_bit22.Q _1617_ _1618_
+ VPWR VGND sg13g2_nor2_1
X_5822_ Tile_X0Y1_FrameData[29] Tile_X0Y1_FrameStrobe[5] Tile_X0Y1_DSP_bot.Inst_DSP_bot_ConfigMem.Inst_frame5_bit29.Q
+ VPWR VGND sg13g2_dlhq_1
XFILLER_97_0 VPWR VGND sg13g2_decap_4
X_4635_ Tile_X0Y0_DSP_top.Inst_DSP_top_ConfigMem.Inst_frame6_bit26.Q Tile_X0Y0_DSP_top.Inst_DSP_top_switch_matrix.N2BEGb3
+ Tile_X0Y0_E2MID[3] Tile_X0Y0_S2MID[3] Tile_X0Y0_W2MID[3] Tile_X0Y0_DSP_top.Inst_DSP_top_ConfigMem.Inst_frame6_bit27.Q
+ _0387_ VPWR VGND sg13g2_mux4_1
X_4704_ _0453_ Tile_X0Y0_DSP_top.Inst_DSP_top_ConfigMem.Inst_frame3_bit12.Q Tile_X0Y0_DSP_top.Inst_DSP_top_switch_matrix.bot2top4
+ VPWR VGND sg13g2_nand2b_1
X_2896_ _1274_ _1127_ _0969_ VPWR VGND sg13g2_nand2b_1
X_2965_ VGND VPWR _1340_ _1341_ _1342_ _1332_ sg13g2_a21oi_1
XFILLER_34_297 VPWR VGND sg13g2_fill_2
X_5753_ Tile_X0Y1_FrameData[2] Tile_X0Y1_FrameStrobe[2] Tile_X0Y1_DSP_bot.Inst_DSP_bot_ConfigMem.Inst_frame2_bit2.Q
+ VPWR VGND sg13g2_dlhq_1
X_5684_ Tile_X0Y1_FrameData[7] Tile_X0Y1_FrameStrobe[0] Tile_X0Y1_DSP_bot.Inst_DSP_bot_ConfigMem.Inst_frame0_bit7.Q
+ VPWR VGND sg13g2_dlhq_1
X_6236_ Tile_X0Y0_DSP_top.Inst_DSP_top_switch_matrix.JN2BEG0 Tile_X0Y0_N2BEG[0] VPWR
+ VGND sg13g2_buf_1
X_4566_ _0320_ VPWR _0321_ VGND Tile_X0Y0_DSP_top.Inst_DSP_top_ConfigMem.Inst_frame3_bit8.Q
+ Tile_X0Y0_DSP_top.Inst_DSP_top_switch_matrix.bot2top5 sg13g2_o21ai_1
X_4497_ Tile_X0Y0_DSP_top.Inst_DSP_top_ConfigMem.Inst_frame8_bit19.Q VPWR _0255_ VGND
+ Tile_X0Y0_DSP_top.Inst_DSP_top_ConfigMem.Inst_frame8_bit18.Q _0254_ sg13g2_o21ai_1
X_6305_ Tile_X0Y0_W6END[2] Tile_X0Y0_W6BEG[0] VPWR VGND sg13g2_buf_1
X_3448_ _1805_ _0072_ Tile_X0Y1_DSP_bot.C5 VPWR VGND sg13g2_nand2b_1
X_3517_ VGND VPWR _1869_ _1870_ _1871_ Tile_X0Y1_DSP_bot.Inst_DSP_bot_ConfigMem.Inst_frame12_bit3.Q
+ sg13g2_a21oi_1
X_5118_ _0848_ _0237_ Tile_X0Y0_DSP_top.Inst_DSP_top_ConfigMem.Inst_frame2_bit16.Q
+ VPWR VGND sg13g2_nand2b_1
XFILLER_94_19 VPWR VGND sg13g2_fill_2
X_6167_ Tile_X0Y0_EE4END[7] Tile_X0Y0_EE4BEG[3] VPWR VGND sg13g2_buf_1
XFILLER_57_345 VPWR VGND sg13g2_fill_2
X_3379_ VGND VPWR Tile_X0Y1_DSP_bot.Inst_DSP_bot_ConfigMem.Inst_frame2_bit24.Q _0130_
+ _1741_ _1740_ sg13g2_a21oi_1
X_6098_ VPWR VGND _2496_ sg13g2_tiehi
XFILLER_27_35 VPWR VGND sg13g2_fill_2
X_5049_ VGND VPWR Tile_X0Y1_DSP_bot.Inst_DSP_bot_ConfigMem.Inst_frame0_bit7.Q _0779_
+ _0783_ _0782_ sg13g2_a21oi_1
XFILLER_40_278 VPWR VGND sg13g2_fill_1
XFILLER_4_102 VPWR VGND sg13g2_fill_1
XFILLER_102_291 VPWR VGND sg13g2_fill_1
X_2750_ _1132_ _0743_ _1130_ VPWR VGND sg13g2_xnor2_1
X_2681_ _1066_ VPWR _1067_ VGND Tile_X0Y1_DSP_bot.Inst_DSP_bot_ConfigMem.Inst_frame9_bit25.Q
+ _1019_ sg13g2_o21ai_1
XFILLER_31_267 VPWR VGND sg13g2_fill_2
X_4351_ VPWR _0114_ Tile_X0Y0_DSP_top.Inst_DSP_top_ConfigMem.Inst_frame8_bit27.Q VGND
+ sg13g2_inv_1
X_3302_ _1667_ _1668_ Tile_X0Y1_DSP_bot.Inst_DSP_bot_ConfigMem.Inst_frame2_bit30.Q
+ _1669_ VPWR VGND sg13g2_mux2_1
X_4282_ VPWR _0045_ Tile_X0Y1_DSP_bot.Inst_DSP_bot_ConfigMem.Inst_frame4_bit14.Q VGND
+ sg13g2_inv_1
X_4420_ _0024_ _0025_ Tile_X0Y1_DSP_bot.Inst_DSP_bot_ConfigMem.Inst_frame1_bit12.Q
+ _0181_ VPWR VGND sg13g2_mux2_1
X_3095_ _1470_ _1471_ _1472_ VPWR VGND sg13g2_nor2_1
X_3164_ _1535_ VPWR _1537_ VGND Tile_X0Y0_DSP_top.Inst_DSP_top_ConfigMem.Inst_frame6_bit19.Q
+ _1536_ sg13g2_o21ai_1
X_6021_ Tile_X0Y1_FrameData[22] Tile_X0Y1_FrameStrobe[11] Tile_X0Y1_DSP_bot.Inst_DSP_bot_ConfigMem.Inst_frame11_bit22.Q
+ VPWR VGND sg13g2_dlhq_1
XFILLER_12_0 VPWR VGND sg13g2_fill_1
X_3233_ Tile_X0Y1_DSP_bot.Inst_DSP_bot_ConfigMem.Inst_frame3_bit29.Q VPWR _1602_ VGND
+ Tile_X0Y1_DSP_bot.Inst_DSP_bot_ConfigMem.Inst_frame3_bit28.Q Tile_X0Y1_DSP_bot.Inst_DSP_bot_switch_matrix.Q6
+ sg13g2_o21ai_1
XFILLER_81_178 VPWR VGND sg13g2_fill_2
XFILLER_81_156 VPWR VGND sg13g2_decap_4
X_3997_ _2283_ _2284_ Tile_X0Y0_DSP_top.Inst_DSP_top_ConfigMem.Inst_frame10_bit29.Q
+ Tile_X0Y0_DSP_top.Inst_DSP_top_switch_matrix.SS4BEG3 VPWR VGND sg13g2_mux2_1
X_5805_ Tile_X0Y1_FrameData[14] Tile_X0Y1_FrameStrobe[4] Tile_X0Y1_DSP_bot.Inst_DSP_bot_ConfigMem.Inst_frame4_bit14.Q
+ VPWR VGND sg13g2_dlhq_1
XFILLER_22_267 VPWR VGND sg13g2_fill_1
X_5598_ Tile_X0Y0_FrameData[15] Tile_X0Y1_FrameStrobe[12] Tile_X0Y0_DSP_top.Inst_DSP_top_ConfigMem.Inst_frame12_bit15.Q
+ VPWR VGND sg13g2_dlhq_1
X_2948_ _1325_ _0786_ _1127_ VPWR VGND sg13g2_nand2_1
X_5736_ Tile_X0Y1_FrameData[19] Tile_X0Y1_FrameStrobe[2] Tile_X0Y1_DSP_bot.Inst_DSP_bot_ConfigMem.Inst_frame2_bit19.Q
+ VPWR VGND sg13g2_dlhq_1
X_2879_ _1258_ _1254_ _1257_ _1232_ Tile_X0Y1_DSP_bot.Inst_DSP_bot_ConfigMem.Inst_frame8_bit1.Q
+ VPWR VGND sg13g2_a22oi_1
X_5667_ Tile_X0Y1_FrameData[24] Tile_X0Y1_FrameStrobe[0] Tile_X0Y1_DSP_bot.Inst_DSP_bot_ConfigMem.Inst_frame0_bit24.Q
+ VPWR VGND sg13g2_dlhq_1
X_4618_ VGND VPWR Tile_X0Y1_DSP_bot.Inst_DSP_bot_ConfigMem.Inst_frame4_bit13.Q _0368_
+ _0371_ _0045_ sg13g2_a21oi_1
X_4549_ VPWR VGND _0304_ Tile_X0Y0_DSP_top.Inst_DSP_top_ConfigMem.Inst_frame4_bit27.Q
+ _0301_ _0296_ _0305_ _0299_ sg13g2_a221oi_1
X_6219_ Tile_X0Y1_FrameStrobe[7] Tile_X0Y0_FrameStrobe_O[7] VPWR VGND sg13g2_buf_1
XFILLER_72_101 VPWR VGND sg13g2_fill_2
XFILLER_54_11 VPWR VGND sg13g2_fill_2
X_3851_ _2172_ Tile_X0Y0_DSP_top.Inst_DSP_top_ConfigMem.Inst_frame1_bit0.Q Tile_X0Y0_DSP_top.Inst_DSP_top_switch_matrix.bot2top8
+ VPWR VGND sg13g2_nand2_1
X_3920_ VGND VPWR Tile_X0Y0_DSP_top.Inst_DSP_top_ConfigMem.Inst_frame11_bit0.Q _1537_
+ _2219_ _2218_ sg13g2_a21oi_1
XFILLER_63_167 VPWR VGND sg13g2_fill_1
X_3782_ VGND VPWR _0116_ Tile_X0Y0_DSP_top.Inst_DSP_top_switch_matrix.JN2BEG5 _2111_
+ Tile_X0Y0_DSP_top.Inst_DSP_top_ConfigMem.Inst_frame8_bit30.Q sg13g2_a21oi_1
X_5521_ Tile_X0Y0_FrameData[28] Tile_X0Y1_FrameStrobe[10] Tile_X0Y0_DSP_top.Inst_DSP_top_ConfigMem.Inst_frame10_bit28.Q
+ VPWR VGND sg13g2_dlhq_1
X_5452_ Tile_X0Y0_FrameData[1] Tile_X0Y1_FrameStrobe[7] Tile_X0Y0_DSP_top.Inst_DSP_top_ConfigMem.Inst_frame7_bit1.Q
+ VPWR VGND sg13g2_dlhq_1
X_2733_ Tile_X0Y1_DSP_bot.Inst_DSP_bot_ConfigMem.Inst_frame2_bit16.Q Tile_X0Y1_N1END[1]
+ Tile_X0Y1_N2END[5] Tile_X0Y1_E1END[1] Tile_X0Y1_E2END[5] Tile_X0Y1_DSP_bot.Inst_DSP_bot_ConfigMem.Inst_frame2_bit17.Q
+ _1117_ VPWR VGND sg13g2_mux4_1
X_2802_ _1182_ VPWR _1183_ VGND Tile_X0Y1_DSP_bot.Inst_DSP_bot_ConfigMem.Inst_frame9_bit22.Q
+ _1175_ sg13g2_o21ai_1
X_2664_ _1050_ VPWR _1051_ VGND Tile_X0Y1_DSP_bot.Inst_DSP_bot_ConfigMem.Inst_frame3_bit4.Q
+ Tile_X0Y1_DSP_bot.Inst_DSP_bot_switch_matrix.Q5 sg13g2_o21ai_1
X_2595_ Tile_X0Y0_W2END[7] Tile_X0Y0_DSP_top.Inst_DSP_top_switch_matrix.E2BEG1 Tile_X0Y0_DSP_top.Inst_DSP_top_ConfigMem.Inst_frame0_bit2.Q
+ _0984_ VPWR VGND sg13g2_mux2_1
X_5383_ Tile_X0Y0_FrameData[6] Tile_X0Y1_FrameStrobe[5] Tile_X0Y0_DSP_top.Inst_DSP_top_ConfigMem.Inst_frame5_bit6.Q
+ VPWR VGND sg13g2_dlhq_1
X_4334_ VPWR _0097_ Tile_X0Y1_DSP_bot.Inst_DSP_bot_ConfigMem.Inst_frame8_bit22.Q VGND
+ sg13g2_inv_1
X_4403_ Tile_X0Y1_E6END[1] Tile_X0Y0_S2MID[3] Tile_X0Y1_DSP_bot.Inst_DSP_bot_ConfigMem.Inst_frame3_bit8.Q
+ _0165_ VPWR VGND sg13g2_mux2_1
X_4265_ VPWR _0028_ Tile_X0Y1_W6END[1] VGND sg13g2_inv_1
X_6004_ Tile_X0Y1_FrameData[7] Tile_X0Y1_FrameStrobe[10] Tile_X0Y1_DSP_bot.Inst_DSP_bot_ConfigMem.Inst_frame10_bit7.Q
+ VPWR VGND sg13g2_dlhq_1
X_3147_ Tile_X0Y0_DSP_top.Inst_DSP_top_ConfigMem.Inst_frame3_bit20.Q Tile_X0Y0_DSP_top.Inst_DSP_top_switch_matrix.bot2top0
+ Tile_X0Y0_DSP_top.Inst_DSP_top_switch_matrix.bot2top1 Tile_X0Y0_DSP_top.Inst_DSP_top_switch_matrix.bot2top2
+ Tile_X0Y0_DSP_top.Inst_DSP_top_switch_matrix.bot2top3 Tile_X0Y0_DSP_top.Inst_DSP_top_ConfigMem.Inst_frame3_bit21.Q
+ _1521_ VPWR VGND sg13g2_mux4_1
X_3078_ VPWR _1455_ _1454_ VGND sg13g2_inv_1
X_3216_ _1583_ _1585_ _1586_ VPWR VGND sg13g2_nor2_1
X_4196_ _2436_ VPWR _2437_ VGND Tile_X0Y1_DSP_bot.Inst_DSP_bot_ConfigMem.Inst_frame9_bit11.Q
+ _1784_ sg13g2_o21ai_1
XFILLER_27_359 VPWR VGND sg13g2_fill_2
XFILLER_10_237 VPWR VGND sg13g2_fill_1
X_5719_ Tile_X0Y1_FrameData[4] Tile_X0Y1_FrameStrobe[1] Tile_X0Y1_DSP_bot.Inst_DSP_bot_ConfigMem.Inst_frame1_bit4.Q
+ VPWR VGND sg13g2_dlhq_1
XFILLER_1_18 VPWR VGND sg13g2_decap_8
XFILLER_1_29 VPWR VGND sg13g2_fill_1
XFILLER_65_87 VPWR VGND sg13g2_fill_1
XANTENNA_122 VPWR VGND Tile_X0Y0_W2MID[7] sg13g2_antennanp
XANTENNA_111 VPWR VGND Tile_X0Y0_S2MID[4] sg13g2_antennanp
XANTENNA_100 VPWR VGND Tile_X0Y0_S2MID[4] sg13g2_antennanp
XANTENNA_133 VPWR VGND Tile_X0Y0_S4END[6] sg13g2_antennanp
XANTENNA_144 VPWR VGND Tile_X0Y0_S4END[6] sg13g2_antennanp
XFILLER_110_334 VPWR VGND sg13g2_decap_8
X_4050_ _2331_ VPWR _2332_ VGND Tile_X0Y0_DSP_top.Inst_DSP_top_ConfigMem.Inst_frame9_bit24.Q
+ _2328_ sg13g2_o21ai_1
X_3001_ _1326_ _1377_ _1378_ VPWR VGND sg13g2_nor2_1
X_3903_ VGND VPWR _0111_ _0129_ _2203_ Tile_X0Y0_DSP_top.Inst_DSP_top_ConfigMem.Inst_frame12_bit30.Q
+ sg13g2_a21oi_1
X_3834_ Tile_X0Y0_DSP_top.Inst_DSP_top_ConfigMem.Inst_frame1_bit0.Q _0293_ _2155_
+ VPWR VGND sg13g2_nor2_1
X_4883_ Tile_X0Y0_DSP_top.Inst_DSP_top_switch_matrix.bot2top5 Tile_X0Y0_DSP_top.Inst_DSP_top_switch_matrix.bot2top6
+ Tile_X0Y0_DSP_top.Inst_DSP_top_ConfigMem.Inst_frame2_bit12.Q _0624_ VPWR VGND sg13g2_mux2_1
X_4952_ Tile_X0Y1_DSP_bot.Inst_DSP_bot_ConfigMem.Inst_frame1_bit16.Q Tile_X0Y1_N1END[1]
+ Tile_X0Y1_N2END[5] Tile_X0Y1_E1END[1] Tile_X0Y1_E2END[5] Tile_X0Y1_DSP_bot.Inst_DSP_bot_ConfigMem.Inst_frame1_bit17.Q
+ _0689_ VPWR VGND sg13g2_mux4_1
X_3765_ _2094_ Tile_X0Y0_DSP_top.Inst_DSP_top_ConfigMem.Inst_frame1_bit31.Q _2095_
+ VPWR VGND sg13g2_nor2b_1
X_5435_ Tile_X0Y0_FrameData[18] Tile_X0Y1_FrameStrobe[7] Tile_X0Y0_DSP_top.Inst_DSP_top_ConfigMem.Inst_frame7_bit18.Q
+ VPWR VGND sg13g2_dlhq_1
X_5504_ Tile_X0Y0_FrameData[13] Tile_X0Y1_FrameStrobe[9] Tile_X0Y0_DSP_top.Inst_DSP_top_ConfigMem.Inst_frame9_bit13.Q
+ VPWR VGND sg13g2_dlhq_1
X_3696_ Tile_X0Y0_DSP_top.Inst_DSP_top_ConfigMem.Inst_frame5_bit31.Q Tile_X0Y1_N2MID[1]
+ Tile_X0Y0_S2END[1] Tile_X0Y0_EE4END[3] Tile_X0Y0_W2END[1] Tile_X0Y0_DSP_top.Inst_DSP_top_ConfigMem.Inst_frame5_bit30.Q
+ _2030_ VPWR VGND sg13g2_mux4_1
X_6484_ Tile_X0Y1_W2MID[7] Tile_X0Y1_W2BEGb[7] VPWR VGND sg13g2_buf_1
X_2647_ _1035_ Tile_X0Y1_DSP_bot.Inst_DSP_bot_ConfigMem.Inst_frame3_bit12.Q Tile_X0Y1_W6END[0]
+ VPWR VGND sg13g2_nand2b_1
X_2716_ Tile_X0Y1_DSP_bot.Inst_DSP_bot_ConfigMem.Inst_frame0_bit12.Q Tile_X0Y1_NN4END[1]
+ Tile_X0Y1_EE4END[1] Tile_X0Y0_S4END[5] Tile_X0Y1_DSP_bot.Inst_DSP_bot_switch_matrix.JS2BEG2
+ Tile_X0Y1_DSP_bot.Inst_DSP_bot_ConfigMem.Inst_frame0_bit13.Q _1100_ VPWR VGND sg13g2_mux4_1
X_5297_ Tile_X0Y0_FrameData[28] Tile_X0Y1_FrameStrobe[3] Tile_X0Y0_DSP_top.Inst_DSP_top_ConfigMem.Inst_frame3_bit28.Q
+ VPWR VGND sg13g2_dlhq_1
X_4248_ Tile_X0Y1_DSP_bot.Inst_DSP_bot_switch_matrix.clr _1959_ _0011_ VPWR VGND sg13g2_nor2_1
X_5366_ Tile_X0Y0_FrameData[23] Tile_X0Y1_FrameStrobe[5] Tile_X0Y0_DSP_top.Inst_DSP_top_ConfigMem.Inst_frame5_bit23.Q
+ VPWR VGND sg13g2_dlhq_1
X_2578_ _0967_ Tile_X0Y1_DSP_bot.Inst_DSP_bot_ConfigMem.Inst_frame12_bit0.Q Tile_X0Y1_DSP_bot.Inst_MULADD.A_reg\[4\]
+ VPWR VGND sg13g2_nand2_1
X_4317_ VPWR _0080_ Tile_X0Y1_E2MID[3] VGND sg13g2_inv_1
X_4179_ _2421_ _2422_ Tile_X0Y1_DSP_bot.Inst_DSP_bot_ConfigMem.Inst_frame9_bit4.Q
+ Tile_X0Y1_DSP_bot.Inst_DSP_bot_switch_matrix.WW4BEG0 VPWR VGND sg13g2_mux2_1
XFILLER_51_56 VPWR VGND sg13g2_fill_1
XFILLER_51_34 VPWR VGND sg13g2_fill_2
XFILLER_18_156 VPWR VGND sg13g2_fill_2
X_5220_ Tile_X0Y0_FrameData[9] Tile_X0Y1_FrameStrobe[0] Tile_X0Y0_DSP_top.Inst_DSP_top_ConfigMem.Inst_frame0_bit9.Q
+ VPWR VGND sg13g2_dlhq_1
X_3481_ _1836_ _1835_ _1837_ VPWR VGND sg13g2_nor2b_1
X_3550_ Tile_X0Y1_DSP_bot.Inst_DSP_bot_ConfigMem.Inst_frame7_bit17.Q VPWR _1903_ VGND
+ Tile_X0Y1_W2MID[6] Tile_X0Y1_DSP_bot.Inst_DSP_bot_ConfigMem.Inst_frame7_bit16.Q
+ sg13g2_o21ai_1
X_4033_ VGND VPWR Tile_X0Y0_DSP_top.Inst_DSP_top_ConfigMem.Inst_frame9_bit18.Q _0387_
+ _2316_ _2315_ sg13g2_a21oi_1
X_5082_ _0813_ VPWR _0814_ VGND _0809_ _0812_ sg13g2_o21ai_1
X_5151_ Tile_X0Y1_DSP_bot.Inst_DSP_bot_switch_matrix.Q7 Tile_X0Y1_DSP_bot.Inst_DSP_bot_switch_matrix.Q9
+ Tile_X0Y1_DSP_bot.Inst_DSP_bot_ConfigMem.Inst_frame2_bit4.Q _0879_ VPWR VGND sg13g2_mux2_1
X_4102_ VGND VPWR Tile_X0Y0_S4END[5] Tile_X0Y1_DSP_bot.Inst_DSP_bot_ConfigMem.Inst_frame2_bit0.Q
+ _2364_ _2363_ sg13g2_a21oi_1
X_5984_ Tile_X0Y1_FrameData[27] Tile_X0Y1_FrameStrobe[10] Tile_X0Y1_DSP_bot.Inst_DSP_bot_ConfigMem.Inst_frame10_bit27.Q
+ VPWR VGND sg13g2_dlhq_1
XANTENNA_44 VPWR VGND Tile_X0Y1_N4END[14] sg13g2_antennanp
XANTENNA_33 VPWR VGND Tile_X0Y1_FrameStrobe[19] sg13g2_antennanp
XANTENNA_55 VPWR VGND Tile_X0Y0_E6END[5] sg13g2_antennanp
X_3748_ VGND VPWR Tile_X0Y0_S1END[2] Tile_X0Y0_DSP_top.Inst_DSP_top_ConfigMem.Inst_frame1_bit28.Q
+ _2078_ Tile_X0Y0_DSP_top.Inst_DSP_top_ConfigMem.Inst_frame1_bit29.Q sg13g2_a21oi_1
XANTENNA_11 VPWR VGND Tile_X0Y0_EE4END[8] sg13g2_antennanp
XANTENNA_66 VPWR VGND Tile_X0Y0_FrameData[6] sg13g2_antennanp
X_4866_ Tile_X0Y1_DSP_bot.Inst_DSP_bot_ConfigMem.Inst_frame12_bit0.Q _0606_ _0607_
+ VPWR VGND sg13g2_nor2_1
XANTENNA_77 VPWR VGND Tile_X0Y0_FrameData[6] sg13g2_antennanp
XANTENNA_99 VPWR VGND Tile_X0Y0_S2MID[4] sg13g2_antennanp
X_4935_ _0673_ Tile_X0Y1_DSP_bot.Inst_DSP_bot_ConfigMem.Inst_frame4_bit18.Q _0674_
+ VPWR VGND sg13g2_nor2b_1
X_3817_ _2140_ Tile_X0Y1_DSP_bot.Inst_MULADD.ACC\[8\] Tile_X0Y1_DSP_bot.Inst_DSP_bot_ConfigMem.Inst_frame12_bit5.Q
+ VPWR VGND sg13g2_nand2_1
X_4797_ VGND VPWR Tile_X0Y1_DSP_bot.Inst_DSP_bot_ConfigMem.Inst_frame4_bit1.Q _0539_
+ _0541_ _0540_ sg13g2_a21oi_1
XANTENNA_88 VPWR VGND Tile_X0Y0_S2MID[4] sg13g2_antennanp
XFILLER_21_26 VPWR VGND sg13g2_decap_4
XANTENNA_22 VPWR VGND Tile_X0Y1_E6END[8] sg13g2_antennanp
X_5349_ Tile_X0Y0_FrameData[8] Tile_X0Y1_FrameStrobe[4] Tile_X0Y0_DSP_top.Inst_DSP_top_ConfigMem.Inst_frame4_bit8.Q
+ VPWR VGND sg13g2_dlhq_1
X_5418_ Tile_X0Y0_FrameData[3] Tile_X0Y1_FrameStrobe[6] Tile_X0Y0_DSP_top.Inst_DSP_top_ConfigMem.Inst_frame6_bit3.Q
+ VPWR VGND sg13g2_dlhq_1
X_3679_ Tile_X0Y0_DSP_top.Inst_DSP_top_ConfigMem.Inst_frame7_bit29.Q Tile_X0Y0_E2MID[4]
+ Tile_X0Y0_W2MID[4] Tile_X0Y0_S2MID[4] Tile_X0Y0_DSP_top.Inst_DSP_top_switch_matrix.JS2BEG6
+ Tile_X0Y0_DSP_top.Inst_DSP_top_ConfigMem.Inst_frame7_bit28.Q _2015_ VPWR VGND sg13g2_mux4_1
X_6398_ Tile_X0Y1_FrameData[17] Tile_X0Y1_FrameData_O[17] VPWR VGND sg13g2_buf_1
X_6467_ Tile_X0Y1_DSP_bot.Inst_DSP_bot_switch_matrix.W1BEG2 Tile_X0Y1_W1BEG[2] VPWR
+ VGND sg13g2_buf_1
XFILLER_70_265 VPWR VGND sg13g2_fill_2
XFILLER_70_232 VPWR VGND sg13g2_fill_1
XFILLER_15_126 VPWR VGND sg13g2_fill_2
X_4651_ VPWR _0403_ _0402_ VGND sg13g2_inv_1
XFILLER_61_254 VPWR VGND sg13g2_fill_1
X_2981_ _1354_ VPWR _1358_ VGND _1355_ _1356_ sg13g2_o21ai_1
X_4720_ VGND VPWR Tile_X0Y1_DSP_bot.Inst_DSP_bot_ConfigMem.Inst_frame4_bit28.Q _0037_
+ _0468_ Tile_X0Y1_DSP_bot.Inst_DSP_bot_ConfigMem.Inst_frame4_bit29.Q sg13g2_a21oi_1
X_3602_ _1920_ _1919_ _1950_ VPWR VGND sg13g2_xor2_1
X_6252_ Tile_X0Y1_N4END[8] Tile_X0Y0_N4BEG[0] VPWR VGND sg13g2_buf_1
X_6183_ Tile_X0Y0_FrameData[3] Tile_X0Y0_FrameData_O[3] VPWR VGND sg13g2_buf_1
XFILLER_88_107 VPWR VGND sg13g2_decap_8
X_4582_ VGND VPWR Tile_X0Y0_DSP_top.Inst_DSP_top_switch_matrix.E2BEG2 _0336_ _0326_
+ sg13g2_or2_1
X_5203_ Tile_X0Y0_FrameData[26] Tile_X0Y1_FrameStrobe[0] Tile_X0Y0_DSP_top.Inst_DSP_top_ConfigMem.Inst_frame0_bit26.Q
+ VPWR VGND sg13g2_dlhq_1
X_6321_ Tile_X0Y0_WW4END[8] Tile_X0Y0_WW4BEG[4] VPWR VGND sg13g2_buf_1
XFILLER_42_0 VPWR VGND sg13g2_fill_2
X_3464_ Tile_X0Y1_DSP_bot.Inst_DSP_bot_ConfigMem.Inst_frame8_bit14.Q VPWR _1821_ VGND
+ Tile_X0Y1_DSP_bot.Inst_DSP_bot_ConfigMem.Inst_frame6_bit25.Q _1820_ sg13g2_o21ai_1
X_3533_ VGND VPWR Tile_X0Y1_DSP_bot.Inst_DSP_bot_ConfigMem.Inst_frame8_bit8.Q _1886_
+ _1887_ Tile_X0Y1_DSP_bot.Inst_DSP_bot_ConfigMem.Inst_frame8_bit9.Q sg13g2_a21oi_1
X_5065_ Tile_X0Y0_DSP_top.Inst_DSP_top_ConfigMem.Inst_frame1_bit9.Q _0237_ Tile_X0Y0_E2END[3]
+ Tile_X0Y1_N2MID[3] Tile_X0Y0_E6END[1] Tile_X0Y0_DSP_top.Inst_DSP_top_ConfigMem.Inst_frame1_bit8.Q
+ _0798_ VPWR VGND sg13g2_mux4_1
X_4016_ VGND VPWR _0032_ Tile_X0Y0_DSP_top.Inst_DSP_top_ConfigMem.Inst_frame9_bit12.Q
+ _2301_ Tile_X0Y0_DSP_top.Inst_DSP_top_ConfigMem.Inst_frame9_bit13.Q sg13g2_a21oi_1
XFILLER_69_321 VPWR VGND sg13g2_fill_2
X_5134_ _0862_ VPWR _0863_ VGND Tile_X0Y0_DSP_top.Inst_DSP_top_ConfigMem.Inst_frame6_bit12.Q
+ _0432_ sg13g2_o21ai_1
X_3395_ _0072_ VPWR _1755_ VGND _1736_ _1754_ sg13g2_o21ai_1
XFILLER_29_207 VPWR VGND sg13g2_fill_1
X_4918_ VGND VPWR Tile_X0Y0_DSP_top.Inst_DSP_top_ConfigMem.Inst_frame3_bit1.Q _0657_
+ _0658_ Tile_X0Y0_DSP_top.Inst_DSP_top_ConfigMem.Inst_frame3_bit2.Q sg13g2_a21oi_1
X_5967_ Tile_X0Y1_FrameData[12] Tile_X0Y1_FrameStrobe[9] Tile_X0Y1_DSP_bot.Inst_DSP_bot_ConfigMem.Inst_frame9_bit12.Q
+ VPWR VGND sg13g2_dlhq_1
X_4849_ VGND VPWR _0022_ Tile_X0Y0_DSP_top.Inst_DSP_top_ConfigMem.Inst_frame1_bit4.Q
+ _0592_ Tile_X0Y0_DSP_top.Inst_DSP_top_ConfigMem.Inst_frame1_bit5.Q sg13g2_a21oi_1
X_5898_ Tile_X0Y1_FrameData[17] Tile_X0Y1_FrameStrobe[7] Tile_X0Y1_DSP_bot.Inst_DSP_bot_ConfigMem.Inst_frame7_bit17.Q
+ VPWR VGND sg13g2_dlhq_1
XFILLER_73_10 VPWR VGND sg13g2_fill_1
XFILLER_93_154 VPWR VGND sg13g2_fill_1
X_3180_ Tile_X0Y0_DSP_top.Inst_DSP_top_switch_matrix.inst_cus_mux41_buf_top2bot9.X
+ _1551_ _1552_ _1545_ Tile_X0Y0_DSP_top.Inst_DSP_top_ConfigMem.Inst_frame8_bit12.Q
+ VPWR VGND sg13g2_a22oi_1
XFILLER_78_173 VPWR VGND sg13g2_fill_2
XFILLER_81_338 VPWR VGND sg13g2_fill_1
X_2964_ _1331_ _1324_ _1341_ VPWR VGND sg13g2_xor2_1
XFILLER_34_287 VPWR VGND sg13g2_fill_1
XFILLER_34_221 VPWR VGND sg13g2_fill_1
X_5752_ Tile_X0Y1_FrameData[3] Tile_X0Y1_FrameStrobe[2] Tile_X0Y1_DSP_bot.Inst_DSP_bot_ConfigMem.Inst_frame2_bit3.Q
+ VPWR VGND sg13g2_dlhq_1
X_5821_ Tile_X0Y1_FrameData[30] Tile_X0Y1_FrameStrobe[5] Tile_X0Y1_DSP_bot.Inst_DSP_bot_ConfigMem.Inst_frame5_bit30.Q
+ VPWR VGND sg13g2_dlhq_1
X_4565_ _0320_ Tile_X0Y0_DSP_top.Inst_DSP_top_ConfigMem.Inst_frame3_bit8.Q Tile_X0Y0_DSP_top.Inst_DSP_top_switch_matrix.bot2top6
+ VPWR VGND sg13g2_nand2b_1
X_4703_ VGND VPWR _0452_ _0451_ _0449_ sg13g2_or2_1
X_2895_ _1216_ _1272_ _1273_ VPWR VGND sg13g2_nor2_1
X_5683_ Tile_X0Y1_FrameData[8] Tile_X0Y1_FrameStrobe[0] Tile_X0Y1_DSP_bot.Inst_DSP_bot_ConfigMem.Inst_frame0_bit8.Q
+ VPWR VGND sg13g2_dlhq_1
X_4634_ Tile_X0Y0_DSP_top.Inst_DSP_top_switch_matrix.N2BEGb3 _0380_ _0386_ _0374_
+ _0372_ VPWR VGND sg13g2_a22oi_1
X_6235_ Tile_X0Y0_DSP_top.Inst_DSP_top_switch_matrix.N1BEG3 Tile_X0Y0_N1BEG[3] VPWR
+ VGND sg13g2_buf_1
X_4496_ Tile_X0Y0_DSP_top.Inst_DSP_top_ConfigMem.Inst_frame5_bit25.Q Tile_X0Y1_N2MID[7]
+ Tile_X0Y0_S2END[7] Tile_X0Y0_E2END[7] Tile_X0Y0_WW4END[0] Tile_X0Y0_DSP_top.Inst_DSP_top_ConfigMem.Inst_frame5_bit24.Q
+ _0254_ VPWR VGND sg13g2_mux4_1
X_6166_ Tile_X0Y0_EE4END[6] Tile_X0Y0_EE4BEG[2] VPWR VGND sg13g2_buf_1
X_6304_ Tile_X0Y0_W2MID[7] Tile_X0Y0_W2BEGb[7] VPWR VGND sg13g2_buf_1
X_3378_ Tile_X0Y1_DSP_bot.Inst_DSP_bot_ConfigMem.Inst_frame2_bit25.Q VPWR _1740_ VGND
+ Tile_X0Y1_DSP_bot.Inst_DSP_bot_ConfigMem.Inst_frame2_bit24.Q Tile_X0Y1_DSP_bot.Inst_DSP_bot_switch_matrix.Q7
+ sg13g2_o21ai_1
X_3447_ _1796_ VPWR Tile_X0Y1_DSP_bot.C5 VGND _1803_ _1804_ sg13g2_o21ai_1
X_3516_ _1870_ _0072_ Tile_X0Y1_DSP_bot.C2 VPWR VGND sg13g2_nand2_1
X_5117_ VGND VPWR Tile_X0Y0_DSP_top.Inst_DSP_top_ConfigMem.Inst_frame2_bit18.Q _0845_
+ _0847_ _0846_ sg13g2_a21oi_1
X_6097_ VPWR VGND _2495_ sg13g2_tiehi
XFILLER_69_173 VPWR VGND sg13g2_fill_1
XFILLER_57_357 VPWR VGND sg13g2_decap_4
X_5048_ Tile_X0Y1_DSP_bot.Inst_DSP_bot_ConfigMem.Inst_frame9_bit28.Q VPWR _0782_ VGND
+ Tile_X0Y1_DSP_bot.Inst_DSP_bot_ConfigMem.Inst_frame0_bit7.Q _0781_ sg13g2_o21ai_1
XFILLER_75_154 VPWR VGND sg13g2_fill_1
XFILLER_0_331 VPWR VGND sg13g2_decap_4
XFILLER_84_42 VPWR VGND sg13g2_fill_2
XFILLER_71_360 VPWR VGND sg13g2_fill_1
X_2680_ VGND VPWR _1066_ _1065_ _1061_ sg13g2_or2_1
XFILLER_98_213 VPWR VGND sg13g2_fill_2
X_4350_ VPWR _0113_ Tile_X0Y0_DSP_top.Inst_DSP_top_ConfigMem.Inst_frame8_bit26.Q VGND
+ sg13g2_inv_1
X_4281_ VPWR _0044_ Tile_X0Y0_DSP_top.Inst_DSP_top_ConfigMem.Inst_frame2_bit12.Q VGND
+ sg13g2_inv_1
X_6020_ Tile_X0Y1_FrameData[23] Tile_X0Y1_FrameStrobe[11] Tile_X0Y1_DSP_bot.Inst_DSP_bot_ConfigMem.Inst_frame11_bit23.Q
+ VPWR VGND sg13g2_dlhq_1
X_3301_ Tile_X0Y1_DSP_bot.Inst_DSP_bot_ConfigMem.Inst_frame2_bit29.Q _0467_ Tile_X0Y1_W1END[0]
+ Tile_X0Y0_S2MID[0] Tile_X0Y1_W1END[2] Tile_X0Y1_DSP_bot.Inst_DSP_bot_ConfigMem.Inst_frame2_bit28.Q
+ _1668_ VPWR VGND sg13g2_mux4_1
X_3232_ _1600_ VPWR _1601_ VGND Tile_X0Y1_DSP_bot.Inst_DSP_bot_ConfigMem.Inst_frame3_bit28.Q
+ Tile_X0Y1_DSP_bot.Inst_DSP_bot_switch_matrix.Q4 sg13g2_o21ai_1
X_3094_ Tile_X0Y0_DSP_top.Inst_DSP_top_ConfigMem.Inst_frame1_bit22.Q VPWR _1471_ VGND
+ Tile_X0Y0_DSP_top.Inst_DSP_top_ConfigMem.Inst_frame1_bit21.Q _1468_ sg13g2_o21ai_1
X_3163_ Tile_X0Y0_DSP_top.Inst_DSP_top_switch_matrix.N2BEGb3 Tile_X0Y0_E2MID[3] Tile_X0Y0_DSP_top.Inst_DSP_top_ConfigMem.Inst_frame6_bit18.Q
+ _1536_ VPWR VGND sg13g2_mux2_1
X_3996_ Tile_X0Y0_DSP_top.Inst_DSP_top_ConfigMem.Inst_frame10_bit27.Q Tile_X0Y0_DSP_top.Inst_DSP_top_switch_matrix.bot2top9
+ _1510_ _2015_ _0603_ Tile_X0Y0_DSP_top.Inst_DSP_top_ConfigMem.Inst_frame10_bit28.Q
+ _2284_ VPWR VGND sg13g2_mux4_1
XFILLER_62_360 VPWR VGND sg13g2_fill_1
X_2947_ _1324_ _1273_ _1279_ VPWR VGND sg13g2_xnor2_1
X_5735_ Tile_X0Y1_FrameData[20] Tile_X0Y1_FrameStrobe[2] Tile_X0Y1_DSP_bot.Inst_DSP_bot_ConfigMem.Inst_frame2_bit20.Q
+ VPWR VGND sg13g2_dlhq_1
X_5804_ Tile_X0Y1_FrameData[15] Tile_X0Y1_FrameStrobe[4] Tile_X0Y1_DSP_bot.Inst_DSP_bot_ConfigMem.Inst_frame4_bit15.Q
+ VPWR VGND sg13g2_dlhq_1
XFILLER_108_318 VPWR VGND sg13g2_fill_2
X_4548_ VGND VPWR Tile_X0Y0_DSP_top.Inst_DSP_top_ConfigMem.Inst_frame4_bit25.Q _0303_
+ _0304_ _0066_ sg13g2_a21oi_1
X_5597_ Tile_X0Y0_FrameData[16] Tile_X0Y1_FrameStrobe[12] Tile_X0Y0_DSP_top.Inst_DSP_top_ConfigMem.Inst_frame12_bit16.Q
+ VPWR VGND sg13g2_dlhq_1
X_2878_ VGND VPWR Tile_X0Y1_DSP_bot.Inst_DSP_bot_ConfigMem.Inst_frame8_bit0.Q _1255_
+ _1257_ Tile_X0Y1_DSP_bot.Inst_DSP_bot_ConfigMem.Inst_frame8_bit1.Q sg13g2_a21oi_1
X_5666_ Tile_X0Y1_FrameData[25] Tile_X0Y1_FrameStrobe[0] Tile_X0Y1_DSP_bot.Inst_DSP_bot_ConfigMem.Inst_frame0_bit25.Q
+ VPWR VGND sg13g2_dlhq_1
X_4617_ VGND VPWR Tile_X0Y1_DSP_bot.Inst_DSP_bot_ConfigMem.Inst_frame4_bit12.Q _0126_
+ _0370_ _0369_ sg13g2_a21oi_1
X_4479_ _0238_ _0237_ Tile_X0Y0_DSP_top.Inst_DSP_top_ConfigMem.Inst_frame4_bit16.Q
+ VPWR VGND sg13g2_nand2b_1
X_6218_ Tile_X0Y1_FrameStrobe[6] Tile_X0Y0_FrameStrobe_O[6] VPWR VGND sg13g2_buf_1
X_6149_ Tile_X0Y0_E2MID[5] Tile_X0Y0_E2BEGb[5] VPWR VGND sg13g2_buf_1
XFILLER_89_268 VPWR VGND sg13g2_fill_1
XFILLER_54_34 VPWR VGND sg13g2_fill_2
XFILLER_53_360 VPWR VGND sg13g2_fill_1
XFILLER_45_349 VPWR VGND sg13g2_fill_2
X_3781_ _2110_ Tile_X0Y0_DSP_top.Inst_DSP_top_ConfigMem.Inst_frame8_bit29.Q Tile_X0Y0_DSP_top.Inst_DSP_top_switch_matrix.JN2BEG7
+ VPWR VGND sg13g2_nand2_1
X_3850_ _2170_ VPWR _2171_ VGND Tile_X0Y0_DSP_top.Inst_DSP_top_ConfigMem.Inst_frame1_bit1.Q
+ _2169_ sg13g2_o21ai_1
X_2801_ Tile_X0Y1_DSP_bot.Inst_DSP_bot_ConfigMem.Inst_frame9_bit23.Q _1181_ _1182_
+ VPWR VGND sg13g2_nor2_1
X_5451_ Tile_X0Y0_FrameData[2] Tile_X0Y1_FrameStrobe[7] Tile_X0Y0_DSP_top.Inst_DSP_top_ConfigMem.Inst_frame7_bit2.Q
+ VPWR VGND sg13g2_dlhq_1
X_2594_ _0982_ VPWR _0983_ VGND Tile_X0Y0_DSP_top.Inst_DSP_top_ConfigMem.Inst_frame9_bit28.Q
+ _0981_ sg13g2_o21ai_1
X_5382_ Tile_X0Y0_FrameData[7] Tile_X0Y1_FrameStrobe[5] Tile_X0Y0_DSP_top.Inst_DSP_top_ConfigMem.Inst_frame5_bit7.Q
+ VPWR VGND sg13g2_dlhq_1
X_5520_ Tile_X0Y0_FrameData[29] Tile_X0Y1_FrameStrobe[10] Tile_X0Y0_DSP_top.Inst_DSP_top_ConfigMem.Inst_frame10_bit29.Q
+ VPWR VGND sg13g2_dlhq_1
X_2732_ _1115_ Tile_X0Y1_DSP_bot.Inst_DSP_bot_ConfigMem.Inst_frame2_bit18.Q _1116_
+ VPWR VGND sg13g2_nor2b_1
X_4402_ Tile_X0Y1_W2END[3] Tile_X0Y1_W6END[1] Tile_X0Y1_DSP_bot.Inst_DSP_bot_ConfigMem.Inst_frame3_bit8.Q
+ _0164_ VPWR VGND sg13g2_mux2_1
X_2663_ VGND VPWR Tile_X0Y1_DSP_bot.Inst_DSP_bot_ConfigMem.Inst_frame3_bit4.Q _0126_
+ _1050_ Tile_X0Y1_DSP_bot.Inst_DSP_bot_ConfigMem.Inst_frame3_bit5.Q sg13g2_a21oi_1
X_3215_ _1585_ _1584_ _1432_ VPWR VGND sg13g2_nand2b_1
X_4333_ VPWR _0096_ Tile_X0Y1_DSP_bot.Inst_MULADD.C_reg\[9\] VGND sg13g2_inv_1
X_4264_ VPWR _0027_ Tile_X0Y1_DSP_bot.Inst_DSP_bot_ConfigMem.Inst_frame3_bit9.Q VGND
+ sg13g2_inv_1
X_6003_ Tile_X0Y1_FrameData[8] Tile_X0Y1_FrameStrobe[10] Tile_X0Y1_DSP_bot.Inst_DSP_bot_ConfigMem.Inst_frame10_bit8.Q
+ VPWR VGND sg13g2_dlhq_1
X_4195_ _2436_ Tile_X0Y1_DSP_bot.Inst_DSP_bot_ConfigMem.Inst_frame9_bit11.Q _0894_
+ VPWR VGND sg13g2_nand2_1
X_3146_ Tile_X0Y0_DSP_top.Inst_DSP_top_ConfigMem.Inst_frame3_bit21.Q Tile_X0Y0_DSP_top.Inst_DSP_top_switch_matrix.bot2top4
+ Tile_X0Y0_DSP_top.Inst_DSP_top_switch_matrix.bot2top7 Tile_X0Y0_DSP_top.Inst_DSP_top_switch_matrix.bot2top6
+ Tile_X0Y0_DSP_top.Inst_DSP_top_switch_matrix.bot2top9 Tile_X0Y0_DSP_top.Inst_DSP_top_ConfigMem.Inst_frame3_bit20.Q
+ _1520_ VPWR VGND sg13g2_mux4_1
X_3077_ _1454_ _1451_ _1453_ VPWR VGND sg13g2_xnor2_1
X_3979_ VGND VPWR _0121_ _0129_ _2269_ Tile_X0Y0_DSP_top.Inst_DSP_top_ConfigMem.Inst_frame10_bit22.Q
+ sg13g2_a21oi_1
X_5718_ Tile_X0Y1_FrameData[5] Tile_X0Y1_FrameStrobe[1] Tile_X0Y1_DSP_bot.Inst_DSP_bot_ConfigMem.Inst_frame1_bit5.Q
+ VPWR VGND sg13g2_dlhq_1
XFILLER_49_34 VPWR VGND sg13g2_fill_1
X_5649_ _2521_ VGND VPWR Tile_X0Y1_DSP_bot.C9 Tile_X0Y1_DSP_bot.Inst_MULADD.C_reg\[9\]
+ clknet_3_2_0_Tile_X0Y1_UserCLK_regs sg13g2_dfrbpq_1
XFILLER_92_208 VPWR VGND sg13g2_fill_1
XFILLER_65_11 VPWR VGND sg13g2_fill_1
XANTENNA_123 VPWR VGND Tile_X0Y0_W2MID[7] sg13g2_antennanp
XANTENNA_101 VPWR VGND Tile_X0Y0_S2MID[4] sg13g2_antennanp
XANTENNA_145 VPWR VGND Tile_X0Y0_S4END[6] sg13g2_antennanp
XANTENNA_112 VPWR VGND Tile_X0Y0_S2MID[4] sg13g2_antennanp
XANTENNA_134 VPWR VGND Tile_X0Y0_S4END[6] sg13g2_antennanp
XFILLER_91_252 VPWR VGND sg13g2_fill_1
XFILLER_91_230 VPWR VGND sg13g2_fill_1
X_4951_ _0684_ _0078_ _0687_ _0688_ VPWR VGND sg13g2_a21o_1
X_3000_ _1377_ _1127_ _1187_ VPWR VGND sg13g2_nand2_1
XFILLER_36_124 VPWR VGND sg13g2_fill_2
X_3833_ VGND VPWR _2152_ _2154_ Tile_X0Y0_DSP_top.Inst_DSP_top_switch_matrix.JS2BEG5
+ _2147_ sg13g2_a21oi_1
X_3764_ VGND VPWR Tile_X0Y0_DSP_top.Inst_DSP_top_ConfigMem.Inst_frame1_bit29.Q _2091_
+ _2094_ _2093_ sg13g2_a21oi_1
X_3902_ _2202_ _2201_ Tile_X0Y0_DSP_top.Inst_DSP_top_ConfigMem.Inst_frame12_bit28.Q
+ Tile_X0Y0_DSP_top.Inst_DSP_top_switch_matrix.NN4BEG0 VPWR VGND sg13g2_mux2_1
X_4882_ VPWR VGND _0622_ Tile_X0Y0_DSP_top.Inst_DSP_top_ConfigMem.Inst_frame2_bit14.Q
+ _0621_ Tile_X0Y0_DSP_top.Inst_DSP_top_ConfigMem.Inst_frame2_bit13.Q _0623_ _0620_
+ sg13g2_a221oi_1
X_5365_ Tile_X0Y0_FrameData[24] Tile_X0Y1_FrameStrobe[5] Tile_X0Y0_DSP_top.Inst_DSP_top_ConfigMem.Inst_frame5_bit24.Q
+ VPWR VGND sg13g2_dlhq_1
X_5434_ Tile_X0Y0_FrameData[19] Tile_X0Y1_FrameStrobe[7] Tile_X0Y0_DSP_top.Inst_DSP_top_ConfigMem.Inst_frame7_bit19.Q
+ VPWR VGND sg13g2_dlhq_1
X_5503_ Tile_X0Y0_FrameData[14] Tile_X0Y1_FrameStrobe[9] Tile_X0Y0_DSP_top.Inst_DSP_top_ConfigMem.Inst_frame9_bit14.Q
+ VPWR VGND sg13g2_dlhq_1
X_3695_ _2029_ _2022_ _2026_ VPWR VGND sg13g2_nand2_1
X_2577_ VGND VPWR Tile_X0Y0_DSP_top.Inst_DSP_top_switch_matrix.inst_cus_mux41_buf_top2bot0.X
+ _0966_ _0963_ sg13g2_or2_1
X_6483_ Tile_X0Y1_W2MID[6] Tile_X0Y1_W2BEGb[6] VPWR VGND sg13g2_buf_1
X_2715_ _1099_ VPWR Tile_X0Y1_DSP_bot.Inst_DSP_bot_switch_matrix.JS2BEG2 VGND _1089_
+ _1095_ sg13g2_o21ai_1
X_2646_ VGND VPWR _0024_ Tile_X0Y1_DSP_bot.Inst_DSP_bot_ConfigMem.Inst_frame3_bit12.Q
+ _1034_ _1033_ sg13g2_a21oi_1
X_5296_ Tile_X0Y0_FrameData[29] Tile_X0Y1_FrameStrobe[3] Tile_X0Y0_DSP_top.Inst_DSP_top_ConfigMem.Inst_frame3_bit29.Q
+ VPWR VGND sg13g2_dlhq_1
X_4247_ Tile_X0Y1_DSP_bot.Inst_DSP_bot_switch_matrix.clr _1957_ _0010_ VPWR VGND sg13g2_nor2_1
XFILLER_59_249 VPWR VGND sg13g2_fill_1
X_4316_ VPWR _0079_ Tile_X0Y1_DSP_bot.Inst_DSP_bot_ConfigMem.Inst_frame3_bit14.Q VGND
+ sg13g2_inv_1
X_4178_ Tile_X0Y1_DSP_bot.Inst_DSP_bot_ConfigMem.Inst_frame9_bit2.Q Tile_X0Y1_DSP_bot.Inst_DSP_bot_switch_matrix.Q6
+ _1019_ _1256_ _1783_ Tile_X0Y1_DSP_bot.Inst_DSP_bot_ConfigMem.Inst_frame9_bit3.Q
+ _2422_ VPWR VGND sg13g2_mux4_1
X_3129_ _1504_ _1502_ _1503_ Tile_X0Y1_DSP_bot.Inst_MULADD.ACC\[13\] Tile_X0Y1_DSP_bot.Inst_DSP_bot_ConfigMem.Inst_frame12_bit3.Q
+ VPWR VGND sg13g2_a22oi_1
XFILLER_2_267 VPWR VGND sg13g2_decap_8
XFILLER_73_285 VPWR VGND sg13g2_fill_1
X_3480_ _1836_ _1420_ _1421_ VPWR VGND sg13g2_xnor2_1
XFILLER_110_165 VPWR VGND sg13g2_fill_1
X_4032_ Tile_X0Y0_DSP_top.Inst_DSP_top_ConfigMem.Inst_frame9_bit18.Q _1537_ _2315_
+ VPWR VGND sg13g2_nor2_1
X_5081_ VGND VPWR Tile_X0Y0_DSP_top.Inst_DSP_top_ConfigMem.Inst_frame8_bit8.Q _0466_
+ _0813_ Tile_X0Y0_DSP_top.Inst_DSP_top_ConfigMem.Inst_frame8_bit9.Q sg13g2_a21oi_1
XFILLER_49_271 VPWR VGND sg13g2_fill_2
X_4101_ Tile_X0Y1_DSP_bot.Inst_DSP_bot_ConfigMem.Inst_frame2_bit0.Q Tile_X0Y0_S2MID[1]
+ _2363_ VPWR VGND sg13g2_nor2b_1
X_5150_ Tile_X0Y1_DSP_bot.Inst_DSP_bot_ConfigMem.Inst_frame2_bit4.Q Tile_X0Y1_DSP_bot.Inst_DSP_bot_switch_matrix.Q0
+ Tile_X0Y1_DSP_bot.Inst_DSP_bot_switch_matrix.Q2 Tile_X0Y1_DSP_bot.Inst_DSP_bot_switch_matrix.Q3
+ Tile_X0Y1_DSP_bot.Inst_DSP_bot_switch_matrix.Q4 Tile_X0Y1_DSP_bot.Inst_DSP_bot_ConfigMem.Inst_frame2_bit5.Q
+ _0878_ VPWR VGND sg13g2_mux4_1
XFILLER_64_241 VPWR VGND sg13g2_decap_8
Xclkbuf_regs_0_Tile_X0Y1_UserCLK Tile_X0Y1_UserCLK Tile_X0Y1_UserCLK_regs VPWR VGND
+ sg13g2_buf_8
X_4934_ VGND VPWR _0055_ Tile_X0Y1_DSP_bot.Inst_DSP_bot_ConfigMem.Inst_frame4_bit16.Q
+ _0673_ _0672_ sg13g2_a21oi_1
X_5983_ Tile_X0Y1_FrameData[28] Tile_X0Y1_FrameStrobe[10] Tile_X0Y1_DSP_bot.Inst_DSP_bot_ConfigMem.Inst_frame10_bit28.Q
+ VPWR VGND sg13g2_dlhq_1
XANTENNA_45 VPWR VGND Tile_X0Y1_N4END[15] sg13g2_antennanp
XANTENNA_34 VPWR VGND Tile_X0Y1_N4END[10] sg13g2_antennanp
XANTENNA_56 VPWR VGND Tile_X0Y0_E6END[8] sg13g2_antennanp
X_3747_ Tile_X0Y0_DSP_top.Inst_DSP_top_ConfigMem.Inst_frame1_bit30.Q _2076_ _2077_
+ VPWR VGND sg13g2_nor2_1
XANTENNA_78 VPWR VGND Tile_X0Y0_FrameData[6] sg13g2_antennanp
XANTENNA_67 VPWR VGND Tile_X0Y0_FrameData[6] sg13g2_antennanp
XANTENNA_12 VPWR VGND Tile_X0Y0_S4END[0] sg13g2_antennanp
X_4865_ VPWR Tile_X0Y0_DSP_top.Inst_DSP_top_switch_matrix.inst_cus_mux41_buf_top2bot3.X
+ _0606_ VGND sg13g2_inv_1
XANTENNA_89 VPWR VGND Tile_X0Y0_S2MID[4] sg13g2_antennanp
X_3816_ _2139_ _1930_ _1931_ VPWR VGND sg13g2_xnor2_1
X_4796_ Tile_X0Y1_DSP_bot.Inst_DSP_bot_ConfigMem.Inst_frame4_bit2.Q VPWR _0540_ VGND
+ Tile_X0Y1_DSP_bot.Inst_DSP_bot_ConfigMem.Inst_frame4_bit1.Q _0537_ sg13g2_o21ai_1
XANTENNA_23 VPWR VGND Tile_X0Y1_EE4END[10] sg13g2_antennanp
X_5348_ Tile_X0Y0_FrameData[9] Tile_X0Y1_FrameStrobe[4] Tile_X0Y0_DSP_top.Inst_DSP_top_ConfigMem.Inst_frame4_bit9.Q
+ VPWR VGND sg13g2_dlhq_1
XFILLER_99_182 VPWR VGND sg13g2_decap_4
X_3678_ Tile_X0Y0_DSP_top.Inst_DSP_top_ConfigMem.Inst_frame8_bit22.Q VPWR _2014_ VGND
+ _2012_ _2013_ sg13g2_o21ai_1
X_2629_ _1016_ _0745_ _1017_ VPWR VGND sg13g2_xor2_1
X_5417_ Tile_X0Y0_FrameData[4] Tile_X0Y1_FrameStrobe[6] Tile_X0Y0_DSP_top.Inst_DSP_top_ConfigMem.Inst_frame6_bit4.Q
+ VPWR VGND sg13g2_dlhq_1
X_6397_ Tile_X0Y1_FrameData[16] Tile_X0Y1_FrameData_O[16] VPWR VGND sg13g2_buf_1
X_6466_ Tile_X0Y1_DSP_bot.Inst_DSP_bot_switch_matrix.W1BEG1 Tile_X0Y1_W1BEG[1] VPWR
+ VGND sg13g2_buf_1
X_5279_ Tile_X0Y0_FrameData[14] Tile_X0Y1_FrameStrobe[2] Tile_X0Y0_DSP_top.Inst_DSP_top_ConfigMem.Inst_frame2_bit14.Q
+ VPWR VGND sg13g2_dlhq_1
XFILLER_70_299 VPWR VGND sg13g2_fill_2
XFILLER_7_304 VPWR VGND sg13g2_decap_4
XFILLER_109_243 VPWR VGND sg13g2_fill_1
XFILLER_109_221 VPWR VGND sg13g2_fill_1
XFILLER_93_358 VPWR VGND sg13g2_fill_2
XFILLER_61_222 VPWR VGND sg13g2_decap_8
XFILLER_61_200 VPWR VGND sg13g2_fill_1
X_2980_ _1357_ _1326_ _1353_ VPWR VGND sg13g2_xnor2_1
X_4650_ Tile_X0Y0_DSP_top.Inst_DSP_top_ConfigMem.Inst_frame1_bit17.Q Tile_X0Y0_S1END[1]
+ Tile_X0Y0_S2END[5] Tile_X0Y0_S1END[3] Tile_X0Y0_W1END[1] Tile_X0Y0_DSP_top.Inst_DSP_top_ConfigMem.Inst_frame1_bit16.Q
+ _0402_ VPWR VGND sg13g2_mux4_1
X_4581_ VPWR VGND _0335_ Tile_X0Y0_DSP_top.Inst_DSP_top_ConfigMem.Inst_frame3_bit11.Q
+ _0332_ _0328_ _0336_ _0330_ sg13g2_a221oi_1
X_6320_ Tile_X0Y0_WW4END[7] Tile_X0Y0_WW4BEG[3] VPWR VGND sg13g2_buf_1
X_3601_ _1949_ VPWR Tile_X0Y1_DSP_bot.Inst_DSP_bot_switch_matrix.Q4 VGND Tile_X0Y1_DSP_bot.Inst_DSP_bot_ConfigMem.Inst_frame12_bit5.Q
+ _1948_ sg13g2_o21ai_1
X_6251_ Tile_X0Y0_DSP_top.Inst_DSP_top_switch_matrix.N2BEGb7 Tile_X0Y0_N2BEGb[7] VPWR
+ VGND sg13g2_buf_1
X_6182_ Tile_X0Y0_FrameData[2] Tile_X0Y0_FrameData_O[2] VPWR VGND sg13g2_buf_1
X_5202_ Tile_X0Y0_FrameData[27] Tile_X0Y1_FrameStrobe[0] Tile_X0Y0_DSP_top.Inst_DSP_top_ConfigMem.Inst_frame0_bit27.Q
+ VPWR VGND sg13g2_dlhq_1
X_5133_ VGND VPWR Tile_X0Y0_E2MID[5] Tile_X0Y0_DSP_top.Inst_DSP_top_ConfigMem.Inst_frame6_bit12.Q
+ _0862_ Tile_X0Y0_DSP_top.Inst_DSP_top_ConfigMem.Inst_frame6_bit13.Q sg13g2_a21oi_1
X_3394_ _1736_ _1754_ Tile_X0Y1_DSP_bot.C8 VPWR VGND sg13g2_nor2_1
X_3532_ Tile_X0Y1_DSP_bot.Inst_DSP_bot_ConfigMem.Inst_frame6_bit18.Q Tile_X0Y1_N2MID[3]
+ Tile_X0Y1_E2MID[3] Tile_X0Y0_DSP_top.Inst_DSP_top_switch_matrix.JS2BEG3 Tile_X0Y1_W2MID[3]
+ Tile_X0Y1_DSP_bot.Inst_DSP_bot_ConfigMem.Inst_frame6_bit19.Q _1886_ VPWR VGND sg13g2_mux4_1
X_3463_ _1819_ VPWR _1820_ VGND Tile_X0Y1_N2MID[7] Tile_X0Y1_DSP_bot.Inst_DSP_bot_ConfigMem.Inst_frame6_bit24.Q
+ sg13g2_o21ai_1
X_5064_ Tile_X0Y0_DSP_top.Inst_DSP_top_ConfigMem.Inst_frame1_bit9.Q Tile_X0Y0_S2END[3]
+ Tile_X0Y0_W2END[3] Tile_X0Y0_S4END[3] Tile_X0Y0_W6END[1] Tile_X0Y0_DSP_top.Inst_DSP_top_ConfigMem.Inst_frame1_bit8.Q
+ _0797_ VPWR VGND sg13g2_mux4_1
XFILLER_96_174 VPWR VGND sg13g2_decap_4
X_4015_ VPWR Tile_X0Y0_DSP_top.Inst_DSP_top_switch_matrix.WW4BEG1 _2300_ VGND sg13g2_inv_1
XFILLER_37_263 VPWR VGND sg13g2_fill_2
X_4917_ Tile_X0Y1_N4END[5] Tile_X0Y0_EE4END[1] Tile_X0Y0_DSP_top.Inst_DSP_top_ConfigMem.Inst_frame3_bit0.Q
+ _0657_ VPWR VGND sg13g2_mux2_1
X_4848_ _0590_ VPWR _0591_ VGND Tile_X0Y0_DSP_top.Inst_DSP_top_ConfigMem.Inst_frame1_bit5.Q
+ _0588_ sg13g2_o21ai_1
XFILLER_52_266 VPWR VGND sg13g2_fill_2
X_5966_ Tile_X0Y1_FrameData[13] Tile_X0Y1_FrameStrobe[9] Tile_X0Y1_DSP_bot.Inst_DSP_bot_ConfigMem.Inst_frame9_bit13.Q
+ VPWR VGND sg13g2_dlhq_1
XFILLER_12_119 VPWR VGND sg13g2_fill_2
X_5897_ Tile_X0Y1_FrameData[18] Tile_X0Y1_FrameStrobe[7] Tile_X0Y1_DSP_bot.Inst_DSP_bot_ConfigMem.Inst_frame7_bit18.Q
+ VPWR VGND sg13g2_dlhq_1
X_6449_ Tile_X0Y0_SS4END[8] Tile_X0Y1_SS4BEG[0] VPWR VGND sg13g2_buf_1
X_4779_ Tile_X0Y0_DSP_top.Inst_DSP_top_ConfigMem.Inst_frame8_bit2.Q VPWR _0524_ VGND
+ _0522_ _0523_ sg13g2_o21ai_1
XFILLER_22_81 VPWR VGND sg13g2_fill_1
XFILLER_19_241 VPWR VGND sg13g2_fill_1
X_4702_ Tile_X0Y0_DSP_top.Inst_DSP_top_ConfigMem.Inst_frame3_bit14.Q VPWR _0451_ VGND
+ Tile_X0Y0_DSP_top.Inst_DSP_top_ConfigMem.Inst_frame3_bit13.Q _0450_ sg13g2_o21ai_1
X_2963_ VPWR _1340_ _1339_ VGND sg13g2_inv_1
X_5751_ Tile_X0Y1_FrameData[4] Tile_X0Y1_FrameStrobe[2] Tile_X0Y1_DSP_bot.Inst_DSP_bot_ConfigMem.Inst_frame2_bit4.Q
+ VPWR VGND sg13g2_dlhq_1
X_5820_ Tile_X0Y1_FrameData[31] Tile_X0Y1_FrameStrobe[5] Tile_X0Y1_DSP_bot.Inst_DSP_bot_ConfigMem.Inst_frame5_bit31.Q
+ VPWR VGND sg13g2_dlhq_1
X_4564_ _0318_ VPWR _0319_ VGND Tile_X0Y0_DSP_top.Inst_DSP_top_ConfigMem.Inst_frame3_bit9.Q
+ _0316_ sg13g2_o21ai_1
X_6303_ Tile_X0Y0_W2MID[6] Tile_X0Y0_W2BEGb[6] VPWR VGND sg13g2_buf_1
X_2894_ _1272_ _1187_ _0869_ _1076_ _0939_ VPWR VGND sg13g2_a22oi_1
X_5682_ Tile_X0Y1_FrameData[9] Tile_X0Y1_FrameStrobe[0] Tile_X0Y1_DSP_bot.Inst_DSP_bot_ConfigMem.Inst_frame0_bit9.Q
+ VPWR VGND sg13g2_dlhq_1
X_4633_ Tile_X0Y1_DSP_bot.Inst_DSP_bot_ConfigMem.Inst_frame4_bit15.Q _0385_ _0386_
+ VPWR VGND sg13g2_nor2_1
X_3515_ _1869_ Tile_X0Y1_DSP_bot.Inst_DSP_bot_ConfigMem.Inst_frame12_bit2.Q Tile_X0Y1_DSP_bot.Inst_MULADD.C_reg\[2\]
+ VPWR VGND sg13g2_nand2_1
X_6234_ Tile_X0Y0_DSP_top.Inst_DSP_top_switch_matrix.N1BEG2 Tile_X0Y0_N1BEG[2] VPWR
+ VGND sg13g2_buf_1
X_5116_ Tile_X0Y0_DSP_top.Inst_DSP_top_ConfigMem.Inst_frame2_bit19.Q VPWR _0846_ VGND
+ Tile_X0Y0_DSP_top.Inst_DSP_top_ConfigMem.Inst_frame2_bit18.Q _0844_ sg13g2_o21ai_1
XFILLER_103_227 VPWR VGND sg13g2_fill_1
X_4495_ VGND VPWR Tile_X0Y0_DSP_top.Inst_DSP_top_ConfigMem.Inst_frame0_bit25.Q _0249_
+ _0253_ _0252_ sg13g2_a21oi_1
X_6165_ Tile_X0Y0_EE4END[5] Tile_X0Y0_EE4BEG[1] VPWR VGND sg13g2_buf_1
X_3377_ _1738_ VPWR _1739_ VGND Tile_X0Y1_DSP_bot.Inst_DSP_bot_ConfigMem.Inst_frame2_bit24.Q
+ Tile_X0Y1_DSP_bot.Inst_DSP_bot_switch_matrix.Q4 sg13g2_o21ai_1
X_6096_ VPWR VGND _2494_ sg13g2_tiehi
X_3446_ Tile_X0Y1_DSP_bot.Inst_DSP_bot_ConfigMem.Inst_frame8_bit17.Q VPWR _1804_ VGND
+ _1798_ _1801_ sg13g2_o21ai_1
X_5047_ VGND VPWR Tile_X0Y1_E6END[0] Tile_X0Y1_DSP_bot.Inst_DSP_bot_ConfigMem.Inst_frame0_bit6.Q
+ _0781_ _0780_ sg13g2_a21oi_1
XFILLER_25_244 VPWR VGND sg13g2_fill_2
XFILLER_27_59 VPWR VGND sg13g2_decap_4
X_5949_ Tile_X0Y1_FrameData[30] Tile_X0Y1_FrameStrobe[9] Tile_X0Y1_DSP_bot.Inst_DSP_bot_ConfigMem.Inst_frame9_bit30.Q
+ VPWR VGND sg13g2_dlhq_1
XFILLER_108_51 VPWR VGND sg13g2_fill_2
XFILLER_63_306 VPWR VGND sg13g2_fill_2
XFILLER_0_343 VPWR VGND sg13g2_fill_1
XFILLER_16_211 VPWR VGND sg13g2_fill_1
X_4280_ VPWR _0043_ Tile_X0Y0_S4END[1] VGND sg13g2_inv_1
X_3162_ _1533_ _1534_ Tile_X0Y0_DSP_top.Inst_DSP_top_ConfigMem.Inst_frame6_bit19.Q
+ _1535_ VPWR VGND sg13g2_nand3_1
X_3300_ Tile_X0Y1_DSP_bot.Inst_DSP_bot_ConfigMem.Inst_frame2_bit28.Q Tile_X0Y1_N1END[0]
+ Tile_X0Y1_N2END[0] Tile_X0Y1_E1END[0] Tile_X0Y1_E2END[0] Tile_X0Y1_DSP_bot.Inst_DSP_bot_ConfigMem.Inst_frame2_bit29.Q
+ _1667_ VPWR VGND sg13g2_mux4_1
XFILLER_3_192 VPWR VGND sg13g2_fill_1
X_3231_ _1600_ Tile_X0Y1_DSP_bot.Inst_DSP_bot_ConfigMem.Inst_frame3_bit28.Q _0125_
+ VPWR VGND sg13g2_nand2_1
X_3093_ VGND VPWR Tile_X0Y0_DSP_top.Inst_DSP_top_ConfigMem.Inst_frame1_bit20.Q Tile_X0Y0_DSP_top.Inst_DSP_top_switch_matrix.bot2top9
+ _1470_ _1469_ sg13g2_a21oi_1
X_3995_ Tile_X0Y0_DSP_top.Inst_DSP_top_ConfigMem.Inst_frame10_bit28.Q _0237_ Tile_X0Y0_W1END[1]
+ Tile_X0Y0_E1END[1] Tile_X0Y0_DSP_top.Inst_DSP_top_switch_matrix.bot2top5 Tile_X0Y0_DSP_top.Inst_DSP_top_ConfigMem.Inst_frame10_bit27.Q
+ _2283_ VPWR VGND sg13g2_mux4_1
X_2946_ _1323_ _1322_ _1321_ VPWR VGND sg13g2_nand2b_1
X_5803_ Tile_X0Y1_FrameData[16] Tile_X0Y1_FrameStrobe[4] Tile_X0Y1_DSP_bot.Inst_DSP_bot_ConfigMem.Inst_frame4_bit16.Q
+ VPWR VGND sg13g2_dlhq_1
X_5734_ Tile_X0Y1_FrameData[21] Tile_X0Y1_FrameStrobe[2] Tile_X0Y1_DSP_bot.Inst_DSP_bot_ConfigMem.Inst_frame2_bit21.Q
+ VPWR VGND sg13g2_dlhq_1
X_2877_ VPWR _1256_ _1255_ VGND sg13g2_inv_1
X_5665_ Tile_X0Y1_FrameData[26] Tile_X0Y1_FrameStrobe[0] Tile_X0Y1_DSP_bot.Inst_DSP_bot_ConfigMem.Inst_frame0_bit26.Q
+ VPWR VGND sg13g2_dlhq_1
X_4547_ _0302_ VPWR _0303_ VGND Tile_X0Y0_W1END[1] Tile_X0Y0_DSP_top.Inst_DSP_top_ConfigMem.Inst_frame4_bit24.Q
+ sg13g2_o21ai_1
X_5596_ Tile_X0Y0_FrameData[17] Tile_X0Y1_FrameStrobe[12] Tile_X0Y0_DSP_top.Inst_DSP_top_ConfigMem.Inst_frame12_bit17.Q
+ VPWR VGND sg13g2_dlhq_1
XFILLER_1_107 VPWR VGND sg13g2_fill_2
X_4478_ Tile_X0Y1_DSP_bot.Inst_DSP_bot_ConfigMem.Inst_frame12_bit8.Q Tile_X0Y1_DSP_bot.Inst_DSP_bot_switch_matrix.Q3
+ _0209_ _0236_ _0223_ Tile_X0Y1_DSP_bot.Inst_DSP_bot_ConfigMem.Inst_frame12_bit9.Q
+ _0237_ VPWR VGND sg13g2_mux4_1
X_4616_ Tile_X0Y1_DSP_bot.Inst_DSP_bot_ConfigMem.Inst_frame4_bit12.Q Tile_X0Y1_DSP_bot.Inst_DSP_bot_switch_matrix.Q5
+ _0369_ VPWR VGND sg13g2_nor2_1
X_6217_ Tile_X0Y1_FrameStrobe[5] Tile_X0Y0_FrameStrobe_O[5] VPWR VGND sg13g2_buf_1
XFILLER_97_291 VPWR VGND sg13g2_fill_2
X_6148_ Tile_X0Y0_E2MID[4] Tile_X0Y0_E2BEGb[4] VPWR VGND sg13g2_buf_1
X_6079_ VPWR VGND _2477_ sg13g2_tiehi
XFILLER_57_166 VPWR VGND sg13g2_fill_2
X_3429_ _1787_ Tile_X0Y1_DSP_bot.Inst_DSP_bot_ConfigMem.Inst_frame12_bit2.Q Tile_X0Y1_DSP_bot.Inst_MULADD.C_reg\[6\]
+ VPWR VGND sg13g2_nand2b_1
XFILLER_107_330 VPWR VGND sg13g2_decap_8
XFILLER_9_218 VPWR VGND sg13g2_fill_2
X_3780_ _2102_ _2109_ Tile_X0Y0_DSP_top.Inst_DSP_top_switch_matrix.JN2BEG7 VPWR VGND
+ sg13g2_nor2_1
X_2731_ VGND VPWR _0055_ Tile_X0Y1_DSP_bot.Inst_DSP_bot_ConfigMem.Inst_frame2_bit16.Q
+ _1115_ _1114_ sg13g2_a21oi_1
X_2800_ VGND VPWR Tile_X0Y1_DSP_bot.Inst_DSP_bot_ConfigMem.Inst_frame6_bit1.Q _1177_
+ _1181_ _1180_ sg13g2_a21oi_1
X_5381_ Tile_X0Y0_FrameData[8] Tile_X0Y1_FrameStrobe[5] Tile_X0Y0_DSP_top.Inst_DSP_top_ConfigMem.Inst_frame5_bit8.Q
+ VPWR VGND sg13g2_dlhq_1
X_5450_ Tile_X0Y0_FrameData[3] Tile_X0Y1_FrameStrobe[7] Tile_X0Y0_DSP_top.Inst_DSP_top_ConfigMem.Inst_frame7_bit3.Q
+ VPWR VGND sg13g2_dlhq_1
X_2593_ VGND VPWR Tile_X0Y0_DSP_top.Inst_DSP_top_ConfigMem.Inst_frame9_bit28.Q _0979_
+ _0982_ Tile_X0Y0_DSP_top.Inst_DSP_top_ConfigMem.Inst_frame9_bit29.Q sg13g2_a21oi_1
X_4332_ VPWR _0095_ Tile_X0Y1_DSP_bot.Inst_DSP_bot_ConfigMem.Inst_frame1_bit30.Q VGND
+ sg13g2_inv_1
X_4401_ VPWR VGND _0162_ _0030_ _0160_ _0156_ _0163_ _0158_ sg13g2_a221oi_1
X_2662_ _1046_ _1048_ _0082_ _1049_ VPWR VGND sg13g2_nand3_1
X_3145_ _1519_ Tile_X0Y1_DSP_bot.Inst_DSP_bot_ConfigMem.Inst_frame12_bit3.Q Tile_X0Y1_DSP_bot.Inst_MULADD.ACC\[11\]
+ VPWR VGND sg13g2_nand2_1
X_3214_ _1430_ _1431_ _1323_ _1584_ VPWR VGND sg13g2_nand3_1
X_6002_ Tile_X0Y1_FrameData[9] Tile_X0Y1_FrameStrobe[10] Tile_X0Y1_DSP_bot.Inst_DSP_bot_ConfigMem.Inst_frame10_bit9.Q
+ VPWR VGND sg13g2_dlhq_1
X_4194_ Tile_X0Y1_DSP_bot.Inst_DSP_bot_ConfigMem.Inst_frame9_bit13.Q _2434_ _2435_
+ VPWR VGND sg13g2_nor2_1
X_4263_ VPWR _0026_ Tile_X0Y1_DSP_bot.Inst_DSP_bot_ConfigMem.Inst_frame1_bit14.Q VGND
+ sg13g2_inv_1
X_3076_ _1443_ _1452_ _1453_ VPWR VGND sg13g2_nor2_1
XFILLER_108_105 VPWR VGND sg13g2_fill_1
X_3978_ VGND VPWR _0121_ _0861_ _2268_ _2267_ sg13g2_a21oi_1
X_2929_ _1306_ Tile_X0Y1_DSP_bot.Inst_DSP_bot_ConfigMem.Inst_frame12_bit1.Q Tile_X0Y1_DSP_bot.Inst_MULADD.B_reg\[0\]
+ VPWR VGND sg13g2_nand2b_1
X_5648_ _2520_ VGND VPWR Tile_X0Y1_DSP_bot.C8 Tile_X0Y1_DSP_bot.Inst_MULADD.C_reg\[8\]
+ clknet_3_0_0_Tile_X0Y1_UserCLK_regs sg13g2_dfrbpq_1
X_5717_ Tile_X0Y1_FrameData[6] Tile_X0Y1_FrameStrobe[1] Tile_X0Y1_DSP_bot.Inst_DSP_bot_ConfigMem.Inst_frame1_bit6.Q
+ VPWR VGND sg13g2_dlhq_1
XFILLER_10_217 VPWR VGND sg13g2_fill_1
X_5579_ Tile_X0Y0_FrameData[2] Tile_X0Y1_FrameStrobe[11] Tile_X0Y0_DSP_top.Inst_DSP_top_ConfigMem.Inst_frame11_bit2.Q
+ VPWR VGND sg13g2_dlhq_1
XFILLER_85_272 VPWR VGND sg13g2_decap_4
XANTENNA_124 VPWR VGND Tile_X0Y0_W2MID[7] sg13g2_antennanp
XANTENNA_113 VPWR VGND Tile_X0Y0_S2MID[4] sg13g2_antennanp
XFILLER_45_136 VPWR VGND sg13g2_fill_2
XANTENNA_102 VPWR VGND Tile_X0Y0_S2MID[4] sg13g2_antennanp
XFILLER_81_11 VPWR VGND sg13g2_fill_1
XANTENNA_135 VPWR VGND Tile_X0Y0_S4END[6] sg13g2_antennanp
XANTENNA_146 VPWR VGND Tile_X0Y0_S4END[6] sg13g2_antennanp
X_3901_ Tile_X0Y0_DSP_top.Inst_DSP_top_ConfigMem.Inst_frame12_bit26.Q Tile_X0Y0_DSP_top.Inst_DSP_top_switch_matrix.N1END2
+ Tile_X0Y0_E1END[2] Tile_X0Y0_W1END[2] Tile_X0Y0_DSP_top.Inst_DSP_top_switch_matrix.bot2top2
+ Tile_X0Y0_DSP_top.Inst_DSP_top_ConfigMem.Inst_frame12_bit27.Q _2202_ VPWR VGND sg13g2_mux4_1
X_4881_ VGND VPWR _0044_ Tile_X0Y0_DSP_top.Inst_DSP_top_switch_matrix.bot2top0 _0622_
+ Tile_X0Y0_DSP_top.Inst_DSP_top_ConfigMem.Inst_frame2_bit13.Q sg13g2_a21oi_1
X_4950_ Tile_X0Y1_DSP_bot.Inst_DSP_bot_ConfigMem.Inst_frame1_bit18.Q VPWR _0687_ VGND
+ _0685_ _0686_ sg13g2_o21ai_1
X_3832_ VGND VPWR _0041_ _2153_ _2154_ Tile_X0Y0_DSP_top.Inst_DSP_top_ConfigMem.Inst_frame2_bit23.Q
+ sg13g2_a21oi_1
X_3763_ Tile_X0Y0_DSP_top.Inst_DSP_top_ConfigMem.Inst_frame1_bit30.Q VPWR _2093_ VGND
+ Tile_X0Y0_DSP_top.Inst_DSP_top_ConfigMem.Inst_frame1_bit29.Q _2092_ sg13g2_o21ai_1
X_5502_ Tile_X0Y0_FrameData[15] Tile_X0Y1_FrameStrobe[9] Tile_X0Y0_DSP_top.Inst_DSP_top_ConfigMem.Inst_frame9_bit15.Q
+ VPWR VGND sg13g2_dlhq_1
X_3694_ _2028_ VPWR Tile_X0Y0_DSP_top.Inst_DSP_top_switch_matrix.bot2top6 VGND Tile_X0Y1_DSP_bot.Inst_DSP_bot_ConfigMem.Inst_frame12_bit5.Q
+ _2027_ sg13g2_o21ai_1
XFILLER_65_0 VPWR VGND sg13g2_decap_8
X_6482_ Tile_X0Y1_W2MID[5] Tile_X0Y1_W2BEGb[5] VPWR VGND sg13g2_buf_1
X_2714_ _1099_ _1098_ Tile_X0Y1_DSP_bot.Inst_DSP_bot_ConfigMem.Inst_frame2_bit11.Q
+ VPWR VGND sg13g2_nand2b_1
X_5295_ Tile_X0Y0_FrameData[30] Tile_X0Y1_FrameStrobe[3] Tile_X0Y0_DSP_top.Inst_DSP_top_ConfigMem.Inst_frame3_bit30.Q
+ VPWR VGND sg13g2_dlhq_1
X_5364_ Tile_X0Y0_FrameData[25] Tile_X0Y1_FrameStrobe[5] Tile_X0Y0_DSP_top.Inst_DSP_top_ConfigMem.Inst_frame5_bit25.Q
+ VPWR VGND sg13g2_dlhq_1
X_5433_ Tile_X0Y0_FrameData[20] Tile_X0Y1_FrameStrobe[7] Tile_X0Y0_DSP_top.Inst_DSP_top_ConfigMem.Inst_frame7_bit20.Q
+ VPWR VGND sg13g2_dlhq_1
XFILLER_59_217 VPWR VGND sg13g2_fill_1
X_2576_ Tile_X0Y0_DSP_top.Inst_DSP_top_ConfigMem.Inst_frame9_bit27.Q _0965_ _0966_
+ VPWR VGND sg13g2_and2_1
X_4315_ VPWR _0078_ Tile_X0Y1_DSP_bot.Inst_DSP_bot_ConfigMem.Inst_frame1_bit17.Q VGND
+ sg13g2_inv_1
X_2645_ Tile_X0Y1_E6END[0] Tile_X0Y1_DSP_bot.Inst_DSP_bot_ConfigMem.Inst_frame3_bit12.Q
+ _1033_ VPWR VGND sg13g2_nor2_1
X_3128_ VGND VPWR Tile_X0Y1_DSP_bot.Inst_DSP_bot_ConfigMem.Inst_frame12_bit2.Q _0108_
+ _1503_ Tile_X0Y1_DSP_bot.Inst_DSP_bot_ConfigMem.Inst_frame12_bit3.Q sg13g2_a21oi_1
X_4246_ Tile_X0Y1_DSP_bot.Inst_DSP_bot_switch_matrix.clr _1956_ _0009_ VPWR VGND sg13g2_nor2b_1
X_4177_ Tile_X0Y1_DSP_bot.Inst_DSP_bot_ConfigMem.Inst_frame9_bit3.Q Tile_X0Y1_N1END[2]
+ Tile_X0Y1_W1END[2] _0422_ Tile_X0Y1_DSP_bot.Inst_DSP_bot_switch_matrix.Q2 Tile_X0Y1_DSP_bot.Inst_DSP_bot_ConfigMem.Inst_frame9_bit2.Q
+ _2421_ VPWR VGND sg13g2_mux4_1
X_3059_ _1434_ _1213_ _1435_ _1436_ VPWR VGND sg13g2_a21o_1
XFILLER_23_353 VPWR VGND sg13g2_fill_1
XFILLER_58_283 VPWR VGND sg13g2_fill_2
X_4031_ Tile_X0Y0_DSP_top.Inst_DSP_top_ConfigMem.Inst_frame9_bit18.Q Tile_X0Y0_DSP_top.Inst_DSP_top_switch_matrix.bot2top2
+ Tile_X0Y0_DSP_top.Inst_DSP_top_switch_matrix.bot2top3 Tile_X0Y0_DSP_top.Inst_DSP_top_switch_matrix.bot2top4
+ Tile_X0Y0_DSP_top.Inst_DSP_top_switch_matrix.bot2top5 Tile_X0Y0_DSP_top.Inst_DSP_top_ConfigMem.Inst_frame9_bit19.Q
+ _2314_ VPWR VGND sg13g2_mux4_1
X_5080_ _0812_ _0065_ _0811_ VPWR VGND sg13g2_nand2_1
X_4100_ VGND VPWR _0028_ Tile_X0Y1_DSP_bot.Inst_DSP_bot_ConfigMem.Inst_frame2_bit0.Q
+ _2362_ _2361_ sg13g2_a21oi_1
XANTENNA_13 VPWR VGND Tile_X0Y0_S4END[0] sg13g2_antennanp
X_4864_ VGND VPWR _0572_ _0578_ _0606_ _0605_ sg13g2_a21oi_1
X_4933_ Tile_X0Y1_DSP_bot.Inst_DSP_bot_ConfigMem.Inst_frame4_bit17.Q VPWR _0672_ VGND
+ Tile_X0Y1_W1END[1] Tile_X0Y1_DSP_bot.Inst_DSP_bot_ConfigMem.Inst_frame4_bit16.Q
+ sg13g2_o21ai_1
X_5982_ Tile_X0Y1_FrameData[29] Tile_X0Y1_FrameStrobe[10] Tile_X0Y1_DSP_bot.Inst_DSP_bot_ConfigMem.Inst_frame10_bit29.Q
+ VPWR VGND sg13g2_dlhq_1
XANTENNA_46 VPWR VGND Tile_X0Y1_N4END[8] sg13g2_antennanp
XANTENNA_35 VPWR VGND Tile_X0Y1_N4END[11] sg13g2_antennanp
XANTENNA_68 VPWR VGND Tile_X0Y0_FrameData[6] sg13g2_antennanp
X_3746_ VGND VPWR Tile_X0Y0_E2END[0] Tile_X0Y0_DSP_top.Inst_DSP_top_ConfigMem.Inst_frame1_bit28.Q
+ _2076_ _2075_ sg13g2_a21oi_1
XANTENNA_79 VPWR VGND Tile_X0Y0_FrameData[6] sg13g2_antennanp
X_5416_ Tile_X0Y0_FrameData[5] Tile_X0Y1_FrameStrobe[6] Tile_X0Y0_DSP_top.Inst_DSP_top_ConfigMem.Inst_frame6_bit5.Q
+ VPWR VGND sg13g2_dlhq_1
X_3677_ Tile_X0Y0_DSP_top.Inst_DSP_top_ConfigMem.Inst_frame6_bit29.Q VPWR _2013_ VGND
+ Tile_X0Y0_S2MID[5] Tile_X0Y0_DSP_top.Inst_DSP_top_ConfigMem.Inst_frame6_bit28.Q
+ sg13g2_o21ai_1
XANTENNA_57 VPWR VGND Tile_X0Y0_FrameData[6] sg13g2_antennanp
X_6465_ Tile_X0Y1_DSP_bot.Inst_DSP_bot_switch_matrix.W1BEG0 Tile_X0Y1_W1BEG[0] VPWR
+ VGND sg13g2_buf_1
X_4795_ _0538_ VPWR _0539_ VGND Tile_X0Y1_DSP_bot.Inst_DSP_bot_ConfigMem.Inst_frame4_bit0.Q
+ Tile_X0Y1_DSP_bot.Inst_DSP_bot_switch_matrix.Q7 sg13g2_o21ai_1
XANTENNA_24 VPWR VGND Tile_X0Y1_EE4END[11] sg13g2_antennanp
X_3815_ _2138_ VPWR Tile_X0Y1_DSP_bot.Inst_DSP_bot_switch_matrix.Q1 VGND Tile_X0Y1_DSP_bot.Inst_DSP_bot_ConfigMem.Inst_frame12_bit5.Q
+ _2137_ sg13g2_o21ai_1
X_5347_ Tile_X0Y0_FrameData[10] Tile_X0Y1_FrameStrobe[4] Tile_X0Y0_DSP_top.Inst_DSP_top_ConfigMem.Inst_frame4_bit10.Q
+ VPWR VGND sg13g2_dlhq_1
X_2559_ Tile_X0Y0_DSP_top.Inst_DSP_top_ConfigMem.Inst_frame4_bit14.Q VPWR _0950_ VGND
+ Tile_X0Y0_DSP_top.Inst_DSP_top_ConfigMem.Inst_frame4_bit13.Q _0947_ sg13g2_o21ai_1
XFILLER_87_334 VPWR VGND sg13g2_fill_1
X_5278_ Tile_X0Y0_FrameData[15] Tile_X0Y1_FrameStrobe[2] Tile_X0Y0_DSP_top.Inst_DSP_top_ConfigMem.Inst_frame2_bit15.Q
+ VPWR VGND sg13g2_dlhq_1
X_2628_ _1014_ _1003_ _1016_ VPWR VGND sg13g2_xor2_1
X_6396_ Tile_X0Y1_FrameData[15] Tile_X0Y1_FrameData_O[15] VPWR VGND sg13g2_buf_1
X_4229_ Tile_X0Y1_DSP_bot.Inst_DSP_bot_ConfigMem.Inst_frame8_bit30.Q VPWR _2467_ VGND
+ Tile_X0Y1_DSP_bot.Inst_DSP_bot_ConfigMem.Inst_frame8_bit28.Q _2466_ sg13g2_o21ai_1
XFILLER_55_286 VPWR VGND sg13g2_fill_2
XFILLER_11_356 VPWR VGND sg13g2_fill_1
X_4580_ _0334_ Tile_X0Y0_DSP_top.Inst_DSP_top_ConfigMem.Inst_frame3_bit10.Q _0335_
+ VPWR VGND sg13g2_nor2b_1
X_3531_ Tile_X0Y1_DSP_bot.Inst_DSP_bot_ConfigMem.Inst_frame6_bit18.Q _0034_ _0080_
+ _0634_ _0081_ Tile_X0Y1_DSP_bot.Inst_DSP_bot_ConfigMem.Inst_frame6_bit19.Q _1885_
+ VPWR VGND sg13g2_mux4_1
X_3600_ _1949_ Tile_X0Y1_DSP_bot.Inst_MULADD.ACC\[4\] Tile_X0Y1_DSP_bot.Inst_DSP_bot_ConfigMem.Inst_frame12_bit5.Q
+ VPWR VGND sg13g2_nand2_1
X_6250_ Tile_X0Y0_DSP_top.Inst_DSP_top_switch_matrix.N2BEGb6 Tile_X0Y0_N2BEGb[6] VPWR
+ VGND sg13g2_buf_1
X_6181_ Tile_X0Y0_FrameData[1] Tile_X0Y0_FrameData_O[1] VPWR VGND sg13g2_buf_1
XFILLER_96_153 VPWR VGND sg13g2_fill_1
X_5201_ Tile_X0Y0_FrameData[28] Tile_X0Y1_FrameStrobe[0] Tile_X0Y0_DSP_top.Inst_DSP_top_ConfigMem.Inst_frame0_bit28.Q
+ VPWR VGND sg13g2_dlhq_1
X_5132_ _0064_ _0024_ _0678_ _0859_ _0058_ Tile_X0Y0_DSP_top.Inst_DSP_top_ConfigMem.Inst_frame7_bit12.Q
+ _0861_ VPWR VGND sg13g2_mux4_1
X_3393_ Tile_X0Y1_DSP_bot.Inst_DSP_bot_ConfigMem.Inst_frame8_bit23.Q _1751_ _1753_
+ _1754_ VPWR VGND sg13g2_nor3_1
XFILLER_42_2 VPWR VGND sg13g2_fill_1
X_3462_ _1819_ Tile_X0Y1_DSP_bot.Inst_DSP_bot_ConfigMem.Inst_frame6_bit24.Q Tile_X0Y1_E2MID[7]
+ VPWR VGND sg13g2_nand2b_1
X_5063_ _0796_ _0794_ _0795_ VPWR VGND sg13g2_nand2b_1
X_4014_ _2294_ VPWR _2300_ VGND _2296_ _2299_ sg13g2_o21ai_1
X_4916_ VGND VPWR Tile_X0Y1_N2MID[1] Tile_X0Y0_DSP_top.Inst_DSP_top_ConfigMem.Inst_frame3_bit0.Q
+ _0656_ _0655_ sg13g2_a21oi_1
X_4847_ VGND VPWR Tile_X0Y0_DSP_top.Inst_DSP_top_ConfigMem.Inst_frame1_bit5.Q _0589_
+ _0590_ Tile_X0Y0_DSP_top.Inst_DSP_top_ConfigMem.Inst_frame1_bit6.Q sg13g2_a21oi_1
X_5965_ Tile_X0Y1_FrameData[14] Tile_X0Y1_FrameStrobe[9] Tile_X0Y1_DSP_bot.Inst_DSP_bot_ConfigMem.Inst_frame9_bit14.Q
+ VPWR VGND sg13g2_dlhq_1
X_5896_ Tile_X0Y1_FrameData[19] Tile_X0Y1_FrameStrobe[7] Tile_X0Y1_DSP_bot.Inst_DSP_bot_ConfigMem.Inst_frame7_bit19.Q
+ VPWR VGND sg13g2_dlhq_1
XFILLER_106_7 VPWR VGND sg13g2_fill_2
X_3729_ _2060_ _0113_ Tile_X0Y0_DSP_top.Inst_DSP_top_switch_matrix.E2BEG4 VPWR VGND
+ sg13g2_nand2_1
X_4778_ Tile_X0Y0_DSP_top.Inst_DSP_top_ConfigMem.Inst_frame6_bit9.Q VPWR _0523_ VGND
+ Tile_X0Y0_S2MID[7] Tile_X0Y0_DSP_top.Inst_DSP_top_ConfigMem.Inst_frame6_bit8.Q sg13g2_o21ai_1
X_6448_ Tile_X0Y1_DSP_bot.Inst_DSP_bot_switch_matrix.S4BEG3 Tile_X0Y1_S4BEG[15] VPWR
+ VGND sg13g2_buf_1
X_6379_ Tile_X0Y1_DSP_bot.Inst_DSP_bot_switch_matrix.EE4BEG2 Tile_X0Y1_EE4BEG[14]
+ VPWR VGND sg13g2_buf_1
XFILLER_75_359 VPWR VGND sg13g2_fill_2
XFILLER_43_245 VPWR VGND sg13g2_fill_1
XFILLER_98_53 VPWR VGND sg13g2_fill_2
XFILLER_98_31 VPWR VGND sg13g2_fill_1
XFILLER_78_175 VPWR VGND sg13g2_fill_1
XFILLER_19_297 VPWR VGND sg13g2_fill_1
X_4701_ Tile_X0Y0_DSP_top.Inst_DSP_top_switch_matrix.bot2top5 Tile_X0Y0_DSP_top.Inst_DSP_top_switch_matrix.bot2top6
+ Tile_X0Y0_DSP_top.Inst_DSP_top_ConfigMem.Inst_frame3_bit12.Q _0450_ VPWR VGND sg13g2_mux2_1
X_2893_ _1214_ _1270_ _1271_ VPWR VGND sg13g2_nor2b_1
X_2962_ _1339_ _1334_ _1338_ VPWR VGND sg13g2_xnor2_1
X_5750_ Tile_X0Y1_FrameData[5] Tile_X0Y1_FrameStrobe[2] Tile_X0Y1_DSP_bot.Inst_DSP_bot_ConfigMem.Inst_frame2_bit5.Q
+ VPWR VGND sg13g2_dlhq_1
X_5681_ Tile_X0Y1_FrameData[10] Tile_X0Y1_FrameStrobe[0] Tile_X0Y1_DSP_bot.Inst_DSP_bot_ConfigMem.Inst_frame0_bit10.Q
+ VPWR VGND sg13g2_dlhq_1
X_4632_ VGND VPWR Tile_X0Y1_DSP_bot.Inst_DSP_bot_ConfigMem.Inst_frame4_bit13.Q _0382_
+ _0385_ _0384_ sg13g2_a21oi_1
X_6233_ Tile_X0Y0_DSP_top.Inst_DSP_top_switch_matrix.N1BEG1 Tile_X0Y0_N1BEG[1] VPWR
+ VGND sg13g2_buf_1
X_4563_ VGND VPWR Tile_X0Y0_DSP_top.Inst_DSP_top_ConfigMem.Inst_frame3_bit9.Q _0317_
+ _0318_ Tile_X0Y0_DSP_top.Inst_DSP_top_ConfigMem.Inst_frame3_bit10.Q sg13g2_a21oi_1
X_4494_ Tile_X0Y0_DSP_top.Inst_DSP_top_ConfigMem.Inst_frame8_bit18.Q VPWR _0252_ VGND
+ Tile_X0Y0_DSP_top.Inst_DSP_top_ConfigMem.Inst_frame0_bit25.Q _0251_ sg13g2_o21ai_1
X_6302_ Tile_X0Y0_W2MID[5] Tile_X0Y0_W2BEGb[5] VPWR VGND sg13g2_buf_1
X_3445_ Tile_X0Y1_DSP_bot.Inst_DSP_bot_ConfigMem.Inst_frame8_bit16.Q _1802_ _1803_
+ VPWR VGND sg13g2_nor2_1
X_3514_ Tile_X0Y1_DSP_bot.Inst_DSP_bot_ConfigMem.Inst_frame8_bit10.Q _1866_ _1867_
+ _1868_ _0223_ Tile_X0Y1_DSP_bot.Inst_DSP_bot_ConfigMem.Inst_frame8_bit11.Q Tile_X0Y1_DSP_bot.C2
+ VPWR VGND sg13g2_mux4_1
X_5115_ Tile_X0Y0_DSP_top.Inst_DSP_top_ConfigMem.Inst_frame2_bit16.Q Tile_X0Y0_DSP_top.Inst_DSP_top_switch_matrix.bot2top5
+ Tile_X0Y0_DSP_top.Inst_DSP_top_switch_matrix.bot2top6 Tile_X0Y0_DSP_top.Inst_DSP_top_switch_matrix.bot2top7
+ Tile_X0Y0_DSP_top.Inst_DSP_top_switch_matrix.bot2top9 Tile_X0Y0_DSP_top.Inst_DSP_top_ConfigMem.Inst_frame2_bit17.Q
+ _0845_ VPWR VGND sg13g2_mux4_1
X_6164_ Tile_X0Y0_EE4END[4] Tile_X0Y0_EE4BEG[0] VPWR VGND sg13g2_buf_1
X_6095_ VPWR VGND _2493_ sg13g2_tiehi
XFILLER_57_304 VPWR VGND sg13g2_fill_1
X_3376_ _1738_ Tile_X0Y1_DSP_bot.Inst_DSP_bot_ConfigMem.Inst_frame2_bit24.Q _0125_
+ VPWR VGND sg13g2_nand2_1
X_5046_ Tile_X0Y1_DSP_bot.Inst_DSP_bot_ConfigMem.Inst_frame0_bit6.Q Tile_X0Y1_N4END[0]
+ _0780_ VPWR VGND sg13g2_nor2b_1
X_5948_ Tile_X0Y1_FrameData[31] Tile_X0Y1_FrameStrobe[9] Tile_X0Y1_DSP_bot.Inst_DSP_bot_ConfigMem.Inst_frame9_bit31.Q
+ VPWR VGND sg13g2_dlhq_1
XFILLER_40_215 VPWR VGND sg13g2_fill_2
XFILLER_25_212 VPWR VGND sg13g2_decap_8
X_5879_ Tile_X0Y1_FrameData[4] Tile_X0Y1_FrameStrobe[6] Tile_X0Y1_DSP_bot.Inst_DSP_bot_ConfigMem.Inst_frame6_bit4.Q
+ VPWR VGND sg13g2_dlhq_1
XFILLER_0_355 VPWR VGND sg13g2_fill_1
XFILLER_84_44 VPWR VGND sg13g2_fill_1
XFILLER_48_315 VPWR VGND sg13g2_fill_2
XFILLER_17_60 VPWR VGND sg13g2_fill_2
X_3161_ _1534_ Tile_X0Y0_W2MID[3] Tile_X0Y0_DSP_top.Inst_DSP_top_ConfigMem.Inst_frame6_bit18.Q
+ VPWR VGND sg13g2_nand2_1
X_3230_ Tile_X0Y1_DSP_bot.Inst_DSP_bot_ConfigMem.Inst_frame3_bit31.Q _1596_ _1598_
+ _1599_ VPWR VGND sg13g2_nor3_1
X_3092_ Tile_X0Y0_DSP_top.Inst_DSP_top_ConfigMem.Inst_frame1_bit21.Q VPWR _1469_ VGND
+ Tile_X0Y0_DSP_top.Inst_DSP_top_ConfigMem.Inst_frame1_bit20.Q _0129_ sg13g2_o21ai_1
X_5802_ Tile_X0Y1_FrameData[17] Tile_X0Y1_FrameStrobe[4] Tile_X0Y1_DSP_bot.Inst_DSP_bot_ConfigMem.Inst_frame4_bit17.Q
+ VPWR VGND sg13g2_dlhq_1
XFILLER_95_0 VPWR VGND sg13g2_fill_2
X_5595_ Tile_X0Y0_FrameData[18] Tile_X0Y1_FrameStrobe[12] Tile_X0Y0_DSP_top.Inst_DSP_top_ConfigMem.Inst_frame12_bit18.Q
+ VPWR VGND sg13g2_dlhq_1
X_3994_ Tile_X0Y0_DSP_top.Inst_DSP_top_switch_matrix.SS4BEG2 _2281_ _2282_ _2276_
+ _2274_ VPWR VGND sg13g2_a22oi_1
X_2945_ _1269_ _1262_ _1322_ VPWR VGND sg13g2_xor2_1
X_5733_ Tile_X0Y1_FrameData[22] Tile_X0Y1_FrameStrobe[2] Tile_X0Y1_DSP_bot.Inst_DSP_bot_ConfigMem.Inst_frame2_bit22.Q
+ VPWR VGND sg13g2_dlhq_1
X_2876_ Tile_X0Y1_DSP_bot.Inst_DSP_bot_ConfigMem.Inst_frame6_bit10.Q _0034_ _0080_
+ _0634_ _0081_ Tile_X0Y1_DSP_bot.Inst_DSP_bot_ConfigMem.Inst_frame6_bit11.Q _1255_
+ VPWR VGND sg13g2_mux4_1
X_5664_ Tile_X0Y1_FrameData[27] Tile_X0Y1_FrameStrobe[0] Tile_X0Y1_DSP_bot.Inst_DSP_bot_ConfigMem.Inst_frame0_bit27.Q
+ VPWR VGND sg13g2_dlhq_1
X_4615_ _0367_ VPWR _0368_ VGND Tile_X0Y1_DSP_bot.Inst_DSP_bot_ConfigMem.Inst_frame4_bit12.Q
+ Tile_X0Y1_DSP_bot.Inst_DSP_bot_switch_matrix.Q7 sg13g2_o21ai_1
X_6216_ Tile_X0Y1_FrameStrobe[4] Tile_X0Y0_FrameStrobe_O[4] VPWR VGND sg13g2_buf_1
X_4546_ _0302_ Tile_X0Y0_DSP_top.Inst_DSP_top_ConfigMem.Inst_frame4_bit24.Q Tile_X0Y0_W1END[3]
+ VPWR VGND sg13g2_nand2b_1
X_4477_ _0236_ _0234_ _0235_ _0227_ _0226_ VPWR VGND sg13g2_a22oi_1
X_3428_ Tile_X0Y1_DSP_bot.Inst_DSP_bot_ConfigMem.Inst_frame8_bit18.Q _1785_ _1786_
+ _1783_ _1782_ Tile_X0Y1_DSP_bot.Inst_DSP_bot_ConfigMem.Inst_frame8_bit19.Q Tile_X0Y1_DSP_bot.C6
+ VPWR VGND sg13g2_mux4_1
X_6147_ Tile_X0Y0_E2MID[3] Tile_X0Y0_E2BEGb[3] VPWR VGND sg13g2_buf_1
X_6078_ VPWR VGND _2476_ sg13g2_tiehi
XFILLER_57_178 VPWR VGND sg13g2_fill_2
XFILLER_57_156 VPWR VGND sg13g2_fill_2
X_3359_ _1722_ Tile_X0Y1_DSP_bot.Inst_DSP_bot_ConfigMem.Inst_frame1_bit24.Q _0125_
+ VPWR VGND sg13g2_nand2_1
X_5029_ _0125_ _0126_ Tile_X0Y1_DSP_bot.Inst_DSP_bot_ConfigMem.Inst_frame1_bit4.Q
+ _0764_ VPWR VGND sg13g2_mux2_1
XFILLER_13_237 VPWR VGND sg13g2_decap_8
XFILLER_13_248 VPWR VGND sg13g2_fill_2
XFILLER_95_65 VPWR VGND sg13g2_fill_1
XFILLER_95_98 VPWR VGND sg13g2_decap_8
X_2730_ Tile_X0Y1_DSP_bot.Inst_DSP_bot_ConfigMem.Inst_frame2_bit17.Q VPWR _1114_ VGND
+ Tile_X0Y1_W1END[1] Tile_X0Y1_DSP_bot.Inst_DSP_bot_ConfigMem.Inst_frame2_bit16.Q
+ sg13g2_o21ai_1
X_2661_ _1047_ VPWR _1048_ VGND Tile_X0Y1_DSP_bot.Inst_DSP_bot_ConfigMem.Inst_frame3_bit4.Q
+ Tile_X0Y1_DSP_bot.Inst_DSP_bot_switch_matrix.Q0 sg13g2_o21ai_1
XFILLER_8_252 VPWR VGND sg13g2_fill_2
X_5380_ Tile_X0Y0_FrameData[9] Tile_X0Y1_FrameStrobe[5] Tile_X0Y0_DSP_top.Inst_DSP_top_ConfigMem.Inst_frame5_bit9.Q
+ VPWR VGND sg13g2_dlhq_1
X_2592_ Tile_X0Y0_DSP_top.Inst_DSP_top_ConfigMem.Inst_frame7_bit3.Q Tile_X0Y0_E2MID[2]
+ Tile_X0Y0_W2MID[2] Tile_X0Y0_S2MID[2] Tile_X0Y0_DSP_top.Inst_DSP_top_switch_matrix.E2BEG3
+ Tile_X0Y0_DSP_top.Inst_DSP_top_ConfigMem.Inst_frame7_bit2.Q _0981_ VPWR VGND sg13g2_mux4_1
X_4331_ VPWR _0094_ Tile_X0Y1_DSP_bot.Inst_DSP_bot_ConfigMem.Inst_frame1_bit21.Q VGND
+ sg13g2_inv_1
X_4400_ VGND VPWR _0027_ _0161_ _0162_ _0029_ sg13g2_a21oi_1
X_4262_ VPWR _0025_ Tile_X0Y0_S4END[4] VGND sg13g2_inv_1
X_3144_ _1517_ _1515_ _1518_ VPWR VGND sg13g2_nor2b_1
X_3075_ _1149_ _1153_ _1452_ VPWR VGND sg13g2_and2_1
X_3213_ _1583_ _1581_ _1582_ Tile_X0Y1_DSP_bot.Inst_MULADD.ACC\[10\] Tile_X0Y1_DSP_bot.Inst_DSP_bot_ConfigMem.Inst_frame12_bit3.Q
+ VPWR VGND sg13g2_a22oi_1
XFILLER_39_189 VPWR VGND sg13g2_fill_2
X_6001_ Tile_X0Y1_FrameData[10] Tile_X0Y1_FrameStrobe[10] Tile_X0Y1_DSP_bot.Inst_DSP_bot_ConfigMem.Inst_frame10_bit10.Q
+ VPWR VGND sg13g2_dlhq_1
XFILLER_10_0 VPWR VGND sg13g2_fill_2
X_4193_ Tile_X0Y1_DSP_bot.Inst_DSP_bot_ConfigMem.Inst_frame9_bit12.Q Tile_X0Y1_N1END[1]
+ Tile_X0Y1_W1END[1] _0669_ Tile_X0Y1_DSP_bot.Inst_DSP_bot_switch_matrix.Q5 Tile_X0Y1_DSP_bot.Inst_DSP_bot_ConfigMem.Inst_frame9_bit11.Q
+ _2434_ VPWR VGND sg13g2_mux4_1
X_3977_ Tile_X0Y0_DSP_top.Inst_DSP_top_ConfigMem.Inst_frame10_bit22.Q VPWR _2267_
+ VGND _0121_ _1500_ sg13g2_o21ai_1
X_5578_ Tile_X0Y0_FrameData[3] Tile_X0Y1_FrameStrobe[11] Tile_X0Y0_DSP_top.Inst_DSP_top_ConfigMem.Inst_frame11_bit3.Q
+ VPWR VGND sg13g2_dlhq_1
X_2859_ VGND VPWR _1239_ _1238_ _1237_ sg13g2_or2_1
X_2928_ _1293_ VPWR Tile_X0Y1_DSP_bot.B0 VGND _1298_ _1305_ sg13g2_o21ai_1
X_5716_ Tile_X0Y1_FrameData[7] Tile_X0Y1_FrameStrobe[1] Tile_X0Y1_DSP_bot.Inst_DSP_bot_ConfigMem.Inst_frame1_bit7.Q
+ VPWR VGND sg13g2_dlhq_1
X_5647_ _2519_ VGND VPWR Tile_X0Y1_DSP_bot.C7 Tile_X0Y1_DSP_bot.Inst_MULADD.C_reg\[7\]
+ clknet_3_3_0_Tile_X0Y1_UserCLK_regs sg13g2_dfrbpq_1
XFILLER_104_345 VPWR VGND sg13g2_fill_2
X_4529_ VGND VPWR _0286_ _0285_ _0280_ sg13g2_or2_1
XANTENNA_125 VPWR VGND Tile_X0Y0_W2MID[7] sg13g2_antennanp
XANTENNA_103 VPWR VGND Tile_X0Y0_S2MID[4] sg13g2_antennanp
XANTENNA_147 VPWR VGND Tile_X0Y0_S4END[6] sg13g2_antennanp
XANTENNA_136 VPWR VGND Tile_X0Y0_S4END[6] sg13g2_antennanp
XANTENNA_114 VPWR VGND Tile_X0Y0_S2MID[4] sg13g2_antennanp
XFILLER_81_67 VPWR VGND sg13g2_fill_2
XFILLER_110_359 VPWR VGND sg13g2_fill_2
XFILLER_36_126 VPWR VGND sg13g2_fill_1
X_3831_ Tile_X0Y0_DSP_top.Inst_DSP_top_ConfigMem.Inst_frame2_bit21.Q Tile_X0Y0_DSP_top.Inst_DSP_top_switch_matrix.N1END2
+ Tile_X0Y0_E1END[2] Tile_X0Y1_N2MID[6] Tile_X0Y0_E2END[6] Tile_X0Y0_DSP_top.Inst_DSP_top_ConfigMem.Inst_frame2_bit20.Q
+ _2153_ VPWR VGND sg13g2_mux4_1
X_3900_ Tile_X0Y0_DSP_top.Inst_DSP_top_ConfigMem.Inst_frame12_bit27.Q Tile_X0Y0_DSP_top.Inst_DSP_top_switch_matrix.bot2top6
+ _0937_ _0980_ _1990_ Tile_X0Y0_DSP_top.Inst_DSP_top_ConfigMem.Inst_frame12_bit26.Q
+ _2201_ VPWR VGND sg13g2_mux4_1
X_4880_ _0621_ Tile_X0Y0_DSP_top.Inst_DSP_top_ConfigMem.Inst_frame2_bit12.Q Tile_X0Y0_DSP_top.Inst_DSP_top_switch_matrix.bot2top1
+ VPWR VGND sg13g2_nand2_1
XFILLER_36_148 VPWR VGND sg13g2_fill_1
X_3762_ Tile_X0Y0_DSP_top.Inst_DSP_top_switch_matrix.bot2top4 Tile_X0Y0_DSP_top.Inst_DSP_top_switch_matrix.bot2top5
+ Tile_X0Y0_DSP_top.Inst_DSP_top_ConfigMem.Inst_frame1_bit28.Q _2092_ VPWR VGND sg13g2_mux2_1
X_5501_ Tile_X0Y0_FrameData[16] Tile_X0Y1_FrameStrobe[9] Tile_X0Y0_DSP_top.Inst_DSP_top_ConfigMem.Inst_frame9_bit16.Q
+ VPWR VGND sg13g2_dlhq_1
X_3693_ _2028_ Tile_X0Y1_DSP_bot.Inst_DSP_bot_ConfigMem.Inst_frame12_bit5.Q Tile_X0Y1_DSP_bot.Inst_MULADD.ACC\[16\]
+ VPWR VGND sg13g2_nand2_1
X_5432_ Tile_X0Y0_FrameData[21] Tile_X0Y1_FrameStrobe[7] Tile_X0Y0_DSP_top.Inst_DSP_top_ConfigMem.Inst_frame7_bit21.Q
+ VPWR VGND sg13g2_dlhq_1
X_6481_ Tile_X0Y1_W2MID[4] Tile_X0Y1_W2BEGb[4] VPWR VGND sg13g2_buf_1
X_2644_ _1031_ Tile_X0Y1_DSP_bot.Inst_DSP_bot_ConfigMem.Inst_frame3_bit15.Q _1032_
+ VPWR VGND sg13g2_nor2b_1
X_2713_ _1097_ _1096_ Tile_X0Y1_DSP_bot.Inst_DSP_bot_ConfigMem.Inst_frame2_bit10.Q
+ _1098_ VPWR VGND sg13g2_mux2_1
X_5294_ Tile_X0Y0_FrameData[31] Tile_X0Y1_FrameStrobe[3] Tile_X0Y0_DSP_top.Inst_DSP_top_ConfigMem.Inst_frame3_bit31.Q
+ VPWR VGND sg13g2_dlhq_1
X_5363_ Tile_X0Y0_FrameData[26] Tile_X0Y1_FrameStrobe[5] Tile_X0Y0_DSP_top.Inst_DSP_top_ConfigMem.Inst_frame5_bit26.Q
+ VPWR VGND sg13g2_dlhq_1
X_2575_ _0964_ _0357_ Tile_X0Y0_DSP_top.Inst_DSP_top_ConfigMem.Inst_frame9_bit26.Q
+ _0965_ VPWR VGND sg13g2_mux2_1
XFILLER_58_0 VPWR VGND sg13g2_fill_2
X_4245_ Tile_X0Y1_DSP_bot.Inst_DSP_bot_switch_matrix.clr _2139_ _0008_ VPWR VGND sg13g2_nor2_1
X_4314_ VPWR _0077_ Tile_X0Y1_DSP_bot.Inst_DSP_bot_ConfigMem.Inst_frame7_bit14.Q VGND
+ sg13g2_inv_1
XFILLER_101_359 VPWR VGND sg13g2_fill_2
X_3127_ _1502_ _0072_ Tile_X0Y0_DSP_top.Inst_DSP_top_switch_matrix.inst_cus_mux41_buf_top2bot11.X
+ VPWR VGND sg13g2_nand2b_1
X_3058_ _1435_ _1142_ _1157_ VPWR VGND sg13g2_xnor2_1
X_4176_ _2420_ _2419_ Tile_X0Y1_DSP_bot.Inst_DSP_bot_ConfigMem.Inst_frame10_bit25.Q
+ Tile_X0Y1_DSP_bot.Inst_DSP_bot_switch_matrix.SS4BEG3 VPWR VGND sg13g2_mux2_1
XFILLER_50_195 VPWR VGND sg13g2_fill_1
XFILLER_35_170 VPWR VGND sg13g2_fill_1
XFILLER_2_203 VPWR VGND sg13g2_decap_4
XFILLER_104_175 VPWR VGND sg13g2_fill_2
XFILLER_41_184 VPWR VGND sg13g2_decap_4
X_4030_ Tile_X0Y0_DSP_top.Inst_DSP_top_ConfigMem.Inst_frame9_bit18.Q Tile_X0Y0_E1END[3]
+ Tile_X0Y0_W1END[3] Tile_X0Y0_DSP_top.Inst_DSP_top_switch_matrix.bot2top0 Tile_X0Y0_DSP_top.Inst_DSP_top_switch_matrix.bot2top1
+ Tile_X0Y0_DSP_top.Inst_DSP_top_ConfigMem.Inst_frame9_bit19.Q _2313_ VPWR VGND sg13g2_mux4_1
XFILLER_2_53 VPWR VGND sg13g2_fill_2
X_5981_ Tile_X0Y1_FrameData[30] Tile_X0Y1_FrameStrobe[10] Tile_X0Y1_DSP_bot.Inst_DSP_bot_ConfigMem.Inst_frame10_bit30.Q
+ VPWR VGND sg13g2_dlhq_1
XANTENNA_36 VPWR VGND Tile_X0Y1_N4END[11] sg13g2_antennanp
XANTENNA_47 VPWR VGND Tile_X0Y1_N4END[9] sg13g2_antennanp
XANTENNA_14 VPWR VGND Tile_X0Y0_S4END[0] sg13g2_antennanp
X_4863_ _0602_ _0604_ _0605_ VPWR VGND sg13g2_nor2_1
X_4932_ _0670_ VPWR _0671_ VGND Tile_X0Y1_DSP_bot.Inst_DSP_bot_ConfigMem.Inst_frame4_bit16.Q
+ _0669_ sg13g2_o21ai_1
XFILLER_32_184 VPWR VGND sg13g2_fill_2
X_4794_ _0538_ Tile_X0Y1_DSP_bot.Inst_DSP_bot_ConfigMem.Inst_frame4_bit0.Q _0130_
+ VPWR VGND sg13g2_nand2_1
XANTENNA_25 VPWR VGND Tile_X0Y1_EE4END[12] sg13g2_antennanp
X_3814_ _2138_ Tile_X0Y1_DSP_bot.Inst_MULADD.ACC\[1\] Tile_X0Y1_DSP_bot.Inst_DSP_bot_ConfigMem.Inst_frame12_bit5.Q
+ VPWR VGND sg13g2_nand2_1
X_3745_ Tile_X0Y0_DSP_top.Inst_DSP_top_ConfigMem.Inst_frame1_bit29.Q VPWR _2075_ VGND
+ _0021_ Tile_X0Y0_DSP_top.Inst_DSP_top_ConfigMem.Inst_frame1_bit28.Q sg13g2_o21ai_1
XANTENNA_58 VPWR VGND Tile_X0Y0_FrameData[6] sg13g2_antennanp
X_2627_ _1015_ _1003_ _1014_ VPWR VGND sg13g2_nand2b_1
X_3676_ Tile_X0Y0_W2MID[5] _0069_ _2012_ VPWR VGND sg13g2_nor2_1
X_5415_ Tile_X0Y0_FrameData[6] Tile_X0Y1_FrameStrobe[6] Tile_X0Y0_DSP_top.Inst_DSP_top_ConfigMem.Inst_frame6_bit6.Q
+ VPWR VGND sg13g2_dlhq_1
XANTENNA_69 VPWR VGND Tile_X0Y0_FrameData[6] sg13g2_antennanp
X_6395_ Tile_X0Y1_FrameData[14] Tile_X0Y1_FrameData_O[14] VPWR VGND sg13g2_buf_1
X_6464_ Tile_X0Y1_DSP_bot.Inst_DSP_bot_switch_matrix.SS4BEG3 Tile_X0Y1_SS4BEG[15]
+ VPWR VGND sg13g2_buf_1
X_5277_ Tile_X0Y0_FrameData[16] Tile_X0Y1_FrameStrobe[2] Tile_X0Y0_DSP_top.Inst_DSP_top_ConfigMem.Inst_frame2_bit16.Q
+ VPWR VGND sg13g2_dlhq_1
X_5346_ Tile_X0Y0_FrameData[11] Tile_X0Y1_FrameStrobe[4] Tile_X0Y0_DSP_top.Inst_DSP_top_ConfigMem.Inst_frame4_bit11.Q
+ VPWR VGND sg13g2_dlhq_1
XFILLER_99_140 VPWR VGND sg13g2_fill_2
X_2558_ VGND VPWR Tile_X0Y0_DSP_top.Inst_DSP_top_ConfigMem.Inst_frame4_bit12.Q _0132_
+ _0949_ _0948_ sg13g2_a21oi_1
X_4228_ Tile_X0Y1_DSP_bot.Inst_DSP_bot_ConfigMem.Inst_frame8_bit29.Q _0186_ _2466_
+ VPWR VGND sg13g2_nor2_1
XFILLER_102_43 VPWR VGND sg13g2_fill_1
XFILLER_55_210 VPWR VGND sg13g2_fill_1
X_4159_ VGND VPWR Tile_X0Y1_DSP_bot.Inst_DSP_bot_ConfigMem.Inst_frame11_bit26.Q _1122_
+ _2408_ _2407_ sg13g2_a21oi_1
XFILLER_62_47 VPWR VGND sg13g2_decap_4
XFILLER_52_80 VPWR VGND sg13g2_fill_1
X_3461_ _1817_ VPWR _1818_ VGND Tile_X0Y1_DSP_bot.Inst_DSP_bot_ConfigMem.Inst_frame6_bit24.Q
+ _0208_ sg13g2_o21ai_1
X_3530_ VPWR VGND _1883_ Tile_X0Y1_DSP_bot.Inst_DSP_bot_ConfigMem.Inst_frame8_bit8.Q
+ _1882_ Tile_X0Y1_DSP_bot.Inst_DSP_bot_ConfigMem.Inst_frame7_bit19.Q _1884_ _1881_
+ sg13g2_a221oi_1
X_6180_ Tile_X0Y0_FrameData[0] Tile_X0Y0_FrameData_O[0] VPWR VGND sg13g2_buf_1
X_5062_ Tile_X0Y0_DSP_top.Inst_DSP_top_ConfigMem.Inst_frame1_bit11.Q VPWR _0795_ VGND
+ Tile_X0Y0_DSP_top.Inst_DSP_top_ConfigMem.Inst_frame1_bit10.Q _0788_ sg13g2_o21ai_1
X_4013_ _2299_ Tile_X0Y0_DSP_top.Inst_DSP_top_ConfigMem.Inst_frame9_bit11.Q _2298_
+ VPWR VGND sg13g2_nand2_1
X_5200_ Tile_X0Y0_FrameData[29] Tile_X0Y1_FrameStrobe[0] Tile_X0Y0_DSP_top.Inst_DSP_top_ConfigMem.Inst_frame0_bit29.Q
+ VPWR VGND sg13g2_dlhq_1
X_5131_ _0064_ Tile_X0Y0_S2MID[4] Tile_X0Y0_DSP_top.Inst_DSP_top_switch_matrix.N2BEGb4
+ Tile_X0Y0_DSP_top.Inst_DSP_top_switch_matrix.JS2BEG4 Tile_X0Y0_E2MID[4] Tile_X0Y0_DSP_top.Inst_DSP_top_ConfigMem.Inst_frame7_bit12.Q
+ _0860_ VPWR VGND sg13g2_mux4_1
X_3392_ VGND VPWR Tile_X0Y1_DSP_bot.Inst_DSP_bot_ConfigMem.Inst_frame8_bit24.Q _1120_
+ _1753_ _1752_ sg13g2_a21oi_1
XFILLER_37_287 VPWR VGND sg13g2_fill_2
XFILLER_37_221 VPWR VGND sg13g2_decap_8
X_5964_ Tile_X0Y1_FrameData[15] Tile_X0Y1_FrameStrobe[9] Tile_X0Y1_DSP_bot.Inst_DSP_bot_ConfigMem.Inst_frame9_bit15.Q
+ VPWR VGND sg13g2_dlhq_1
X_4915_ Tile_X0Y0_DSP_top.Inst_DSP_top_ConfigMem.Inst_frame3_bit0.Q _0293_ _0655_
+ VPWR VGND sg13g2_nor2_1
X_4777_ Tile_X0Y0_W2MID[7] Tile_X0Y0_DSP_top.Inst_DSP_top_ConfigMem.Inst_frame6_bit8.Q
+ _0522_ VPWR VGND sg13g2_nor2b_1
X_4846_ Tile_X0Y0_E2END[2] Tile_X0Y0_E6END[0] Tile_X0Y0_DSP_top.Inst_DSP_top_ConfigMem.Inst_frame1_bit4.Q
+ _0589_ VPWR VGND sg13g2_mux2_1
X_5895_ Tile_X0Y1_FrameData[20] Tile_X0Y1_FrameStrobe[7] Tile_X0Y1_DSP_bot.Inst_DSP_bot_ConfigMem.Inst_frame7_bit20.Q
+ VPWR VGND sg13g2_dlhq_1
XFILLER_32_39 VPWR VGND sg13g2_fill_1
XFILLER_106_204 VPWR VGND sg13g2_fill_1
X_5329_ Tile_X0Y0_FrameData[28] Tile_X0Y1_FrameStrobe[4] Tile_X0Y0_DSP_top.Inst_DSP_top_ConfigMem.Inst_frame4_bit28.Q
+ VPWR VGND sg13g2_dlhq_1
X_3728_ VGND VPWR _0113_ Tile_X0Y0_DSP_top.Inst_DSP_top_switch_matrix.JN2BEG4 _2059_
+ _2058_ sg13g2_a21oi_1
X_3659_ _1964_ _1994_ _1996_ VPWR VGND sg13g2_and2_1
X_6447_ Tile_X0Y1_DSP_bot.Inst_DSP_bot_switch_matrix.S4BEG2 Tile_X0Y1_S4BEG[14] VPWR
+ VGND sg13g2_buf_1
X_6378_ Tile_X0Y1_DSP_bot.Inst_DSP_bot_switch_matrix.EE4BEG1 Tile_X0Y1_EE4BEG[13]
+ VPWR VGND sg13g2_buf_1
XFILLER_75_349 VPWR VGND sg13g2_fill_2
XFILLER_57_14 VPWR VGND sg13g2_fill_2
XFILLER_28_243 VPWR VGND sg13g2_fill_1
XFILLER_11_187 VPWR VGND sg13g2_decap_8
XFILLER_34_257 VPWR VGND sg13g2_fill_1
X_4700_ VGND VPWR Tile_X0Y0_DSP_top.Inst_DSP_top_ConfigMem.Inst_frame3_bit12.Q Tile_X0Y0_DSP_top.Inst_DSP_top_switch_matrix.bot2top9
+ _0449_ _0448_ sg13g2_a21oi_1
X_2892_ _1268_ VPWR _1270_ VGND _1262_ _1269_ sg13g2_o21ai_1
X_2961_ _1336_ _1335_ _1338_ VPWR VGND sg13g2_xor2_1
X_5680_ Tile_X0Y1_FrameData[11] Tile_X0Y1_FrameStrobe[0] Tile_X0Y1_DSP_bot.Inst_DSP_bot_ConfigMem.Inst_frame0_bit11.Q
+ VPWR VGND sg13g2_dlhq_1
X_4631_ _0045_ VPWR _0384_ VGND Tile_X0Y1_DSP_bot.Inst_DSP_bot_ConfigMem.Inst_frame4_bit13.Q
+ _0383_ sg13g2_o21ai_1
X_6232_ Tile_X0Y0_DSP_top.Inst_DSP_top_switch_matrix.N1BEG0 Tile_X0Y0_N1BEG[0] VPWR
+ VGND sg13g2_buf_1
X_4493_ VGND VPWR Tile_X0Y0_EE4END[0] Tile_X0Y0_DSP_top.Inst_DSP_top_ConfigMem.Inst_frame0_bit24.Q
+ _0251_ _0250_ sg13g2_a21oi_1
X_4562_ Tile_X0Y0_DSP_top.Inst_DSP_top_switch_matrix.bot2top3 Tile_X0Y0_DSP_top.Inst_DSP_top_switch_matrix.bot2top4
+ Tile_X0Y0_DSP_top.Inst_DSP_top_ConfigMem.Inst_frame3_bit8.Q _0317_ VPWR VGND sg13g2_mux2_1
X_6301_ Tile_X0Y0_W2MID[4] Tile_X0Y0_W2BEGb[4] VPWR VGND sg13g2_buf_1
X_3513_ Tile_X0Y1_DSP_bot.Inst_DSP_bot_ConfigMem.Inst_frame5_bit20.Q Tile_X0Y1_N2END[5]
+ Tile_X0Y1_E2END[5] Tile_X0Y0_SS4END[5] Tile_X0Y1_W2END[5] Tile_X0Y1_DSP_bot.Inst_DSP_bot_ConfigMem.Inst_frame5_bit21.Q
+ _1868_ VPWR VGND sg13g2_mux4_1
X_3444_ Tile_X0Y1_DSP_bot.Inst_DSP_bot_ConfigMem.Inst_frame5_bit26.Q Tile_X0Y1_N2END[3]
+ Tile_X0Y1_E2END[3] Tile_X0Y0_SS4END[4] Tile_X0Y1_W2END[3] Tile_X0Y1_DSP_bot.Inst_DSP_bot_ConfigMem.Inst_frame5_bit27.Q
+ _1802_ VPWR VGND sg13g2_mux4_1
X_5114_ VPWR _0844_ _0843_ VGND sg13g2_inv_1
X_6163_ Tile_X0Y0_DSP_top.Inst_DSP_top_switch_matrix.E6BEG1 Tile_X0Y0_E6BEG[11] VPWR
+ VGND sg13g2_buf_1
X_6094_ VPWR VGND _2492_ sg13g2_tiehi
X_3375_ Tile_X0Y1_DSP_bot.Inst_DSP_bot_ConfigMem.Inst_frame2_bit24.Q Tile_X0Y1_DSP_bot.Inst_DSP_bot_switch_matrix.Q0
+ Tile_X0Y1_DSP_bot.Inst_DSP_bot_switch_matrix.Q1 Tile_X0Y1_DSP_bot.Inst_DSP_bot_switch_matrix.Q2
+ Tile_X0Y1_DSP_bot.Inst_DSP_bot_switch_matrix.Q3 Tile_X0Y1_DSP_bot.Inst_DSP_bot_ConfigMem.Inst_frame2_bit25.Q
+ _1737_ VPWR VGND sg13g2_mux4_1
X_5045_ _0778_ VPWR _0779_ VGND _0025_ Tile_X0Y1_DSP_bot.Inst_DSP_bot_ConfigMem.Inst_frame0_bit6.Q
+ sg13g2_o21ai_1
XFILLER_80_341 VPWR VGND sg13g2_fill_2
XFILLER_65_360 VPWR VGND sg13g2_fill_1
X_5947_ Tile_X0Y1_FrameData[0] Tile_X0Y1_FrameStrobe[8] Tile_X0Y1_DSP_bot.Inst_DSP_bot_ConfigMem.Inst_frame8_bit0.Q
+ VPWR VGND sg13g2_dlhq_1
X_4829_ _0571_ VPWR _0572_ VGND Tile_X0Y0_DSP_top.Inst_DSP_top_ConfigMem.Inst_frame7_bit7.Q
+ _0552_ sg13g2_o21ai_1
X_5878_ Tile_X0Y1_FrameData[5] Tile_X0Y1_FrameStrobe[6] Tile_X0Y1_DSP_bot.Inst_DSP_bot_ConfigMem.Inst_frame6_bit5.Q
+ VPWR VGND sg13g2_dlhq_1
XFILLER_104_5 VPWR VGND sg13g2_fill_2
XFILLER_63_308 VPWR VGND sg13g2_fill_1
XFILLER_56_360 VPWR VGND sg13g2_fill_1
XFILLER_16_268 VPWR VGND sg13g2_fill_2
XFILLER_31_238 VPWR VGND sg13g2_fill_2
X_3091_ Tile_X0Y0_DSP_top.Inst_DSP_top_switch_matrix.bot2top4 Tile_X0Y0_DSP_top.Inst_DSP_top_switch_matrix.bot2top6
+ Tile_X0Y0_DSP_top.Inst_DSP_top_ConfigMem.Inst_frame1_bit20.Q _1468_ VPWR VGND sg13g2_mux2_1
X_3160_ _1533_ Tile_X0Y0_S2MID[3] Tile_X0Y0_DSP_top.Inst_DSP_top_ConfigMem.Inst_frame6_bit18.Q
+ VPWR VGND sg13g2_nand2b_1
XFILLER_66_146 VPWR VGND sg13g2_decap_4
XFILLER_81_138 VPWR VGND sg13g2_fill_1
X_3993_ _2278_ Tile_X0Y0_DSP_top.Inst_DSP_top_ConfigMem.Inst_frame10_bit26.Q _2282_
+ VPWR VGND sg13g2_nor2b_1
X_5801_ Tile_X0Y1_FrameData[18] Tile_X0Y1_FrameStrobe[4] Tile_X0Y1_DSP_bot.Inst_DSP_bot_ConfigMem.Inst_frame4_bit18.Q
+ VPWR VGND sg13g2_dlhq_1
X_5732_ Tile_X0Y1_FrameData[23] Tile_X0Y1_FrameStrobe[2] Tile_X0Y1_DSP_bot.Inst_DSP_bot_ConfigMem.Inst_frame2_bit23.Q
+ VPWR VGND sg13g2_dlhq_1
X_4545_ _0300_ VPWR _0301_ VGND _0047_ Tile_X0Y0_DSP_top.Inst_DSP_top_ConfigMem.Inst_frame4_bit24.Q
+ sg13g2_o21ai_1
X_5594_ Tile_X0Y0_FrameData[19] Tile_X0Y1_FrameStrobe[12] Tile_X0Y0_DSP_top.Inst_DSP_top_ConfigMem.Inst_frame12_bit19.Q
+ VPWR VGND sg13g2_dlhq_1
X_2944_ _1317_ _1320_ _1321_ VPWR VGND sg13g2_nor2_1
X_2875_ _1253_ VPWR _1254_ VGND _1250_ _1251_ sg13g2_o21ai_1
X_4614_ _0367_ Tile_X0Y1_DSP_bot.Inst_DSP_bot_ConfigMem.Inst_frame4_bit12.Q _0131_
+ VPWR VGND sg13g2_nand2_1
X_5663_ Tile_X0Y1_FrameData[28] Tile_X0Y1_FrameStrobe[0] Tile_X0Y1_DSP_bot.Inst_DSP_bot_ConfigMem.Inst_frame0_bit28.Q
+ VPWR VGND sg13g2_dlhq_1
X_6215_ Tile_X0Y1_FrameStrobe[3] Tile_X0Y0_FrameStrobe_O[3] VPWR VGND sg13g2_buf_1
X_6146_ Tile_X0Y0_E2MID[2] Tile_X0Y0_E2BEGb[2] VPWR VGND sg13g2_buf_1
X_3358_ Tile_X0Y1_DSP_bot.Inst_DSP_bot_ConfigMem.Inst_frame1_bit27.Q _1718_ _1720_
+ _1721_ VPWR VGND sg13g2_nor3_1
X_4476_ Tile_X0Y1_DSP_bot.Inst_DSP_bot_ConfigMem.Inst_frame1_bit3.Q _0232_ _0235_
+ VPWR VGND sg13g2_nor2_1
X_3427_ Tile_X0Y1_DSP_bot.Inst_DSP_bot_ConfigMem.Inst_frame6_bit28.Q Tile_X0Y1_N2MID[5]
+ Tile_X0Y1_E2MID[5] Tile_X0Y0_DSP_top.Inst_DSP_top_switch_matrix.JS2BEG5 Tile_X0Y1_W2MID[5]
+ Tile_X0Y1_DSP_bot.Inst_DSP_bot_ConfigMem.Inst_frame6_bit29.Q _1786_ VPWR VGND sg13g2_mux4_1
X_6077_ VPWR VGND _2475_ sg13g2_tiehi
X_3289_ _1656_ _0432_ Tile_X0Y1_DSP_bot.Inst_DSP_bot_ConfigMem.Inst_frame8_bit25.Q
+ VPWR VGND sg13g2_nand2b_1
X_5028_ _0762_ VPWR _0763_ VGND Tile_X0Y1_DSP_bot.Inst_DSP_bot_ConfigMem.Inst_frame1_bit5.Q
+ _0761_ sg13g2_o21ai_1
XFILLER_28_82 VPWR VGND sg13g2_decap_8
XFILLER_29_360 VPWR VGND sg13g2_fill_1
X_2660_ VGND VPWR Tile_X0Y1_DSP_bot.Inst_DSP_bot_ConfigMem.Inst_frame3_bit4.Q _0127_
+ _1047_ Tile_X0Y1_DSP_bot.Inst_DSP_bot_ConfigMem.Inst_frame3_bit5.Q sg13g2_a21oi_1
XFILLER_8_297 VPWR VGND sg13g2_fill_2
X_2591_ VPWR _0980_ _0979_ VGND sg13g2_inv_1
X_3212_ VGND VPWR Tile_X0Y1_DSP_bot.Inst_DSP_bot_ConfigMem.Inst_frame12_bit2.Q _0090_
+ _1582_ Tile_X0Y1_DSP_bot.Inst_DSP_bot_ConfigMem.Inst_frame12_bit3.Q sg13g2_a21oi_1
X_4261_ VPWR _0024_ Tile_X0Y0_S2MID[4] VGND sg13g2_inv_1
X_4330_ VPWR _0093_ Tile_X0Y1_DSP_bot.Inst_DSP_bot_ConfigMem.Inst_frame2_bit31.Q VGND
+ sg13g2_inv_1
XFILLER_5_53 VPWR VGND sg13g2_fill_2
X_6000_ Tile_X0Y1_FrameData[11] Tile_X0Y1_FrameStrobe[10] Tile_X0Y1_DSP_bot.Inst_DSP_bot_ConfigMem.Inst_frame10_bit11.Q
+ VPWR VGND sg13g2_dlhq_1
X_3143_ _1517_ _1436_ _1516_ VPWR VGND sg13g2_nand2_1
X_3074_ _1451_ _1442_ _1449_ VPWR VGND sg13g2_xnor2_1
XFILLER_39_113 VPWR VGND sg13g2_fill_1
XFILLER_39_102 VPWR VGND sg13g2_decap_8
X_4192_ VGND VPWR Tile_X0Y1_DSP_bot.Inst_DSP_bot_ConfigMem.Inst_frame9_bit10.Q _2433_
+ Tile_X0Y1_DSP_bot.Inst_DSP_bot_switch_matrix.WW4BEG2 _2432_ sg13g2_a21oi_1
X_3976_ _2265_ VPWR _2266_ VGND Tile_X0Y0_DSP_top.Inst_DSP_top_ConfigMem.Inst_frame10_bit22.Q
+ _2263_ sg13g2_o21ai_1
X_2927_ VGND VPWR _1305_ _1304_ Tile_X0Y1_DSP_bot.Inst_DSP_bot_ConfigMem.Inst_frame9_bit31.Q
+ sg13g2_or2_1
X_5715_ Tile_X0Y1_FrameData[8] Tile_X0Y1_FrameStrobe[1] Tile_X0Y1_DSP_bot.Inst_DSP_bot_ConfigMem.Inst_frame1_bit8.Q
+ VPWR VGND sg13g2_dlhq_1
X_2789_ _1171_ Tile_X0Y0_DSP_top.Inst_DSP_top_ConfigMem.Inst_frame2_bit24.Q Tile_X0Y0_W1END[3]
+ VPWR VGND sg13g2_nand2b_1
X_5577_ Tile_X0Y0_FrameData[4] Tile_X0Y1_FrameStrobe[11] Tile_X0Y0_DSP_top.Inst_DSP_top_ConfigMem.Inst_frame11_bit4.Q
+ VPWR VGND sg13g2_dlhq_1
X_2858_ Tile_X0Y1_DSP_bot.Inst_DSP_bot_ConfigMem.Inst_frame3_bit18.Q VPWR _1238_ VGND
+ Tile_X0Y1_DSP_bot.Inst_DSP_bot_ConfigMem.Inst_frame3_bit17.Q _1235_ sg13g2_o21ai_1
XFILLER_40_17 VPWR VGND sg13g2_fill_2
X_4528_ VGND VPWR Tile_X0Y1_DSP_bot.Inst_DSP_bot_ConfigMem.Inst_frame1_bit9.Q _0282_
+ _0285_ _0284_ sg13g2_a21oi_1
X_5646_ _2518_ VGND VPWR Tile_X0Y1_DSP_bot.C6 Tile_X0Y1_DSP_bot.Inst_MULADD.C_reg\[6\]
+ clknet_3_3_0_Tile_X0Y1_UserCLK_regs sg13g2_dfrbpq_1
X_6129_ VPWR VGND _2527_ sg13g2_tiehi
X_4459_ Tile_X0Y1_DSP_bot.Inst_DSP_bot_ConfigMem.Inst_frame2_bit12.Q Tile_X0Y0_S2MID[4]
+ Tile_X0Y0_S4END[4] Tile_X0Y1_W2END[4] Tile_X0Y1_WW4END[2] Tile_X0Y1_DSP_bot.Inst_DSP_bot_ConfigMem.Inst_frame2_bit13.Q
+ _0219_ VPWR VGND sg13g2_mux4_1
XANTENNA_126 VPWR VGND Tile_X0Y0_W2MID[7] sg13g2_antennanp
XANTENNA_115 VPWR VGND Tile_X0Y0_S2MID[4] sg13g2_antennanp
XANTENNA_104 VPWR VGND Tile_X0Y0_S2MID[4] sg13g2_antennanp
XFILLER_45_138 VPWR VGND sg13g2_fill_1
Xclkbuf_3_1_0_Tile_X0Y1_UserCLK_regs clknet_0_Tile_X0Y1_UserCLK_regs clknet_3_1_0_Tile_X0Y1_UserCLK_regs
+ VPWR VGND sg13g2_buf_8
XANTENNA_137 VPWR VGND Tile_X0Y0_S4END[6] sg13g2_antennanp
XANTENNA_148 VPWR VGND Tile_X0Y0_S4END[6] sg13g2_antennanp
XFILLER_110_327 VPWR VGND sg13g2_decap_8
XFILLER_76_285 VPWR VGND sg13g2_fill_2
X_3830_ _2150_ Tile_X0Y0_DSP_top.Inst_DSP_top_ConfigMem.Inst_frame2_bit21.Q _2151_
+ _2152_ VPWR VGND sg13g2_a21o_1
X_3761_ _2090_ VPWR _2091_ VGND Tile_X0Y0_DSP_top.Inst_DSP_top_ConfigMem.Inst_frame1_bit28.Q
+ Tile_X0Y0_DSP_top.Inst_DSP_top_switch_matrix.bot2top6 sg13g2_o21ai_1
XFILLER_32_300 VPWR VGND sg13g2_fill_2
X_5362_ Tile_X0Y0_FrameData[27] Tile_X0Y1_FrameStrobe[5] Tile_X0Y0_DSP_top.Inst_DSP_top_ConfigMem.Inst_frame5_bit27.Q
+ VPWR VGND sg13g2_dlhq_1
X_2574_ Tile_X0Y0_DSP_top.Inst_DSP_top_ConfigMem.Inst_frame5_bit0.Q Tile_X0Y1_N2MID[6]
+ Tile_X0Y0_E2END[6] Tile_X0Y0_SS4END[3] Tile_X0Y0_W2END[6] Tile_X0Y0_DSP_top.Inst_DSP_top_ConfigMem.Inst_frame5_bit1.Q
+ _0964_ VPWR VGND sg13g2_mux4_1
X_3692_ _2027_ _2026_ _2025_ VPWR VGND sg13g2_nand2b_1
X_5500_ Tile_X0Y0_FrameData[17] Tile_X0Y1_FrameStrobe[9] Tile_X0Y0_DSP_top.Inst_DSP_top_ConfigMem.Inst_frame9_bit17.Q
+ VPWR VGND sg13g2_dlhq_1
X_5431_ Tile_X0Y0_FrameData[22] Tile_X0Y1_FrameStrobe[7] Tile_X0Y0_DSP_top.Inst_DSP_top_ConfigMem.Inst_frame7_bit22.Q
+ VPWR VGND sg13g2_dlhq_1
X_6480_ Tile_X0Y1_W2MID[3] Tile_X0Y1_W2BEGb[3] VPWR VGND sg13g2_buf_1
X_2643_ VGND VPWR Tile_X0Y1_DSP_bot.Inst_DSP_bot_ConfigMem.Inst_frame3_bit13.Q _1029_
+ _1031_ _1030_ sg13g2_a21oi_1
X_2712_ Tile_X0Y1_DSP_bot.Inst_DSP_bot_ConfigMem.Inst_frame2_bit8.Q Tile_X0Y1_NN4END[3]
+ Tile_X0Y1_E1END[1] Tile_X0Y1_E2END[3] Tile_X0Y1_E6END[1] Tile_X0Y1_DSP_bot.Inst_DSP_bot_ConfigMem.Inst_frame2_bit9.Q
+ _1097_ VPWR VGND sg13g2_mux4_1
X_5293_ Tile_X0Y0_FrameData[0] Tile_X0Y1_FrameStrobe[2] Tile_X0Y0_DSP_top.Inst_DSP_top_ConfigMem.Inst_frame2_bit0.Q
+ VPWR VGND sg13g2_dlhq_1
XFILLER_67_252 VPWR VGND sg13g2_decap_4
X_4313_ VPWR _0076_ Tile_X0Y1_W2MID[4] VGND sg13g2_inv_1
X_4175_ Tile_X0Y1_DSP_bot.Inst_DSP_bot_ConfigMem.Inst_frame10_bit24.Q Tile_X0Y1_N1END[1]
+ Tile_X0Y1_W1END[1] Tile_X0Y1_E1END[1] Tile_X0Y1_DSP_bot.Inst_DSP_bot_switch_matrix.Q5
+ Tile_X0Y1_DSP_bot.Inst_DSP_bot_ConfigMem.Inst_frame10_bit23.Q _2420_ VPWR VGND sg13g2_mux4_1
X_4244_ Tile_X0Y1_DSP_bot.Inst_DSP_bot_switch_matrix.clr _1954_ _0007_ VPWR VGND sg13g2_nor2b_1
X_3126_ _1494_ VPWR Tile_X0Y0_DSP_top.Inst_DSP_top_switch_matrix.inst_cus_mux41_buf_top2bot11.X
+ VGND _1499_ _1501_ sg13g2_o21ai_1
X_3057_ _1433_ VPWR _1434_ VGND _1271_ _1432_ sg13g2_o21ai_1
X_3959_ _2252_ _2250_ _2251_ _2249_ Tile_X0Y0_DSP_top.Inst_DSP_top_ConfigMem.Inst_frame11_bit27.Q
+ VPWR VGND sg13g2_a22oi_1
X_5629_ _2501_ VGND VPWR Tile_X0Y0_DSP_top.Inst_DSP_top_switch_matrix.inst_cus_mux41_buf_top2bot1.X
+ Tile_X0Y1_DSP_bot.Inst_MULADD.A_reg\[5\] clknet_3_5_0_Tile_X0Y1_UserCLK_regs sg13g2_dfrbpq_1
XFILLER_58_285 VPWR VGND sg13g2_fill_1
XFILLER_73_299 VPWR VGND sg13g2_fill_2
XFILLER_33_119 VPWR VGND sg13g2_fill_2
XFILLER_14_300 VPWR VGND sg13g2_fill_2
XFILLER_44_7 VPWR VGND sg13g2_decap_8
XFILLER_2_21 VPWR VGND sg13g2_fill_2
XFILLER_64_222 VPWR VGND sg13g2_fill_2
X_4931_ VGND VPWR _0051_ Tile_X0Y1_DSP_bot.Inst_DSP_bot_ConfigMem.Inst_frame4_bit16.Q
+ _0670_ Tile_X0Y1_DSP_bot.Inst_DSP_bot_ConfigMem.Inst_frame4_bit17.Q sg13g2_a21oi_1
X_5980_ Tile_X0Y1_FrameData[31] Tile_X0Y1_FrameStrobe[10] Tile_X0Y1_DSP_bot.Inst_DSP_bot_ConfigMem.Inst_frame10_bit31.Q
+ VPWR VGND sg13g2_dlhq_1
XANTENNA_48 VPWR VGND Tile_X0Y1_N4END[9] sg13g2_antennanp
XANTENNA_37 VPWR VGND Tile_X0Y1_N4END[11] sg13g2_antennanp
X_3744_ _2073_ VPWR _2074_ VGND Tile_X0Y0_DSP_top.Inst_DSP_top_ConfigMem.Inst_frame1_bit28.Q
+ _0190_ sg13g2_o21ai_1
XANTENNA_59 VPWR VGND Tile_X0Y0_FrameData[6] sg13g2_antennanp
X_4862_ Tile_X0Y0_DSP_top.Inst_DSP_top_ConfigMem.Inst_frame8_bit1.Q VPWR _0604_ VGND
+ Tile_X0Y0_DSP_top.Inst_DSP_top_ConfigMem.Inst_frame8_bit0.Q _0603_ sg13g2_o21ai_1
XANTENNA_15 VPWR VGND Tile_X0Y0_S4END[0] sg13g2_antennanp
X_4793_ VGND VPWR Tile_X0Y1_DSP_bot.Inst_DSP_bot_ConfigMem.Inst_frame4_bit0.Q _0126_
+ _0537_ _0536_ sg13g2_a21oi_1
XANTENNA_26 VPWR VGND Tile_X0Y1_EE4END[4] sg13g2_antennanp
XFILLER_20_347 VPWR VGND sg13g2_fill_2
X_3813_ _2137_ _1914_ _1915_ VPWR VGND sg13g2_xnor2_1
X_5345_ Tile_X0Y0_FrameData[12] Tile_X0Y1_FrameStrobe[4] Tile_X0Y0_DSP_top.Inst_DSP_top_ConfigMem.Inst_frame4_bit12.Q
+ VPWR VGND sg13g2_dlhq_1
X_2557_ Tile_X0Y0_DSP_top.Inst_DSP_top_ConfigMem.Inst_frame4_bit13.Q VPWR _0948_ VGND
+ Tile_X0Y0_DSP_top.Inst_DSP_top_ConfigMem.Inst_frame4_bit12.Q Tile_X0Y0_DSP_top.Inst_DSP_top_switch_matrix.bot2top7
+ sg13g2_o21ai_1
X_3675_ VGND VPWR _0069_ _0432_ _2011_ _2010_ sg13g2_a21oi_1
X_2626_ _1014_ _0610_ _1013_ VPWR VGND sg13g2_xnor2_1
X_5414_ Tile_X0Y0_FrameData[7] Tile_X0Y1_FrameStrobe[6] Tile_X0Y0_DSP_top.Inst_DSP_top_ConfigMem.Inst_frame6_bit7.Q
+ VPWR VGND sg13g2_dlhq_1
X_6394_ Tile_X0Y1_FrameData[13] Tile_X0Y1_FrameData_O[13] VPWR VGND sg13g2_buf_1
X_6463_ Tile_X0Y1_DSP_bot.Inst_DSP_bot_switch_matrix.SS4BEG2 Tile_X0Y1_SS4BEG[14]
+ VPWR VGND sg13g2_buf_1
X_5276_ Tile_X0Y0_FrameData[17] Tile_X0Y1_FrameStrobe[2] Tile_X0Y0_DSP_top.Inst_DSP_top_ConfigMem.Inst_frame2_bit17.Q
+ VPWR VGND sg13g2_dlhq_1
X_4227_ Tile_X0Y1_DSP_bot.Inst_DSP_bot_ConfigMem.Inst_frame8_bit30.Q _2464_ _2465_
+ VPWR VGND sg13g2_nor2b_1
X_4158_ Tile_X0Y1_DSP_bot.Inst_DSP_bot_ConfigMem.Inst_frame11_bit26.Q _0874_ _2407_
+ VPWR VGND sg13g2_nor2_1
XFILLER_102_22 VPWR VGND sg13g2_fill_1
X_3109_ _1484_ VPWR _1485_ VGND Tile_X0Y0_E2MID[0] Tile_X0Y0_DSP_top.Inst_DSP_top_ConfigMem.Inst_frame7_bit22.Q
+ sg13g2_o21ai_1
X_4089_ Tile_X0Y1_DSP_bot.Inst_DSP_bot_ConfigMem.Inst_frame2_bit1.Q VPWR _2351_ VGND
+ Tile_X0Y1_DSP_bot.Inst_DSP_bot_ConfigMem.Inst_frame2_bit0.Q Tile_X0Y1_DSP_bot.Inst_DSP_bot_switch_matrix.Q7
+ sg13g2_o21ai_1
XFILLER_23_130 VPWR VGND sg13g2_decap_8
XFILLER_87_67 VPWR VGND sg13g2_fill_2
XFILLER_61_236 VPWR VGND sg13g2_fill_1
X_3391_ _0097_ VPWR _1752_ VGND Tile_X0Y1_DSP_bot.Inst_DSP_bot_ConfigMem.Inst_frame8_bit24.Q
+ Tile_X0Y0_DSP_top.Inst_DSP_top_switch_matrix.N2BEGb4 sg13g2_o21ai_1
X_3460_ _1817_ Tile_X0Y1_W2MID[7] Tile_X0Y1_DSP_bot.Inst_DSP_bot_ConfigMem.Inst_frame6_bit24.Q
+ VPWR VGND sg13g2_nand2_1
X_5061_ _0793_ VPWR _0794_ VGND Tile_X0Y0_DSP_top.Inst_DSP_top_ConfigMem.Inst_frame1_bit9.Q
+ _0790_ sg13g2_o21ai_1
X_4012_ _2297_ VPWR _2298_ VGND _0123_ _0679_ sg13g2_o21ai_1
X_5130_ VPWR _0859_ Tile_X0Y0_DSP_top.Inst_DSP_top_switch_matrix.JS2BEG4 VGND sg13g2_inv_1
XFILLER_92_350 VPWR VGND sg13g2_fill_2
X_4914_ Tile_X0Y0_DSP_top.Inst_DSP_top_ConfigMem.Inst_frame3_bit3.Q VPWR _0654_ VGND
+ _0650_ _0653_ sg13g2_o21ai_1
XFILLER_37_299 VPWR VGND sg13g2_fill_1
X_5894_ Tile_X0Y1_FrameData[21] Tile_X0Y1_FrameStrobe[7] Tile_X0Y1_DSP_bot.Inst_DSP_bot_ConfigMem.Inst_frame7_bit21.Q
+ VPWR VGND sg13g2_dlhq_1
X_5963_ Tile_X0Y1_FrameData[16] Tile_X0Y1_FrameStrobe[9] Tile_X0Y1_DSP_bot.Inst_DSP_bot_ConfigMem.Inst_frame9_bit16.Q
+ VPWR VGND sg13g2_dlhq_1
X_3727_ Tile_X0Y0_DSP_top.Inst_DSP_top_switch_matrix.JN2BEG6 Tile_X0Y0_DSP_top.Inst_DSP_top_ConfigMem.Inst_frame8_bit26.Q
+ Tile_X0Y0_DSP_top.Inst_DSP_top_ConfigMem.Inst_frame8_bit27.Q _2058_ VPWR VGND sg13g2_a21o_1
X_4776_ Tile_X0Y0_DSP_top.Inst_DSP_top_ConfigMem.Inst_frame6_bit9.Q _0520_ _0521_
+ VPWR VGND sg13g2_nor2_1
X_4845_ VGND VPWR Tile_X0Y1_N2MID[2] Tile_X0Y0_DSP_top.Inst_DSP_top_ConfigMem.Inst_frame1_bit4.Q
+ _0588_ _0587_ sg13g2_a21oi_1
X_5328_ Tile_X0Y0_FrameData[29] Tile_X0Y1_FrameStrobe[4] Tile_X0Y0_DSP_top.Inst_DSP_top_ConfigMem.Inst_frame4_bit29.Q
+ VPWR VGND sg13g2_dlhq_1
XFILLER_87_122 VPWR VGND sg13g2_fill_2
X_3658_ _1964_ _1994_ _1995_ VPWR VGND sg13g2_nor2_1
X_3589_ _1458_ _1460_ _1508_ _1939_ _1941_ VPWR VGND sg13g2_or4_1
X_2609_ _0997_ _0818_ _0995_ VPWR VGND sg13g2_xnor2_1
X_6446_ Tile_X0Y1_DSP_bot.Inst_DSP_bot_switch_matrix.S4BEG1 Tile_X0Y1_S4BEG[13] VPWR
+ VGND sg13g2_buf_1
X_6377_ Tile_X0Y1_DSP_bot.Inst_DSP_bot_switch_matrix.EE4BEG0 Tile_X0Y1_EE4BEG[12]
+ VPWR VGND sg13g2_buf_1
X_5259_ Tile_X0Y0_FrameData[2] Tile_X0Y1_FrameStrobe[1] Tile_X0Y0_DSP_top.Inst_DSP_top_ConfigMem.Inst_frame1_bit2.Q
+ VPWR VGND sg13g2_dlhq_1
XFILLER_75_328 VPWR VGND sg13g2_fill_1
XFILLER_57_48 VPWR VGND sg13g2_fill_2
XFILLER_51_291 VPWR VGND sg13g2_fill_2
XFILLER_43_236 VPWR VGND sg13g2_fill_1
XFILLER_98_55 VPWR VGND sg13g2_fill_1
XFILLER_66_339 VPWR VGND sg13g2_fill_2
XFILLER_0_0 VPWR VGND sg13g2_fill_2
X_2960_ _1337_ _1335_ _1336_ VPWR VGND sg13g2_nand2b_1
XFILLER_47_70 VPWR VGND sg13g2_fill_1
X_4561_ _0315_ VPWR _0316_ VGND Tile_X0Y0_DSP_top.Inst_DSP_top_ConfigMem.Inst_frame3_bit8.Q
+ Tile_X0Y0_DSP_top.Inst_DSP_top_switch_matrix.bot2top0 sg13g2_o21ai_1
X_6300_ Tile_X0Y0_W2MID[3] Tile_X0Y0_W2BEGb[3] VPWR VGND sg13g2_buf_1
X_2891_ _1269_ _1266_ _1267_ VPWR VGND sg13g2_xnor2_1
X_4630_ Tile_X0Y1_N2END[4] Tile_X0Y1_N4END[0] Tile_X0Y1_DSP_bot.Inst_DSP_bot_ConfigMem.Inst_frame4_bit12.Q
+ _0383_ VPWR VGND sg13g2_mux2_1
X_6231_ Tile_X0Y1_FrameStrobe[19] Tile_X0Y0_FrameStrobe_O[19] VPWR VGND sg13g2_buf_1
X_5113_ Tile_X0Y0_DSP_top.Inst_DSP_top_ConfigMem.Inst_frame2_bit16.Q Tile_X0Y0_DSP_top.Inst_DSP_top_switch_matrix.bot2top0
+ Tile_X0Y0_DSP_top.Inst_DSP_top_switch_matrix.bot2top1 Tile_X0Y0_DSP_top.Inst_DSP_top_switch_matrix.bot2top2
+ Tile_X0Y0_DSP_top.Inst_DSP_top_switch_matrix.bot2top3 Tile_X0Y0_DSP_top.Inst_DSP_top_ConfigMem.Inst_frame2_bit17.Q
+ _0843_ VPWR VGND sg13g2_mux4_1
X_6162_ Tile_X0Y0_DSP_top.Inst_DSP_top_switch_matrix.E6BEG0 Tile_X0Y0_E6BEG[10] VPWR
+ VGND sg13g2_buf_1
X_4492_ Tile_X0Y0_DSP_top.Inst_DSP_top_ConfigMem.Inst_frame0_bit24.Q Tile_X0Y1_N4END[7]
+ _0250_ VPWR VGND sg13g2_nor2b_1
X_3374_ VGND VPWR Tile_X0Y1_DSP_bot.Inst_DSP_bot_ConfigMem.Inst_frame8_bit22.Q _1732_
+ _1736_ _1735_ sg13g2_a21oi_1
XFILLER_33_0 VPWR VGND sg13g2_fill_2
X_3512_ Tile_X0Y1_DSP_bot.Inst_DSP_bot_ConfigMem.Inst_frame6_bit20.Q Tile_X0Y1_N2MID[5]
+ Tile_X0Y1_E2MID[5] Tile_X0Y0_DSP_top.Inst_DSP_top_switch_matrix.JS2BEG5 Tile_X0Y1_W2MID[5]
+ Tile_X0Y1_DSP_bot.Inst_DSP_bot_ConfigMem.Inst_frame6_bit21.Q _1867_ VPWR VGND sg13g2_mux4_1
X_3443_ Tile_X0Y1_DSP_bot.Inst_DSP_bot_ConfigMem.Inst_frame8_bit16.Q VPWR _1801_ VGND
+ Tile_X0Y1_DSP_bot.Inst_DSP_bot_ConfigMem.Inst_frame0_bit27.Q _1800_ sg13g2_o21ai_1
X_6093_ VPWR VGND _2491_ sg13g2_tiehi
X_5044_ _0778_ Tile_X0Y1_DSP_bot.Inst_DSP_bot_ConfigMem.Inst_frame0_bit6.Q Tile_X0Y1_DSP_bot.Inst_DSP_bot_switch_matrix.JW2BEG1
+ VPWR VGND sg13g2_nand2_1
X_4828_ VGND VPWR Tile_X0Y0_DSP_top.Inst_DSP_top_ConfigMem.Inst_frame7_bit7.Q _0570_
+ _0571_ Tile_X0Y0_DSP_top.Inst_DSP_top_ConfigMem.Inst_frame8_bit0.Q sg13g2_a21oi_1
X_5946_ Tile_X0Y1_FrameData[1] Tile_X0Y1_FrameStrobe[8] Tile_X0Y1_DSP_bot.Inst_DSP_bot_ConfigMem.Inst_frame8_bit1.Q
+ VPWR VGND sg13g2_dlhq_1
XFILLER_40_217 VPWR VGND sg13g2_fill_1
X_5877_ Tile_X0Y1_FrameData[6] Tile_X0Y1_FrameStrobe[6] Tile_X0Y1_DSP_bot.Inst_DSP_bot_ConfigMem.Inst_frame6_bit6.Q
+ VPWR VGND sg13g2_dlhq_1
X_4759_ Tile_X0Y0_DSP_top.Inst_DSP_top_ConfigMem.Inst_frame4_bit10.Q VPWR _0505_ VGND
+ Tile_X0Y0_DSP_top.Inst_DSP_top_ConfigMem.Inst_frame4_bit9.Q _0502_ sg13g2_o21ai_1
XFILLER_4_129 VPWR VGND sg13g2_fill_1
X_6429_ Tile_X0Y0_DSP_top.Inst_DSP_top_switch_matrix.JS2BEG4 Tile_X0Y1_S2BEGb[4] VPWR
+ VGND sg13g2_buf_1
XFILLER_108_87 VPWR VGND sg13g2_fill_2
XFILLER_0_335 VPWR VGND sg13g2_fill_2
XFILLER_98_206 VPWR VGND sg13g2_decap_8
X_3090_ _1466_ VPWR _1467_ VGND Tile_X0Y0_DSP_top.Inst_DSP_top_ConfigMem.Inst_frame1_bit21.Q
+ _1465_ sg13g2_o21ai_1
X_3992_ _2281_ Tile_X0Y0_DSP_top.Inst_DSP_top_ConfigMem.Inst_frame10_bit25.Q _2280_
+ VPWR VGND sg13g2_nand2_1
X_5731_ Tile_X0Y1_FrameData[24] Tile_X0Y1_FrameStrobe[2] Tile_X0Y1_DSP_bot.Inst_DSP_bot_ConfigMem.Inst_frame2_bit24.Q
+ VPWR VGND sg13g2_dlhq_1
X_2943_ _1318_ _1319_ _1320_ VPWR VGND sg13g2_nor2b_1
X_5800_ Tile_X0Y1_FrameData[19] Tile_X0Y1_FrameStrobe[4] Tile_X0Y1_DSP_bot.Inst_DSP_bot_ConfigMem.Inst_frame4_bit19.Q
+ VPWR VGND sg13g2_dlhq_1
XFILLER_22_206 VPWR VGND sg13g2_decap_4
X_4544_ VGND VPWR Tile_X0Y0_S2END[7] Tile_X0Y0_DSP_top.Inst_DSP_top_ConfigMem.Inst_frame4_bit24.Q
+ _0300_ Tile_X0Y0_DSP_top.Inst_DSP_top_ConfigMem.Inst_frame4_bit25.Q sg13g2_a21oi_1
X_5593_ Tile_X0Y0_FrameData[20] Tile_X0Y1_FrameStrobe[12] Tile_X0Y0_DSP_top.Inst_DSP_top_ConfigMem.Inst_frame12_bit20.Q
+ VPWR VGND sg13g2_dlhq_1
X_4613_ _0050_ _0359_ _0366_ VPWR VGND sg13g2_nor2_1
X_2874_ VGND VPWR _0088_ _1252_ _1253_ Tile_X0Y1_DSP_bot.Inst_DSP_bot_ConfigMem.Inst_frame8_bit0.Q
+ sg13g2_a21oi_1
X_5662_ Tile_X0Y1_FrameData[29] Tile_X0Y1_FrameStrobe[0] Tile_X0Y1_DSP_bot.Inst_DSP_bot_ConfigMem.Inst_frame0_bit29.Q
+ VPWR VGND sg13g2_dlhq_1
X_6214_ Tile_X0Y1_FrameStrobe[2] Tile_X0Y0_FrameStrobe_O[2] VPWR VGND sg13g2_buf_1
X_6145_ Tile_X0Y0_E2MID[1] Tile_X0Y0_E2BEGb[1] VPWR VGND sg13g2_buf_1
X_6076_ VPWR VGND _2474_ sg13g2_tiehi
X_3357_ Tile_X0Y1_DSP_bot.Inst_DSP_bot_ConfigMem.Inst_frame1_bit26.Q _1719_ _1720_
+ VPWR VGND sg13g2_nor2_1
X_4475_ _0234_ _0233_ Tile_X0Y1_DSP_bot.Inst_DSP_bot_ConfigMem.Inst_frame1_bit2.Q
+ VPWR VGND sg13g2_nand2b_1
X_3426_ VPWR _1785_ _1784_ VGND sg13g2_inv_1
XFILLER_53_320 VPWR VGND sg13g2_fill_2
X_3288_ Tile_X0Y1_DSP_bot.Inst_DSP_bot_ConfigMem.Inst_frame8_bit26.Q _1654_ _1655_
+ VPWR VGND sg13g2_and2_1
X_5027_ VGND VPWR Tile_X0Y1_DSP_bot.Inst_DSP_bot_ConfigMem.Inst_frame1_bit5.Q _0759_
+ _0762_ Tile_X0Y1_DSP_bot.Inst_DSP_bot_ConfigMem.Inst_frame1_bit6.Q sg13g2_a21oi_1
XFILLER_13_217 VPWR VGND sg13g2_fill_2
X_5929_ Tile_X0Y1_FrameData[18] Tile_X0Y1_FrameStrobe[8] Tile_X0Y1_DSP_bot.Inst_DSP_bot_ConfigMem.Inst_frame8_bit18.Q
+ VPWR VGND sg13g2_dlhq_1
XFILLER_107_344 VPWR VGND sg13g2_fill_2
X_2590_ _0977_ VPWR _0979_ VGND Tile_X0Y0_DSP_top.Inst_DSP_top_ConfigMem.Inst_frame6_bit3.Q
+ _0978_ sg13g2_o21ai_1
X_4260_ VPWR _0023_ Tile_X0Y0_DSP_top.Inst_DSP_top_ConfigMem.Inst_frame2_bit6.Q VGND
+ sg13g2_inv_1
X_3211_ _1581_ _0072_ Tile_X0Y0_DSP_top.Inst_DSP_top_switch_matrix.inst_cus_mux41_buf_top2bot8.X
+ VPWR VGND sg13g2_nand2b_1
X_3142_ _1434_ _1435_ _1213_ _1516_ VPWR VGND sg13g2_nand3_1
XFILLER_5_65 VPWR VGND sg13g2_fill_2
XFILLER_5_43 VPWR VGND sg13g2_fill_1
X_4191_ Tile_X0Y1_DSP_bot.Inst_DSP_bot_ConfigMem.Inst_frame9_bit9.Q _0130_ _1794_
+ _1885_ _1103_ Tile_X0Y1_DSP_bot.Inst_DSP_bot_ConfigMem.Inst_frame9_bit8.Q _2433_
+ VPWR VGND sg13g2_mux4_1
X_3073_ _1450_ _1449_ _1442_ VPWR VGND sg13g2_nand2b_1
X_3975_ VGND VPWR Tile_X0Y0_DSP_top.Inst_DSP_top_ConfigMem.Inst_frame10_bit22.Q _2264_
+ _2265_ Tile_X0Y0_DSP_top.Inst_DSP_top_ConfigMem.Inst_frame10_bit23.Q sg13g2_a21oi_1
X_2857_ VGND VPWR Tile_X0Y1_DSP_bot.Inst_DSP_bot_ConfigMem.Inst_frame3_bit16.Q _0131_
+ _1237_ _1236_ sg13g2_a21oi_1
X_2926_ VGND VPWR Tile_X0Y1_DSP_bot.Inst_DSP_bot_ConfigMem.Inst_frame6_bit9.Q _1300_
+ _1304_ _1303_ sg13g2_a21oi_1
X_5645_ _2517_ VGND VPWR Tile_X0Y1_DSP_bot.C5 Tile_X0Y1_DSP_bot.Inst_MULADD.C_reg\[5\]
+ clknet_3_0_0_Tile_X0Y1_UserCLK_regs sg13g2_dfrbpq_1
X_5714_ Tile_X0Y1_FrameData[9] Tile_X0Y1_FrameStrobe[1] Tile_X0Y1_DSP_bot.Inst_DSP_bot_ConfigMem.Inst_frame1_bit9.Q
+ VPWR VGND sg13g2_dlhq_1
X_2788_ _1169_ VPWR _1170_ VGND _0047_ Tile_X0Y0_DSP_top.Inst_DSP_top_ConfigMem.Inst_frame2_bit24.Q
+ sg13g2_o21ai_1
X_5576_ Tile_X0Y0_FrameData[5] Tile_X0Y1_FrameStrobe[11] Tile_X0Y0_DSP_top.Inst_DSP_top_ConfigMem.Inst_frame11_bit5.Q
+ VPWR VGND sg13g2_dlhq_1
X_4527_ Tile_X0Y1_DSP_bot.Inst_DSP_bot_ConfigMem.Inst_frame1_bit10.Q VPWR _0284_ VGND
+ Tile_X0Y1_DSP_bot.Inst_DSP_bot_ConfigMem.Inst_frame1_bit9.Q _0283_ sg13g2_o21ai_1
X_4458_ _0217_ Tile_X0Y1_DSP_bot.Inst_DSP_bot_ConfigMem.Inst_frame2_bit15.Q _0218_
+ VPWR VGND sg13g2_nor2b_1
X_6128_ VPWR VGND _2526_ sg13g2_tiehi
X_4389_ Tile_X0Y1_DSP_bot.Inst_DSP_bot_ConfigMem.Inst_frame6_bit14.Q Tile_X0Y1_N2MID[1]
+ Tile_X0Y1_E2MID[1] Tile_X0Y0_DSP_top.Inst_DSP_top_switch_matrix.JS2BEG1 Tile_X0Y1_W2MID[1]
+ Tile_X0Y1_DSP_bot.Inst_DSP_bot_ConfigMem.Inst_frame6_bit15.Q _0151_ VPWR VGND sg13g2_mux4_1
X_3409_ Tile_X0Y1_DSP_bot.Inst_DSP_bot_ConfigMem.Inst_frame6_bit31.Q VPWR _1769_ VGND
+ Tile_X0Y1_W2MID[1] _0103_ sg13g2_o21ai_1
X_6059_ Tile_X0Y1_FrameData[16] Tile_X0Y1_FrameStrobe[12] Tile_X0Y1_DSP_bot.Inst_DSP_bot_ConfigMem.Inst_frame12_bit16.Q
+ VPWR VGND sg13g2_dlhq_1
XFILLER_81_69 VPWR VGND sg13g2_fill_1
XANTENNA_116 VPWR VGND Tile_X0Y0_S2MID[4] sg13g2_antennanp
XANTENNA_127 VPWR VGND Tile_X0Y0_W2MID[7] sg13g2_antennanp
XANTENNA_105 VPWR VGND Tile_X0Y0_S2MID[4] sg13g2_antennanp
XFILLER_38_191 VPWR VGND sg13g2_fill_2
XANTENNA_138 VPWR VGND Tile_X0Y0_S4END[6] sg13g2_antennanp
XANTENNA_149 VPWR VGND Tile_X0Y0_S4END[6] sg13g2_antennanp
XFILLER_5_213 VPWR VGND sg13g2_fill_1
XFILLER_107_185 VPWR VGND sg13g2_fill_2
XFILLER_51_109 VPWR VGND sg13g2_fill_1
XFILLER_36_106 VPWR VGND sg13g2_fill_1
XFILLER_17_342 VPWR VGND sg13g2_fill_1
X_3760_ _2090_ Tile_X0Y0_DSP_top.Inst_DSP_top_ConfigMem.Inst_frame1_bit28.Q _0134_
+ VPWR VGND sg13g2_nand2_1
XFILLER_55_92 VPWR VGND sg13g2_fill_2
XFILLER_32_345 VPWR VGND sg13g2_fill_1
XFILLER_32_312 VPWR VGND sg13g2_fill_1
X_2711_ Tile_X0Y1_DSP_bot.Inst_DSP_bot_ConfigMem.Inst_frame2_bit9.Q Tile_X0Y0_S2MID[3]
+ Tile_X0Y1_W2END[3] Tile_X0Y0_S4END[7] Tile_X0Y1_W6END[1] Tile_X0Y1_DSP_bot.Inst_DSP_bot_ConfigMem.Inst_frame2_bit8.Q
+ _1096_ VPWR VGND sg13g2_mux4_1
X_3691_ _2023_ VPWR _2026_ VGND _1996_ _2024_ sg13g2_o21ai_1
X_5361_ Tile_X0Y0_FrameData[28] Tile_X0Y1_FrameStrobe[5] Tile_X0Y0_DSP_top.Inst_DSP_top_ConfigMem.Inst_frame5_bit28.Q
+ VPWR VGND sg13g2_dlhq_1
X_5292_ Tile_X0Y0_FrameData[1] Tile_X0Y1_FrameStrobe[2] Tile_X0Y0_DSP_top.Inst_DSP_top_ConfigMem.Inst_frame2_bit1.Q
+ VPWR VGND sg13g2_dlhq_1
X_5430_ Tile_X0Y0_FrameData[23] Tile_X0Y1_FrameStrobe[7] Tile_X0Y0_DSP_top.Inst_DSP_top_ConfigMem.Inst_frame7_bit23.Q
+ VPWR VGND sg13g2_dlhq_1
X_2573_ VGND VPWR _0960_ _0962_ _0963_ Tile_X0Y0_DSP_top.Inst_DSP_top_ConfigMem.Inst_frame9_bit27.Q
+ sg13g2_a21oi_1
X_2642_ Tile_X0Y1_DSP_bot.Inst_DSP_bot_ConfigMem.Inst_frame3_bit14.Q VPWR _1030_ VGND
+ Tile_X0Y1_DSP_bot.Inst_DSP_bot_ConfigMem.Inst_frame3_bit13.Q _1027_ sg13g2_o21ai_1
X_4312_ VPWR _0075_ Tile_X0Y1_E2MID[4] VGND sg13g2_inv_1
X_3125_ Tile_X0Y0_DSP_top.Inst_DSP_top_ConfigMem.Inst_frame8_bit17.Q VPWR _1501_ VGND
+ Tile_X0Y0_DSP_top.Inst_DSP_top_ConfigMem.Inst_frame8_bit16.Q _1500_ sg13g2_o21ai_1
X_4174_ Tile_X0Y1_DSP_bot.Inst_DSP_bot_ConfigMem.Inst_frame10_bit24.Q Tile_X0Y1_DSP_bot.Inst_DSP_bot_switch_matrix.Q9
+ _1785_ _1866_ _0784_ Tile_X0Y1_DSP_bot.Inst_DSP_bot_ConfigMem.Inst_frame10_bit23.Q
+ _2419_ VPWR VGND sg13g2_mux4_1
X_4243_ Tile_X0Y1_DSP_bot.Inst_DSP_bot_switch_matrix.clr _1952_ _0006_ VPWR VGND sg13g2_nor2_1
X_3056_ _1433_ _1211_ _1212_ VPWR VGND sg13g2_xnor2_1
X_3889_ Tile_X0Y0_DSP_top.Inst_DSP_top_ConfigMem.Inst_frame11_bit8.Q Tile_X0Y0_DSP_top.Inst_DSP_top_switch_matrix.bot2top4
+ _0644_ Tile_X0Y0_DSP_top.Inst_DSP_top_switch_matrix.JN2BEG0 _0668_ Tile_X0Y0_DSP_top.Inst_DSP_top_ConfigMem.Inst_frame11_bit9.Q
+ Tile_X0Y0_DSP_top.Inst_DSP_top_switch_matrix.E1BEG1 VPWR VGND sg13g2_mux4_1
X_3958_ VGND VPWR _0120_ _0980_ _2251_ Tile_X0Y0_DSP_top.Inst_DSP_top_ConfigMem.Inst_frame11_bit27.Q
+ sg13g2_a21oi_1
X_5628_ _2500_ VGND VPWR Tile_X0Y0_DSP_top.Inst_DSP_top_switch_matrix.inst_cus_mux41_buf_top2bot0.X
+ Tile_X0Y1_DSP_bot.Inst_MULADD.A_reg\[4\] clknet_3_4_0_Tile_X0Y1_UserCLK_regs sg13g2_dfrbpq_1
X_2909_ Tile_X0Y1_DSP_bot.Inst_DSP_bot_ConfigMem.Inst_frame0_bit8.Q Tile_X0Y1_E2END[3]
+ _1287_ VPWR VGND sg13g2_nor2b_1
X_5559_ Tile_X0Y0_FrameData[22] Tile_X0Y1_FrameStrobe[11] Tile_X0Y0_DSP_top.Inst_DSP_top_ConfigMem.Inst_frame11_bit22.Q
+ VPWR VGND sg13g2_dlhq_1
XFILLER_58_220 VPWR VGND sg13g2_fill_1
XFILLER_96_359 VPWR VGND sg13g2_fill_2
XFILLER_2_55 VPWR VGND sg13g2_fill_1
XFILLER_1_260 VPWR VGND sg13g2_fill_2
X_4861_ Tile_X0Y0_DSP_top.Inst_DSP_top_ConfigMem.Inst_frame5_bit6.Q Tile_X0Y1_N2MID[0]
+ Tile_X0Y0_E2END[0] Tile_X0Y0_S2END[0] Tile_X0Y0_WW4END[3] Tile_X0Y0_DSP_top.Inst_DSP_top_ConfigMem.Inst_frame5_bit7.Q
+ _0603_ VPWR VGND sg13g2_mux4_1
X_4930_ Tile_X0Y0_DSP_top.Inst_DSP_top_ConfigMem.Inst_frame10_bit4.Q Tile_X0Y0_DSP_top.Inst_DSP_top_switch_matrix.bot2top5
+ _0644_ Tile_X0Y0_DSP_top.Inst_DSP_top_switch_matrix.E2BEG0 _0668_ Tile_X0Y0_DSP_top.Inst_DSP_top_ConfigMem.Inst_frame10_bit5.Q
+ _0669_ VPWR VGND sg13g2_mux4_1
XANTENNA_38 VPWR VGND Tile_X0Y1_N4END[12] sg13g2_antennanp
XANTENNA_49 VPWR VGND Tile_X0Y1_N4END[9] sg13g2_antennanp
X_3743_ VGND VPWR Tile_X0Y1_N2MID[0] Tile_X0Y0_DSP_top.Inst_DSP_top_ConfigMem.Inst_frame1_bit28.Q
+ _2073_ Tile_X0Y0_DSP_top.Inst_DSP_top_ConfigMem.Inst_frame1_bit29.Q sg13g2_a21oi_1
X_3812_ _2136_ VPWR Tile_X0Y0_DSP_top.Inst_DSP_top_switch_matrix.bot2top8 VGND Tile_X0Y1_DSP_bot.Inst_DSP_bot_ConfigMem.Inst_frame12_bit5.Q
+ _2135_ sg13g2_o21ai_1
XANTENNA_16 VPWR VGND Tile_X0Y0_S4END[0] sg13g2_antennanp
X_3674_ _0070_ VPWR _2010_ VGND Tile_X0Y0_E2MID[5] _0069_ sg13g2_o21ai_1
XFILLER_32_186 VPWR VGND sg13g2_fill_1
X_6462_ Tile_X0Y1_DSP_bot.Inst_DSP_bot_switch_matrix.SS4BEG1 Tile_X0Y1_SS4BEG[13]
+ VPWR VGND sg13g2_buf_1
X_4792_ Tile_X0Y1_DSP_bot.Inst_DSP_bot_ConfigMem.Inst_frame4_bit0.Q Tile_X0Y1_DSP_bot.Inst_DSP_bot_switch_matrix.Q5
+ _0536_ VPWR VGND sg13g2_nor2_1
XFILLER_9_360 VPWR VGND sg13g2_fill_1
XANTENNA_27 VPWR VGND Tile_X0Y1_EE4END[5] sg13g2_antennanp
X_5275_ Tile_X0Y0_FrameData[18] Tile_X0Y1_FrameStrobe[2] Tile_X0Y0_DSP_top.Inst_DSP_top_ConfigMem.Inst_frame2_bit18.Q
+ VPWR VGND sg13g2_dlhq_1
X_2556_ VGND VPWR Tile_X0Y0_DSP_top.Inst_DSP_top_ConfigMem.Inst_frame4_bit12.Q Tile_X0Y0_DSP_top.Inst_DSP_top_switch_matrix.bot2top6
+ _0947_ _0946_ sg13g2_a21oi_1
XFILLER_87_304 VPWR VGND sg13g2_decap_4
X_5344_ Tile_X0Y0_FrameData[13] Tile_X0Y1_FrameStrobe[4] Tile_X0Y0_DSP_top.Inst_DSP_top_ConfigMem.Inst_frame4_bit13.Q
+ VPWR VGND sg13g2_dlhq_1
X_5413_ Tile_X0Y0_FrameData[8] Tile_X0Y1_FrameStrobe[6] Tile_X0Y0_DSP_top.Inst_DSP_top_ConfigMem.Inst_frame6_bit8.Q
+ VPWR VGND sg13g2_dlhq_1
XFILLER_63_0 VPWR VGND sg13g2_fill_2
X_2625_ _1013_ _1004_ _1011_ VPWR VGND sg13g2_xnor2_1
X_6393_ Tile_X0Y1_FrameData[12] Tile_X0Y1_FrameData_O[12] VPWR VGND sg13g2_buf_1
X_3108_ _1484_ _0037_ Tile_X0Y0_DSP_top.Inst_DSP_top_ConfigMem.Inst_frame7_bit22.Q
+ VPWR VGND sg13g2_nand2_1
X_4088_ _2349_ VPWR _2350_ VGND Tile_X0Y1_DSP_bot.Inst_DSP_bot_ConfigMem.Inst_frame2_bit0.Q
+ Tile_X0Y1_DSP_bot.Inst_DSP_bot_switch_matrix.Q5 sg13g2_o21ai_1
X_4157_ VGND VPWR Tile_X0Y1_DSP_bot.Inst_DSP_bot_ConfigMem.Inst_frame11_bit26.Q _1784_
+ _2406_ _2405_ sg13g2_a21oi_1
X_4226_ Tile_X0Y1_DSP_bot.Inst_DSP_bot_ConfigMem.Inst_frame8_bit28.Q Tile_X0Y1_DSP_bot.Inst_DSP_bot_switch_matrix.E2BEG3
+ Tile_X0Y1_DSP_bot.Inst_DSP_bot_switch_matrix.JS2BEG2 Tile_X0Y1_DSP_bot.Inst_DSP_bot_switch_matrix.JS2BEG3
+ Tile_X0Y1_DSP_bot.Inst_DSP_bot_switch_matrix.JW2BEG2 Tile_X0Y1_DSP_bot.Inst_DSP_bot_ConfigMem.Inst_frame8_bit29.Q
+ _2464_ VPWR VGND sg13g2_mux4_1
X_3039_ _1408_ _1377_ _1416_ VPWR VGND sg13g2_xor2_1
XFILLER_11_326 VPWR VGND sg13g2_fill_1
X_3390_ VGND VPWR Tile_X0Y1_DSP_bot.Inst_DSP_bot_ConfigMem.Inst_frame8_bit24.Q _1749_
+ _1751_ _1750_ sg13g2_a21oi_1
X_5060_ _0792_ Tile_X0Y0_DSP_top.Inst_DSP_top_ConfigMem.Inst_frame1_bit10.Q _0793_
+ VPWR VGND sg13g2_nor2b_1
XFILLER_96_178 VPWR VGND sg13g2_fill_2
X_4011_ VGND VPWR _0123_ _0129_ _2297_ Tile_X0Y0_DSP_top.Inst_DSP_top_ConfigMem.Inst_frame9_bit10.Q
+ sg13g2_a21oi_1
XFILLER_69_359 VPWR VGND sg13g2_fill_2
XFILLER_37_256 VPWR VGND sg13g2_decap_8
X_4913_ Tile_X0Y0_DSP_top.Inst_DSP_top_ConfigMem.Inst_frame3_bit2.Q VPWR _0653_ VGND
+ _0651_ _0652_ sg13g2_o21ai_1
X_4844_ Tile_X0Y0_DSP_top.Inst_DSP_top_ConfigMem.Inst_frame1_bit4.Q _0190_ _0587_
+ VPWR VGND sg13g2_nor2_1
X_5893_ Tile_X0Y1_FrameData[22] Tile_X0Y1_FrameStrobe[7] Tile_X0Y1_DSP_bot.Inst_DSP_bot_ConfigMem.Inst_frame7_bit22.Q
+ VPWR VGND sg13g2_dlhq_1
X_5962_ Tile_X0Y1_FrameData[17] Tile_X0Y1_FrameStrobe[9] Tile_X0Y1_DSP_bot.Inst_DSP_bot_ConfigMem.Inst_frame9_bit17.Q
+ VPWR VGND sg13g2_dlhq_1
X_4775_ VGND VPWR Tile_X0Y0_E2MID[7] Tile_X0Y0_DSP_top.Inst_DSP_top_ConfigMem.Inst_frame6_bit8.Q
+ _0520_ _0519_ sg13g2_a21oi_1
X_3726_ _2057_ VPWR Tile_X0Y0_DSP_top.Inst_DSP_top_switch_matrix.bot2top7 VGND Tile_X0Y1_DSP_bot.Inst_DSP_bot_ConfigMem.Inst_frame12_bit5.Q
+ _2056_ sg13g2_o21ai_1
X_3657_ _1965_ VPWR _1994_ VGND Tile_X0Y1_DSP_bot.Inst_DSP_bot_ConfigMem.Inst_frame12_bit3.Q
+ _1993_ sg13g2_o21ai_1
X_6445_ Tile_X0Y1_DSP_bot.Inst_DSP_bot_switch_matrix.S4BEG0 Tile_X0Y1_S4BEG[12] VPWR
+ VGND sg13g2_buf_1
X_5327_ Tile_X0Y0_FrameData[30] Tile_X0Y1_FrameStrobe[4] Tile_X0Y0_DSP_top.Inst_DSP_top_ConfigMem.Inst_frame4_bit30.Q
+ VPWR VGND sg13g2_dlhq_1
X_5258_ Tile_X0Y0_FrameData[3] Tile_X0Y1_FrameStrobe[1] Tile_X0Y0_DSP_top.Inst_DSP_top_ConfigMem.Inst_frame1_bit3.Q
+ VPWR VGND sg13g2_dlhq_1
X_3588_ _1508_ _1939_ _1940_ VPWR VGND sg13g2_nor2_1
X_2608_ _0996_ _0994_ _0902_ VPWR VGND sg13g2_nand2b_1
XFILLER_57_16 VPWR VGND sg13g2_fill_1
X_6376_ Tile_X0Y1_EE4END[15] Tile_X0Y1_EE4BEG[11] VPWR VGND sg13g2_buf_1
X_2539_ Tile_X0Y1_DSP_bot.Inst_DSP_bot_ConfigMem.Inst_frame4_bit8.Q Tile_X0Y1_E6END[1]
+ Tile_X0Y0_S2MID[3] Tile_X0Y1_W2END[3] Tile_X0Y1_WW4END[1] Tile_X0Y1_DSP_bot.Inst_DSP_bot_ConfigMem.Inst_frame4_bit9.Q
+ _0932_ VPWR VGND sg13g2_mux4_1
X_5189_ _0915_ Tile_X0Y0_S1END[1] Tile_X0Y0_DSP_top.Inst_DSP_top_ConfigMem.Inst_frame3_bit16.Q
+ VPWR VGND sg13g2_nand2b_1
X_4209_ _2446_ Tile_X0Y1_DSP_bot.Inst_DSP_bot_ConfigMem.Inst_frame9_bit16.Q _2448_
+ _2449_ VPWR VGND sg13g2_a21o_1
XFILLER_63_70 VPWR VGND sg13g2_fill_1
X_2890_ _1268_ _1266_ _1267_ VPWR VGND sg13g2_nand2_1
X_4491_ Tile_X0Y0_S4END[3] Tile_X0Y0_DSP_top.Inst_DSP_top_switch_matrix.JN2BEG4 Tile_X0Y0_DSP_top.Inst_DSP_top_ConfigMem.Inst_frame0_bit24.Q
+ _0249_ VPWR VGND sg13g2_mux2_1
X_4560_ _0315_ Tile_X0Y0_DSP_top.Inst_DSP_top_ConfigMem.Inst_frame3_bit8.Q _0133_
+ VPWR VGND sg13g2_nand2_1
X_3511_ VPWR _1866_ _1865_ VGND sg13g2_inv_1
X_6230_ Tile_X0Y1_FrameStrobe[18] Tile_X0Y0_FrameStrobe_O[18] VPWR VGND sg13g2_buf_1
X_6161_ Tile_X0Y0_E6END[11] Tile_X0Y0_E6BEG[9] VPWR VGND sg13g2_buf_1
X_5112_ VPWR _0842_ _0841_ VGND sg13g2_inv_1
X_3373_ Tile_X0Y1_DSP_bot.Inst_DSP_bot_ConfigMem.Inst_frame8_bit23.Q VPWR _1735_ VGND
+ Tile_X0Y1_DSP_bot.Inst_DSP_bot_ConfigMem.Inst_frame8_bit22.Q _1734_ sg13g2_o21ai_1
X_6092_ VPWR VGND _2490_ sg13g2_tiehi
X_3442_ VGND VPWR Tile_X0Y0_SS4END[6] Tile_X0Y1_DSP_bot.Inst_DSP_bot_ConfigMem.Inst_frame0_bit26.Q
+ _1800_ _1799_ sg13g2_a21oi_1
XFILLER_65_340 VPWR VGND sg13g2_fill_2
X_5043_ _0768_ VPWR Tile_X0Y1_DSP_bot.Inst_DSP_bot_switch_matrix.JW2BEG1 VGND Tile_X0Y1_DSP_bot.Inst_DSP_bot_ConfigMem.Inst_frame1_bit7.Q
+ _0777_ sg13g2_o21ai_1
X_4827_ _0569_ VPWR _0570_ VGND _0037_ Tile_X0Y0_DSP_top.Inst_DSP_top_ConfigMem.Inst_frame7_bit6.Q
+ sg13g2_o21ai_1
X_5945_ Tile_X0Y1_FrameData[2] Tile_X0Y1_FrameStrobe[8] Tile_X0Y1_DSP_bot.Inst_DSP_bot_ConfigMem.Inst_frame8_bit2.Q
+ VPWR VGND sg13g2_dlhq_1
X_5876_ Tile_X0Y1_FrameData[7] Tile_X0Y1_FrameStrobe[6] Tile_X0Y1_DSP_bot.Inst_DSP_bot_ConfigMem.Inst_frame6_bit7.Q
+ VPWR VGND sg13g2_dlhq_1
X_4758_ VGND VPWR Tile_X0Y0_DSP_top.Inst_DSP_top_ConfigMem.Inst_frame4_bit8.Q _0134_
+ _0504_ _0503_ sg13g2_a21oi_1
X_3709_ _2043_ Tile_X0Y0_DSP_top.Inst_DSP_top_ConfigMem.Inst_frame1_bit24.Q Tile_X0Y0_W1END[3]
+ VPWR VGND sg13g2_nand2b_1
X_4689_ Tile_X0Y1_DSP_bot.Inst_DSP_bot_ConfigMem.Inst_frame4_bit25.Q VPWR _0439_ VGND
+ Tile_X0Y1_DSP_bot.Inst_DSP_bot_ConfigMem.Inst_frame4_bit24.Q Tile_X0Y1_W1END[1]
+ sg13g2_o21ai_1
X_6428_ Tile_X0Y0_DSP_top.Inst_DSP_top_switch_matrix.JS2BEG3 Tile_X0Y1_S2BEGb[3] VPWR
+ VGND sg13g2_buf_1
XFILLER_68_37 VPWR VGND sg13g2_fill_1
X_6359_ Tile_X0Y1_E6END[8] Tile_X0Y1_E6BEG[6] VPWR VGND sg13g2_buf_1
XFILLER_17_85 VPWR VGND sg13g2_fill_1
XFILLER_17_96 VPWR VGND sg13g2_decap_4
X_3991_ _2279_ VPWR _2280_ VGND Tile_X0Y0_DSP_top.Inst_DSP_top_ConfigMem.Inst_frame10_bit24.Q
+ _0388_ sg13g2_o21ai_1
X_2942_ _1319_ _1315_ _1316_ VPWR VGND sg13g2_xnor2_1
X_5730_ Tile_X0Y1_FrameData[25] Tile_X0Y1_FrameStrobe[2] Tile_X0Y1_DSP_bot.Inst_DSP_bot_ConfigMem.Inst_frame2_bit25.Q
+ VPWR VGND sg13g2_dlhq_1
X_2873_ Tile_X0Y1_N2MID[2] Tile_X0Y1_E2MID[2] Tile_X0Y1_DSP_bot.Inst_DSP_bot_ConfigMem.Inst_frame7_bit10.Q
+ _1252_ VPWR VGND sg13g2_mux2_1
X_5661_ Tile_X0Y1_FrameData[30] Tile_X0Y1_FrameStrobe[0] Tile_X0Y1_DSP_bot.Inst_DSP_bot_ConfigMem.Inst_frame0_bit30.Q
+ VPWR VGND sg13g2_dlhq_1
X_6213_ Tile_X0Y1_FrameStrobe[1] Tile_X0Y0_FrameStrobe_O[1] VPWR VGND sg13g2_buf_1
X_4543_ Tile_X0Y0_DSP_top.Inst_DSP_top_ConfigMem.Inst_frame4_bit26.Q _0298_ _0299_
+ VPWR VGND sg13g2_nor2_1
X_5592_ Tile_X0Y0_FrameData[21] Tile_X0Y1_FrameStrobe[12] Tile_X0Y0_DSP_top.Inst_DSP_top_ConfigMem.Inst_frame12_bit21.Q
+ VPWR VGND sg13g2_dlhq_1
X_4612_ Tile_X0Y1_DSP_bot.Inst_DSP_bot_ConfigMem.Inst_frame4_bit22.Q _0362_ _0365_
+ VPWR VGND _0364_ sg13g2_nand3b_1
X_4474_ Tile_X0Y1_DSP_bot.Inst_DSP_bot_ConfigMem.Inst_frame1_bit0.Q Tile_X0Y1_N1END[3]
+ Tile_X0Y1_N2END[1] Tile_X0Y1_E2END[1] Tile_X0Y1_E6END[1] Tile_X0Y1_DSP_bot.Inst_DSP_bot_ConfigMem.Inst_frame1_bit1.Q
+ _0233_ VPWR VGND sg13g2_mux4_1
X_6144_ Tile_X0Y0_E2MID[0] Tile_X0Y0_E2BEGb[0] VPWR VGND sg13g2_buf_1
X_3356_ Tile_X0Y1_DSP_bot.Inst_DSP_bot_ConfigMem.Inst_frame1_bit24.Q Tile_X0Y1_N1END[3]
+ Tile_X0Y1_N2END[7] Tile_X0Y1_E1END[3] Tile_X0Y1_E2END[7] Tile_X0Y1_DSP_bot.Inst_DSP_bot_ConfigMem.Inst_frame1_bit25.Q
+ _1719_ VPWR VGND sg13g2_mux4_1
X_6075_ Tile_X0Y1_FrameData[0] Tile_X0Y1_FrameStrobe[12] Tile_X0Y1_DSP_bot.Inst_DSP_bot_ConfigMem.Inst_frame12_bit0.Q
+ VPWR VGND sg13g2_dlhq_1
X_3287_ _1652_ Tile_X0Y1_DSP_bot.Inst_DSP_bot_ConfigMem.Inst_frame8_bit25.Q _1653_
+ _1654_ VPWR VGND sg13g2_a21o_1
X_5026_ VGND VPWR Tile_X0Y1_DSP_bot.Inst_DSP_bot_ConfigMem.Inst_frame1_bit4.Q Tile_X0Y1_DSP_bot.Inst_DSP_bot_switch_matrix.Q2
+ _0761_ _0760_ sg13g2_a21oi_1
X_3425_ Tile_X0Y1_DSP_bot.Inst_DSP_bot_ConfigMem.Inst_frame7_bit29.Q _0075_ _0076_
+ _0859_ _1749_ Tile_X0Y1_DSP_bot.Inst_DSP_bot_ConfigMem.Inst_frame7_bit28.Q _1784_
+ VPWR VGND sg13g2_mux4_1
X_5928_ Tile_X0Y1_FrameData[19] Tile_X0Y1_FrameStrobe[8] Tile_X0Y1_DSP_bot.Inst_DSP_bot_ConfigMem.Inst_frame8_bit19.Q
+ VPWR VGND sg13g2_dlhq_1
X_5859_ Tile_X0Y1_FrameData[24] Tile_X0Y1_FrameStrobe[6] Tile_X0Y1_DSP_bot.Inst_DSP_bot_ConfigMem.Inst_frame6_bit24.Q
+ VPWR VGND sg13g2_dlhq_1
XFILLER_95_35 VPWR VGND sg13g2_fill_2
XFILLER_71_162 VPWR VGND sg13g2_fill_2
XFILLER_60_82 VPWR VGND sg13g2_fill_2
XFILLER_8_299 VPWR VGND sg13g2_fill_1
XFILLER_94_221 VPWR VGND sg13g2_fill_1
X_3210_ _1580_ VPWR Tile_X0Y0_DSP_top.Inst_DSP_top_switch_matrix.inst_cus_mux41_buf_top2bot8.X
+ VGND _1563_ _1565_ sg13g2_o21ai_1
X_3141_ _1509_ VPWR _1515_ VGND Tile_X0Y1_DSP_bot.Inst_DSP_bot_ConfigMem.Inst_frame12_bit3.Q
+ _1514_ sg13g2_o21ai_1
XFILLER_69_91 VPWR VGND sg13g2_fill_1
XFILLER_5_77 VPWR VGND sg13g2_fill_1
X_4190_ Tile_X0Y1_DSP_bot.Inst_DSP_bot_ConfigMem.Inst_frame9_bit10.Q _2431_ _2432_
+ VPWR VGND sg13g2_nor2_1
X_3072_ _1145_ _1438_ _1449_ VPWR VGND sg13g2_nor2b_1
XFILLER_108_109 VPWR VGND sg13g2_fill_1
XFILLER_93_0 VPWR VGND sg13g2_fill_2
X_3974_ Tile_X0Y0_W1END[3] Tile_X0Y0_DSP_top.Inst_DSP_top_switch_matrix.bot2top3 Tile_X0Y0_DSP_top.Inst_DSP_top_ConfigMem.Inst_frame10_bit21.Q
+ _2264_ VPWR VGND sg13g2_mux2_1
X_2856_ Tile_X0Y1_DSP_bot.Inst_DSP_bot_ConfigMem.Inst_frame3_bit17.Q VPWR _1236_ VGND
+ Tile_X0Y1_DSP_bot.Inst_DSP_bot_ConfigMem.Inst_frame3_bit16.Q Tile_X0Y1_DSP_bot.Inst_DSP_bot_switch_matrix.Q7
+ sg13g2_o21ai_1
X_2925_ Tile_X0Y1_DSP_bot.Inst_DSP_bot_ConfigMem.Inst_frame9_bit30.Q VPWR _1303_ VGND
+ Tile_X0Y1_DSP_bot.Inst_DSP_bot_ConfigMem.Inst_frame6_bit9.Q _1302_ sg13g2_o21ai_1
X_5644_ _2516_ VGND VPWR Tile_X0Y1_DSP_bot.C4 Tile_X0Y1_DSP_bot.Inst_MULADD.C_reg\[4\]
+ clknet_3_0_0_Tile_X0Y1_UserCLK_regs sg13g2_dfrbpq_1
X_5713_ Tile_X0Y1_FrameData[10] Tile_X0Y1_FrameStrobe[1] Tile_X0Y1_DSP_bot.Inst_DSP_bot_ConfigMem.Inst_frame1_bit10.Q
+ VPWR VGND sg13g2_dlhq_1
X_2787_ VGND VPWR Tile_X0Y0_S2END[7] Tile_X0Y0_DSP_top.Inst_DSP_top_ConfigMem.Inst_frame2_bit24.Q
+ _1169_ Tile_X0Y0_DSP_top.Inst_DSP_top_ConfigMem.Inst_frame2_bit25.Q sg13g2_a21oi_1
XFILLER_104_359 VPWR VGND sg13g2_fill_2
X_5575_ Tile_X0Y0_FrameData[6] Tile_X0Y1_FrameStrobe[11] Tile_X0Y0_DSP_top.Inst_DSP_top_ConfigMem.Inst_frame11_bit6.Q
+ VPWR VGND sg13g2_dlhq_1
X_4526_ Tile_X0Y0_S2MID[3] Tile_X0Y0_S4END[7] Tile_X0Y1_DSP_bot.Inst_DSP_bot_ConfigMem.Inst_frame1_bit8.Q
+ _0283_ VPWR VGND sg13g2_mux2_1
X_4457_ VGND VPWR Tile_X0Y1_DSP_bot.Inst_DSP_bot_ConfigMem.Inst_frame2_bit13.Q _0215_
+ _0217_ _0216_ sg13g2_a21oi_1
X_3408_ VGND VPWR _0102_ _1767_ _1768_ Tile_X0Y1_DSP_bot.Inst_DSP_bot_ConfigMem.Inst_frame8_bit20.Q
+ sg13g2_a21oi_1
XFILLER_85_276 VPWR VGND sg13g2_fill_2
XFILLER_85_210 VPWR VGND sg13g2_fill_2
X_6127_ VPWR VGND _2525_ sg13g2_tiehi
X_5009_ _0744_ _0682_ _0533_ VPWR VGND sg13g2_nand2b_1
X_4388_ VPWR Tile_X0Y0_DSP_top.Inst_DSP_top_switch_matrix.JS2BEG1 _0150_ VGND sg13g2_inv_1
X_3339_ _1703_ Tile_X0Y1_DSP_bot.Inst_DSP_bot_ConfigMem.Inst_frame3_bit24.Q _0125_
+ VPWR VGND sg13g2_nand2_1
XANTENNA_106 VPWR VGND Tile_X0Y0_S2MID[4] sg13g2_antennanp
X_6058_ Tile_X0Y1_FrameData[17] Tile_X0Y1_FrameStrobe[12] Tile_X0Y1_DSP_bot.Inst_DSP_bot_ConfigMem.Inst_frame12_bit17.Q
+ VPWR VGND sg13g2_dlhq_1
XANTENNA_117 VPWR VGND Tile_X0Y0_S2MID[4] sg13g2_antennanp
XANTENNA_128 VPWR VGND Tile_X0Y0_S4END[6] sg13g2_antennanp
XANTENNA_139 VPWR VGND Tile_X0Y0_S4END[6] sg13g2_antennanp
XFILLER_76_265 VPWR VGND sg13g2_fill_2
X_3690_ _1996_ _2023_ _2024_ _2025_ VPWR VGND sg13g2_nor3_1
XFILLER_71_70 VPWR VGND sg13g2_fill_2
X_2710_ Tile_X0Y1_DSP_bot.Inst_DSP_bot_ConfigMem.Inst_frame2_bit11.Q VPWR _1095_ VGND
+ _1091_ _1094_ sg13g2_o21ai_1
X_5360_ Tile_X0Y0_FrameData[29] Tile_X0Y1_FrameStrobe[5] Tile_X0Y0_DSP_top.Inst_DSP_top_ConfigMem.Inst_frame5_bit29.Q
+ VPWR VGND sg13g2_dlhq_1
X_5291_ Tile_X0Y0_FrameData[2] Tile_X0Y1_FrameStrobe[2] Tile_X0Y0_DSP_top.Inst_DSP_top_ConfigMem.Inst_frame2_bit2.Q
+ VPWR VGND sg13g2_dlhq_1
X_2572_ _0962_ Tile_X0Y0_DSP_top.Inst_DSP_top_ConfigMem.Inst_frame9_bit26.Q _0961_
+ VPWR VGND sg13g2_nand2_1
X_4311_ VPWR _0074_ Tile_X0Y1_DSP_bot.Inst_DSP_bot_ConfigMem.Inst_frame12_bit1.Q VGND
+ sg13g2_inv_1
X_4242_ Tile_X0Y1_DSP_bot.Inst_DSP_bot_switch_matrix.clr _1951_ _0005_ VPWR VGND sg13g2_nor2b_1
X_2641_ _1028_ VPWR _1029_ VGND Tile_X0Y1_DSP_bot.Inst_DSP_bot_ConfigMem.Inst_frame3_bit12.Q
+ Tile_X0Y1_DSP_bot.Inst_DSP_bot_switch_matrix.Q7 sg13g2_o21ai_1
XFILLER_67_221 VPWR VGND sg13g2_fill_2
XFILLER_67_210 VPWR VGND sg13g2_fill_2
X_3124_ Tile_X0Y0_DSP_top.Inst_DSP_top_ConfigMem.Inst_frame5_bit22.Q Tile_X0Y1_NN4END[6]
+ Tile_X0Y0_E2END[1] Tile_X0Y0_S2END[1] Tile_X0Y0_W2END[1] Tile_X0Y0_DSP_top.Inst_DSP_top_ConfigMem.Inst_frame5_bit23.Q
+ _1500_ VPWR VGND sg13g2_mux4_1
X_3055_ VGND VPWR _1323_ _1430_ _1432_ _1431_ sg13g2_a21oi_1
X_4173_ _2418_ _2417_ Tile_X0Y1_DSP_bot.Inst_DSP_bot_ConfigMem.Inst_frame10_bit22.Q
+ Tile_X0Y1_DSP_bot.Inst_DSP_bot_switch_matrix.SS4BEG2 VPWR VGND sg13g2_mux2_1
XFILLER_27_129 VPWR VGND sg13g2_fill_2
X_3957_ _2250_ Tile_X0Y0_DSP_top.Inst_DSP_top_ConfigMem.Inst_frame11_bit26.Q _0937_
+ VPWR VGND sg13g2_nand2_1
X_3888_ _2188_ VPWR Tile_X0Y0_DSP_top.Inst_DSP_top_switch_matrix.JN2BEG0 VGND Tile_X0Y0_DSP_top.Inst_DSP_top_ConfigMem.Inst_frame4_bit3.Q
+ _2200_ sg13g2_o21ai_1
X_5558_ Tile_X0Y0_FrameData[23] Tile_X0Y1_FrameStrobe[11] Tile_X0Y0_DSP_top.Inst_DSP_top_ConfigMem.Inst_frame11_bit23.Q
+ VPWR VGND sg13g2_dlhq_1
X_2839_ _1219_ _0991_ _1127_ VPWR VGND sg13g2_nand2_1
X_5627_ _2499_ VGND VPWR Tile_X0Y1_DSP_bot.A3 Tile_X0Y1_DSP_bot.Inst_MULADD.A_reg\[3\]
+ clknet_3_1_0_Tile_X0Y1_UserCLK_regs sg13g2_dfrbpq_1
X_2908_ VGND VPWR Tile_X0Y1_DSP_bot.Inst_DSP_bot_ConfigMem.Inst_frame0_bit8.Q _0935_
+ _1286_ _1285_ sg13g2_a21oi_1
XFILLER_104_101 VPWR VGND sg13g2_fill_2
X_5489_ Tile_X0Y0_FrameData[28] Tile_X0Y1_FrameStrobe[9] Tile_X0Y0_DSP_top.Inst_DSP_top_ConfigMem.Inst_frame9_bit28.Q
+ VPWR VGND sg13g2_dlhq_1
X_4509_ Tile_X0Y1_DSP_bot.Inst_DSP_bot_ConfigMem.Inst_frame4_bit6.Q VPWR _0267_ VGND
+ Tile_X0Y1_DSP_bot.Inst_DSP_bot_ConfigMem.Inst_frame4_bit5.Q _0264_ sg13g2_o21ai_1
XFILLER_41_62 VPWR VGND sg13g2_fill_2
X_3811_ _2136_ Tile_X0Y1_DSP_bot.Inst_DSP_bot_ConfigMem.Inst_frame12_bit5.Q Tile_X0Y1_DSP_bot.Inst_MULADD.ACC\[18\]
+ VPWR VGND sg13g2_nand2_1
X_4860_ VGND VPWR Tile_X0Y0_DSP_top.Inst_DSP_top_ConfigMem.Inst_frame0_bit7.Q _0598_
+ _0602_ _0601_ sg13g2_a21oi_1
XANTENNA_39 VPWR VGND Tile_X0Y1_N4END[12] sg13g2_antennanp
X_5412_ Tile_X0Y0_FrameData[9] Tile_X0Y1_FrameStrobe[6] Tile_X0Y0_DSP_top.Inst_DSP_top_ConfigMem.Inst_frame6_bit9.Q
+ VPWR VGND sg13g2_dlhq_1
X_3742_ _2072_ Tile_X0Y1_DSP_bot.Inst_DSP_bot_ConfigMem.Inst_frame12_bit3.Q Tile_X0Y1_DSP_bot.Inst_MULADD.ACC\[19\]
+ VPWR VGND sg13g2_nand2_1
X_3673_ Tile_X0Y0_DSP_top.Inst_DSP_top_ConfigMem.Inst_frame8_bit23.Q VPWR _2009_ VGND
+ Tile_X0Y0_DSP_top.Inst_DSP_top_ConfigMem.Inst_frame8_bit22.Q _2008_ sg13g2_o21ai_1
X_2624_ _1012_ _1004_ _1011_ VPWR VGND sg13g2_nand2_1
X_6392_ Tile_X0Y1_FrameData[11] Tile_X0Y1_FrameData_O[11] VPWR VGND sg13g2_buf_1
XANTENNA_17 VPWR VGND Tile_X0Y1_E6END[10] sg13g2_antennanp
X_6461_ Tile_X0Y1_DSP_bot.Inst_DSP_bot_switch_matrix.SS4BEG0 Tile_X0Y1_SS4BEG[12]
+ VPWR VGND sg13g2_buf_1
X_4791_ _0535_ _0534_ Tile_X0Y1_DSP_bot.Inst_DSP_bot_ConfigMem.Inst_frame4_bit2.Q
+ VPWR VGND sg13g2_nand2b_1
XANTENNA_28 VPWR VGND Tile_X0Y1_EE4END[7] sg13g2_antennanp
X_5274_ Tile_X0Y0_FrameData[19] Tile_X0Y1_FrameStrobe[2] Tile_X0Y0_DSP_top.Inst_DSP_top_ConfigMem.Inst_frame2_bit19.Q
+ VPWR VGND sg13g2_dlhq_1
X_2555_ Tile_X0Y0_DSP_top.Inst_DSP_top_ConfigMem.Inst_frame4_bit12.Q Tile_X0Y0_DSP_top.Inst_DSP_top_switch_matrix.bot2top5
+ _0946_ VPWR VGND sg13g2_nor2b_1
X_5343_ Tile_X0Y0_FrameData[14] Tile_X0Y1_FrameStrobe[4] Tile_X0Y0_DSP_top.Inst_DSP_top_ConfigMem.Inst_frame4_bit14.Q
+ VPWR VGND sg13g2_dlhq_1
XFILLER_56_0 VPWR VGND sg13g2_decap_4
X_4225_ Tile_X0Y1_DSP_bot.Inst_DSP_bot_ConfigMem.Inst_frame8_bit29.Q Tile_X0Y1_DSP_bot.Inst_DSP_bot_ConfigMem.Inst_frame8_bit28.Q
+ _2463_ VPWR VGND sg13g2_nor2b_1
X_3107_ Tile_X0Y0_W2MID[0] Tile_X0Y0_DSP_top.Inst_DSP_top_switch_matrix.JW2BEG5 Tile_X0Y0_DSP_top.Inst_DSP_top_ConfigMem.Inst_frame7_bit22.Q
+ _1483_ VPWR VGND sg13g2_mux2_1
XFILLER_55_257 VPWR VGND sg13g2_decap_4
X_3038_ _1415_ _1407_ _1411_ VPWR VGND sg13g2_xnor2_1
X_4087_ VGND VPWR Tile_X0Y1_DSP_bot.Inst_DSP_bot_ConfigMem.Inst_frame2_bit0.Q _0126_
+ _2349_ Tile_X0Y1_DSP_bot.Inst_DSP_bot_ConfigMem.Inst_frame2_bit1.Q sg13g2_a21oi_1
X_4156_ Tile_X0Y1_DSP_bot.Inst_DSP_bot_ConfigMem.Inst_frame11_bit27.Q VPWR _2405_
+ VGND Tile_X0Y1_DSP_bot.Inst_DSP_bot_ConfigMem.Inst_frame11_bit26.Q _1866_ sg13g2_o21ai_1
XFILLER_70_238 VPWR VGND sg13g2_fill_1
X_4989_ Tile_X0Y1_DSP_bot.Inst_DSP_bot_ConfigMem.Inst_frame8_bit4.Q _0724_ _0725_
+ VPWR VGND sg13g2_nor2b_1
XFILLER_86_360 VPWR VGND sg13g2_fill_1
XFILLER_6_320 VPWR VGND sg13g2_fill_1
XFILLER_10_360 VPWR VGND sg13g2_fill_1
XFILLER_14_176 VPWR VGND sg13g2_fill_1
XFILLER_14_198 VPWR VGND sg13g2_fill_1
XFILLER_69_349 VPWR VGND sg13g2_fill_2
XFILLER_69_305 VPWR VGND sg13g2_fill_1
XFILLER_92_352 VPWR VGND sg13g2_fill_1
X_4010_ VGND VPWR _0123_ _0861_ _2296_ _2295_ sg13g2_a21oi_1
X_5961_ Tile_X0Y1_FrameData[18] Tile_X0Y1_FrameStrobe[9] Tile_X0Y1_DSP_bot.Inst_DSP_bot_ConfigMem.Inst_frame9_bit18.Q
+ VPWR VGND sg13g2_dlhq_1
X_4912_ Tile_X0Y0_DSP_top.Inst_DSP_top_ConfigMem.Inst_frame3_bit1.Q VPWR _0652_ VGND
+ Tile_X0Y0_DSP_top.Inst_DSP_top_ConfigMem.Inst_frame3_bit0.Q Tile_X0Y0_DSP_top.Inst_DSP_top_switch_matrix.bot2top7
+ sg13g2_o21ai_1
X_4774_ Tile_X0Y0_DSP_top.Inst_DSP_top_ConfigMem.Inst_frame6_bit8.Q _0488_ _0519_
+ VPWR VGND sg13g2_nor2_1
X_4843_ Tile_X0Y0_DSP_top.Inst_DSP_top_ConfigMem.Inst_frame1_bit7.Q VPWR _0586_ VGND
+ _0584_ _0585_ sg13g2_o21ai_1
XFILLER_60_271 VPWR VGND sg13g2_fill_2
X_5892_ Tile_X0Y1_FrameData[23] Tile_X0Y1_FrameStrobe[7] Tile_X0Y1_DSP_bot.Inst_DSP_bot_ConfigMem.Inst_frame7_bit23.Q
+ VPWR VGND sg13g2_dlhq_1
X_3656_ _1992_ VPWR _1993_ VGND Tile_X0Y1_DSP_bot.Inst_DSP_bot_ConfigMem.Inst_frame12_bit2.Q
+ Tile_X0Y0_DSP_top.Inst_DSP_top_switch_matrix.inst_cus_mux41_buf_top2bot13.X sg13g2_o21ai_1
X_3725_ _2057_ Tile_X0Y1_DSP_bot.Inst_DSP_bot_ConfigMem.Inst_frame12_bit5.Q Tile_X0Y1_DSP_bot.Inst_MULADD.ACC\[17\]
+ VPWR VGND sg13g2_nand2_1
X_3587_ VPWR VGND _1937_ _1518_ _1936_ _1505_ _1939_ _1507_ sg13g2_a221oi_1
X_6444_ Tile_X0Y0_DSP_top.Inst_DSP_top_switch_matrix.S4BEG3 Tile_X0Y1_S4BEG[11] VPWR
+ VGND sg13g2_buf_1
X_2607_ _0995_ _0869_ _0970_ VPWR VGND sg13g2_nand2_1
X_6375_ Tile_X0Y1_EE4END[14] Tile_X0Y1_EE4BEG[10] VPWR VGND sg13g2_buf_1
X_5326_ Tile_X0Y0_FrameData[31] Tile_X0Y1_FrameStrobe[4] Tile_X0Y0_DSP_top.Inst_DSP_top_ConfigMem.Inst_frame4_bit31.Q
+ VPWR VGND sg13g2_dlhq_1
X_5188_ VPWR VGND Tile_X0Y0_DSP_top.Inst_DSP_top_ConfigMem.Inst_frame3_bit17.Q Tile_X0Y0_DSP_top.Inst_DSP_top_ConfigMem.Inst_frame3_bit18.Q
+ _0913_ _0910_ _0914_ _0911_ sg13g2_a221oi_1
XFILLER_87_124 VPWR VGND sg13g2_fill_1
X_5257_ Tile_X0Y0_FrameData[4] Tile_X0Y1_FrameStrobe[1] Tile_X0Y0_DSP_top.Inst_DSP_top_ConfigMem.Inst_frame1_bit4.Q
+ VPWR VGND sg13g2_dlhq_1
X_4208_ Tile_X0Y1_DSP_bot.Inst_DSP_bot_ConfigMem.Inst_frame9_bit17.Q VPWR _2448_ VGND
+ Tile_X0Y1_DSP_bot.Inst_DSP_bot_ConfigMem.Inst_frame9_bit16.Q _2447_ sg13g2_o21ai_1
X_2538_ VGND VPWR _0922_ _0925_ _0931_ _0061_ sg13g2_a21oi_1
X_4139_ _2389_ VPWR _2390_ VGND Tile_X0Y1_DSP_bot.Inst_DSP_bot_ConfigMem.Inst_frame11_bit19.Q
+ Tile_X0Y1_DSP_bot.Inst_DSP_bot_switch_matrix.Q9 sg13g2_o21ai_1
XFILLER_22_42 VPWR VGND sg13g2_fill_1
XFILLER_42_293 VPWR VGND sg13g2_fill_1
X_4490_ _0139_ _0248_ Tile_X0Y0_DSP_top.Inst_DSP_top_switch_matrix.JN2BEG4 VPWR VGND
+ sg13g2_nor2_1
X_3510_ Tile_X0Y1_DSP_bot.Inst_DSP_bot_ConfigMem.Inst_frame7_bit21.Q _0020_ _0076_
+ _0859_ _1683_ Tile_X0Y1_DSP_bot.Inst_DSP_bot_ConfigMem.Inst_frame7_bit20.Q _1865_
+ VPWR VGND sg13g2_mux4_1
X_3441_ Tile_X0Y1_DSP_bot.Inst_DSP_bot_ConfigMem.Inst_frame0_bit26.Q Tile_X0Y1_N4END[2]
+ _1799_ VPWR VGND sg13g2_nor2b_1
X_6160_ Tile_X0Y0_E6END[10] Tile_X0Y0_E6BEG[8] VPWR VGND sg13g2_buf_1
X_5111_ Tile_X0Y0_DSP_top.Inst_DSP_top_ConfigMem.Inst_frame5_bit12.Q Tile_X0Y1_N2MID[4]
+ Tile_X0Y0_E2END[4] Tile_X0Y0_SS4END[2] Tile_X0Y0_W2END[4] Tile_X0Y0_DSP_top.Inst_DSP_top_ConfigMem.Inst_frame5_bit13.Q
+ _0841_ VPWR VGND sg13g2_mux4_1
X_3372_ _1733_ VPWR _1734_ VGND Tile_X0Y1_DSP_bot.Inst_DSP_bot_ConfigMem.Inst_frame8_bit24.Q
+ Tile_X0Y1_DSP_bot.Inst_DSP_bot_switch_matrix.E2BEG4 sg13g2_o21ai_1
XFILLER_33_2 VPWR VGND sg13g2_fill_1
X_5042_ Tile_X0Y1_DSP_bot.Inst_DSP_bot_ConfigMem.Inst_frame1_bit5.Q _0776_ _0774_
+ _0770_ _0772_ Tile_X0Y1_DSP_bot.Inst_DSP_bot_ConfigMem.Inst_frame1_bit6.Q _0777_
+ VPWR VGND sg13g2_mux4_1
X_6091_ VPWR VGND _2489_ sg13g2_tiehi
XFILLER_40_208 VPWR VGND sg13g2_decap_8
X_5944_ Tile_X0Y1_FrameData[3] Tile_X0Y1_FrameStrobe[8] Tile_X0Y1_DSP_bot.Inst_DSP_bot_ConfigMem.Inst_frame8_bit3.Q
+ VPWR VGND sg13g2_dlhq_1
X_4757_ Tile_X0Y0_DSP_top.Inst_DSP_top_ConfigMem.Inst_frame4_bit9.Q VPWR _0503_ VGND
+ Tile_X0Y0_DSP_top.Inst_DSP_top_ConfigMem.Inst_frame4_bit8.Q Tile_X0Y0_DSP_top.Inst_DSP_top_switch_matrix.bot2top7
+ sg13g2_o21ai_1
X_4826_ _0569_ Tile_X0Y0_DSP_top.Inst_DSP_top_ConfigMem.Inst_frame7_bit6.Q _0568_
+ VPWR VGND sg13g2_nand2_1
X_5875_ Tile_X0Y1_FrameData[8] Tile_X0Y1_FrameStrobe[6] Tile_X0Y1_DSP_bot.Inst_DSP_bot_ConfigMem.Inst_frame6_bit8.Q
+ VPWR VGND sg13g2_dlhq_1
X_5309_ Tile_X0Y0_FrameData[16] Tile_X0Y1_FrameStrobe[3] Tile_X0Y0_DSP_top.Inst_DSP_top_ConfigMem.Inst_frame3_bit16.Q
+ VPWR VGND sg13g2_dlhq_1
X_3639_ _1978_ Tile_X0Y0_DSP_top.Inst_DSP_top_ConfigMem.Inst_frame3_bit24.Q Tile_X0Y0_W1END[3]
+ VPWR VGND sg13g2_nand2b_1
X_3708_ _2041_ VPWR _2042_ VGND _0048_ Tile_X0Y0_DSP_top.Inst_DSP_top_ConfigMem.Inst_frame1_bit24.Q
+ sg13g2_o21ai_1
X_4688_ _0437_ VPWR _0438_ VGND Tile_X0Y1_DSP_bot.Inst_DSP_bot_ConfigMem.Inst_frame4_bit24.Q
+ _0435_ sg13g2_o21ai_1
X_6427_ Tile_X0Y0_DSP_top.Inst_DSP_top_switch_matrix.JS2BEG2 Tile_X0Y1_S2BEGb[2] VPWR
+ VGND sg13g2_buf_1
X_6358_ Tile_X0Y1_E6END[7] Tile_X0Y1_E6BEG[5] VPWR VGND sg13g2_buf_1
X_6289_ Tile_X0Y0_W2END[0] Tile_X0Y0_W2BEG[0] VPWR VGND sg13g2_buf_1
XFILLER_33_41 VPWR VGND sg13g2_fill_1
XFILLER_16_238 VPWR VGND sg13g2_fill_2
XFILLER_33_96 VPWR VGND sg13g2_fill_1
XFILLER_3_164 VPWR VGND sg13g2_fill_2
X_3990_ _2279_ Tile_X0Y0_DSP_top.Inst_DSP_top_ConfigMem.Inst_frame10_bit24.Q _0806_
+ VPWR VGND sg13g2_nand2_1
X_5591_ Tile_X0Y0_FrameData[22] Tile_X0Y1_FrameStrobe[12] Tile_X0Y0_DSP_top.Inst_DSP_top_ConfigMem.Inst_frame12_bit22.Q
+ VPWR VGND sg13g2_dlhq_1
X_2941_ VGND VPWR _1283_ _1311_ _1318_ _1310_ sg13g2_a21oi_1
X_4611_ VGND VPWR Tile_X0Y1_DSP_bot.Inst_DSP_bot_ConfigMem.Inst_frame4_bit20.Q _0131_
+ _0364_ _0363_ sg13g2_a21oi_1
X_2872_ Tile_X0Y1_DSP_bot.Inst_DSP_bot_ConfigMem.Inst_frame7_bit11.Q VPWR _1251_ VGND
+ Tile_X0Y1_W2MID[2] Tile_X0Y1_DSP_bot.Inst_DSP_bot_ConfigMem.Inst_frame7_bit10.Q
+ sg13g2_o21ai_1
X_5660_ Tile_X0Y1_FrameData[31] Tile_X0Y1_FrameStrobe[0] Tile_X0Y1_DSP_bot.Inst_DSP_bot_ConfigMem.Inst_frame0_bit31.Q
+ VPWR VGND sg13g2_dlhq_1
X_4542_ VGND VPWR Tile_X0Y0_DSP_top.Inst_DSP_top_ConfigMem.Inst_frame4_bit24.Q Tile_X0Y0_E2END[7]
+ _0298_ _0297_ sg13g2_a21oi_1
X_6212_ Tile_X0Y1_FrameStrobe[0] Tile_X0Y0_FrameStrobe_O[0] VPWR VGND sg13g2_buf_1
X_4473_ VGND VPWR Tile_X0Y1_DSP_bot.Inst_DSP_bot_ConfigMem.Inst_frame1_bit1.Q _0229_
+ _0232_ _0231_ sg13g2_a21oi_1
X_3424_ Tile_X0Y1_DSP_bot.Inst_DSP_bot_ConfigMem.Inst_frame5_bit28.Q Tile_X0Y1_NN4END[1]
+ Tile_X0Y1_E2END[5] Tile_X0Y0_S2MID[5] Tile_X0Y1_W2END[5] Tile_X0Y1_DSP_bot.Inst_DSP_bot_ConfigMem.Inst_frame5_bit29.Q
+ _1783_ VPWR VGND sg13g2_mux4_1
X_6143_ Tile_X0Y0_DSP_top.Inst_DSP_top_switch_matrix.E2BEG7 Tile_X0Y0_E2BEG[7] VPWR
+ VGND sg13g2_buf_1
X_3355_ _0100_ _1715_ _1717_ _1718_ VPWR VGND sg13g2_nor3_1
X_6074_ Tile_X0Y1_FrameData[1] Tile_X0Y1_FrameStrobe[12] Tile_X0Y1_DSP_bot.Inst_DSP_bot_ConfigMem.Inst_frame12_bit1.Q
+ VPWR VGND sg13g2_dlhq_1
X_3286_ Tile_X0Y1_DSP_bot.Inst_DSP_bot_ConfigMem.Inst_frame8_bit27.Q VPWR _1653_ VGND
+ Tile_X0Y1_DSP_bot.Inst_DSP_bot_ConfigMem.Inst_frame8_bit25.Q Tile_X0Y1_DSP_bot.Inst_DSP_bot_switch_matrix.JW2BEG5
+ sg13g2_o21ai_1
X_5025_ Tile_X0Y1_DSP_bot.Inst_DSP_bot_ConfigMem.Inst_frame1_bit4.Q Tile_X0Y1_DSP_bot.Inst_DSP_bot_switch_matrix.Q0
+ _0760_ VPWR VGND sg13g2_nor2b_1
XFILLER_70_17 VPWR VGND sg13g2_fill_1
XFILLER_13_219 VPWR VGND sg13g2_fill_1
X_5927_ Tile_X0Y1_FrameData[20] Tile_X0Y1_FrameStrobe[8] Tile_X0Y1_DSP_bot.Inst_DSP_bot_ConfigMem.Inst_frame8_bit20.Q
+ VPWR VGND sg13g2_dlhq_1
XFILLER_107_346 VPWR VGND sg13g2_fill_1
X_4809_ VGND VPWR Tile_X0Y0_E2MID[0] Tile_X0Y0_DSP_top.Inst_DSP_top_ConfigMem.Inst_frame7_bit6.Q
+ _0552_ _0551_ sg13g2_a21oi_1
X_5789_ Tile_X0Y1_FrameData[30] Tile_X0Y1_FrameStrobe[4] Tile_X0Y1_DSP_bot.Inst_DSP_bot_ConfigMem.Inst_frame4_bit30.Q
+ VPWR VGND sg13g2_dlhq_1
X_5858_ Tile_X0Y1_FrameData[25] Tile_X0Y1_FrameStrobe[6] Tile_X0Y1_DSP_bot.Inst_DSP_bot_ConfigMem.Inst_frame6_bit25.Q
+ VPWR VGND sg13g2_dlhq_1
XFILLER_21_263 VPWR VGND sg13g2_decap_4
XFILLER_88_274 VPWR VGND sg13g2_fill_2
XFILLER_0_178 VPWR VGND sg13g2_fill_2
XFILLER_28_63 VPWR VGND sg13g2_fill_1
XFILLER_60_94 VPWR VGND sg13g2_fill_1
XFILLER_60_61 VPWR VGND sg13g2_fill_2
X_3140_ VGND VPWR _0072_ Tile_X0Y0_DSP_top.Inst_DSP_top_switch_matrix.inst_cus_mux41_buf_top2bot10.X
+ _1514_ _1513_ sg13g2_a21oi_1
X_3071_ VPWR _1448_ _1447_ VGND sg13g2_inv_1
X_3973_ VGND VPWR Tile_X0Y0_E1END[3] Tile_X0Y0_DSP_top.Inst_DSP_top_ConfigMem.Inst_frame10_bit21.Q
+ _2263_ _2262_ sg13g2_a21oi_1
XFILLER_35_355 VPWR VGND sg13g2_fill_2
X_5712_ Tile_X0Y1_FrameData[11] Tile_X0Y1_FrameStrobe[1] Tile_X0Y1_DSP_bot.Inst_DSP_bot_ConfigMem.Inst_frame1_bit11.Q
+ VPWR VGND sg13g2_dlhq_1
X_2786_ Tile_X0Y0_DSP_top.Inst_DSP_top_ConfigMem.Inst_frame2_bit26.Q _1167_ _1168_
+ VPWR VGND sg13g2_nor2_1
X_5574_ Tile_X0Y0_FrameData[7] Tile_X0Y1_FrameStrobe[11] Tile_X0Y0_DSP_top.Inst_DSP_top_ConfigMem.Inst_frame11_bit7.Q
+ VPWR VGND sg13g2_dlhq_1
X_2855_ _0125_ _0126_ Tile_X0Y1_DSP_bot.Inst_DSP_bot_ConfigMem.Inst_frame3_bit16.Q
+ _1235_ VPWR VGND sg13g2_mux2_1
X_2924_ _1301_ VPWR _1302_ VGND Tile_X0Y1_N2MID[7] Tile_X0Y1_DSP_bot.Inst_DSP_bot_ConfigMem.Inst_frame6_bit8.Q
+ sg13g2_o21ai_1
X_4525_ _0281_ VPWR _0282_ VGND Tile_X0Y1_W2END[3] Tile_X0Y1_DSP_bot.Inst_DSP_bot_ConfigMem.Inst_frame1_bit8.Q
+ sg13g2_o21ai_1
X_5643_ _2515_ VGND VPWR Tile_X0Y1_DSP_bot.C3 Tile_X0Y1_DSP_bot.Inst_MULADD.C_reg\[3\]
+ clknet_3_3_0_Tile_X0Y1_UserCLK_regs sg13g2_dfrbpq_1
X_4387_ VGND VPWR Tile_X0Y0_DSP_top.Inst_DSP_top_ConfigMem.Inst_frame2_bit7.Q _0142_
+ _0150_ _0149_ sg13g2_a21oi_1
X_6126_ VPWR VGND _2524_ sg13g2_tiehi
X_3338_ Tile_X0Y1_DSP_bot.Inst_DSP_bot_ConfigMem.Inst_frame3_bit27.Q _1701_ _1702_
+ VPWR VGND sg13g2_nor2_1
X_4456_ Tile_X0Y1_DSP_bot.Inst_DSP_bot_ConfigMem.Inst_frame2_bit14.Q VPWR _0216_ VGND
+ Tile_X0Y1_DSP_bot.Inst_DSP_bot_ConfigMem.Inst_frame2_bit13.Q _0213_ sg13g2_o21ai_1
X_3407_ _1766_ VPWR _1767_ VGND _0031_ Tile_X0Y1_DSP_bot.Inst_DSP_bot_ConfigMem.Inst_frame7_bit30.Q
+ sg13g2_o21ai_1
XFILLER_85_233 VPWR VGND sg13g2_fill_2
XANTENNA_107 VPWR VGND Tile_X0Y0_S2MID[4] sg13g2_antennanp
X_5008_ _0743_ _0682_ _0741_ VPWR VGND sg13g2_nand2_1
X_3269_ Tile_X0Y1_DSP_bot.Inst_DSP_bot_ConfigMem.Inst_frame1_bit28.Q Tile_X0Y1_N1END[0]
+ Tile_X0Y1_N2END[0] Tile_X0Y1_E1END[0] Tile_X0Y1_E2END[0] Tile_X0Y1_DSP_bot.Inst_DSP_bot_ConfigMem.Inst_frame1_bit29.Q
+ _1636_ VPWR VGND sg13g2_mux4_1
X_6057_ Tile_X0Y1_FrameData[18] Tile_X0Y1_FrameStrobe[12] Tile_X0Y1_DSP_bot.Inst_DSP_bot_ConfigMem.Inst_frame12_bit18.Q
+ VPWR VGND sg13g2_dlhq_1
XANTENNA_118 VPWR VGND Tile_X0Y0_S2MID[4] sg13g2_antennanp
XANTENNA_129 VPWR VGND Tile_X0Y0_S4END[6] sg13g2_antennanp
XFILLER_14_32 VPWR VGND sg13g2_fill_2
XFILLER_107_110 VPWR VGND sg13g2_fill_2
XFILLER_55_94 VPWR VGND sg13g2_fill_1
XFILLER_55_72 VPWR VGND sg13g2_fill_1
XFILLER_44_174 VPWR VGND sg13g2_fill_2
X_2640_ _1028_ Tile_X0Y1_DSP_bot.Inst_DSP_bot_ConfigMem.Inst_frame3_bit12.Q _0130_
+ VPWR VGND sg13g2_nand2_1
X_2571_ Tile_X0Y0_DSP_top.Inst_DSP_top_ConfigMem.Inst_frame6_bit1.Q Tile_X0Y0_DSP_top.Inst_DSP_top_switch_matrix.N2BEGb7
+ Tile_X0Y0_S2MID[7] Tile_X0Y0_E2MID[7] Tile_X0Y0_W2MID[7] Tile_X0Y0_DSP_top.Inst_DSP_top_ConfigMem.Inst_frame6_bit0.Q
+ _0961_ VPWR VGND sg13g2_mux4_1
X_5290_ Tile_X0Y0_FrameData[3] Tile_X0Y1_FrameStrobe[2] Tile_X0Y0_DSP_top.Inst_DSP_top_ConfigMem.Inst_frame2_bit3.Q
+ VPWR VGND sg13g2_dlhq_1
X_4310_ VPWR _0073_ Tile_X0Y1_DSP_bot.Inst_DSP_bot_ConfigMem.Inst_frame12_bit0.Q VGND
+ sg13g2_inv_1
X_4241_ Tile_X0Y1_DSP_bot.Inst_DSP_bot_switch_matrix.clr _1948_ _0004_ VPWR VGND sg13g2_nor2_1
X_3123_ VGND VPWR Tile_X0Y0_DSP_top.Inst_DSP_top_ConfigMem.Inst_frame0_bit23.Q _1495_
+ _1499_ _1498_ sg13g2_a21oi_1
X_3054_ _1270_ _1214_ _1431_ VPWR VGND sg13g2_xor2_1
X_4172_ Tile_X0Y1_DSP_bot.Inst_DSP_bot_ConfigMem.Inst_frame10_bit20.Q Tile_X0Y1_N1END[0]
+ Tile_X0Y1_E1END[0] Tile_X0Y1_W1END[0] Tile_X0Y1_DSP_bot.Inst_DSP_bot_switch_matrix.Q4
+ Tile_X0Y1_DSP_bot.Inst_DSP_bot_ConfigMem.Inst_frame10_bit21.Q _2418_ VPWR VGND sg13g2_mux4_1
X_3956_ VGND VPWR Tile_X0Y0_DSP_top.Inst_DSP_top_ConfigMem.Inst_frame11_bit26.Q _0387_
+ _2249_ _2248_ sg13g2_a21oi_1
X_2907_ Tile_X0Y1_DSP_bot.Inst_DSP_bot_ConfigMem.Inst_frame0_bit9.Q VPWR _1285_ VGND
+ Tile_X0Y1_WW4END[2] Tile_X0Y1_DSP_bot.Inst_DSP_bot_ConfigMem.Inst_frame0_bit8.Q
+ sg13g2_o21ai_1
X_3887_ _2194_ VPWR _2200_ VGND _2196_ _2199_ sg13g2_o21ai_1
X_5557_ Tile_X0Y0_FrameData[24] Tile_X0Y1_FrameStrobe[11] Tile_X0Y0_DSP_top.Inst_DSP_top_ConfigMem.Inst_frame11_bit24.Q
+ VPWR VGND sg13g2_dlhq_1
X_5488_ Tile_X0Y0_FrameData[29] Tile_X0Y1_FrameStrobe[9] Tile_X0Y0_DSP_top.Inst_DSP_top_ConfigMem.Inst_frame9_bit29.Q
+ VPWR VGND sg13g2_dlhq_1
X_2769_ _1149_ _1150_ _1151_ VPWR VGND sg13g2_and2_1
X_2838_ _1218_ _1191_ _1192_ VPWR VGND sg13g2_xnor2_1
X_5626_ _2498_ VGND VPWR Tile_X0Y1_DSP_bot.A2 Tile_X0Y1_DSP_bot.Inst_MULADD.A_reg\[2\]
+ clknet_3_1_0_Tile_X0Y1_UserCLK_regs sg13g2_dfrbpq_1
X_4508_ _0265_ VPWR _0266_ VGND Tile_X0Y1_DSP_bot.Inst_DSP_bot_ConfigMem.Inst_frame4_bit4.Q
+ Tile_X0Y1_DSP_bot.Inst_DSP_bot_switch_matrix.Q7 sg13g2_o21ai_1
XFILLER_2_207 VPWR VGND sg13g2_fill_1
X_4439_ Tile_X0Y0_DSP_top.Inst_DSP_top_ConfigMem.Inst_frame2_bit30.Q _0199_ _0200_
+ VPWR VGND sg13g2_nor2_1
X_6109_ VPWR VGND _2507_ sg13g2_tiehi
XFILLER_73_225 VPWR VGND sg13g2_fill_1
XFILLER_18_119 VPWR VGND sg13g2_fill_2
XFILLER_26_152 VPWR VGND sg13g2_fill_2
X_3741_ _2068_ VPWR _2071_ VGND _2069_ _2070_ sg13g2_o21ai_1
X_3810_ _2135_ _2069_ _2070_ VPWR VGND sg13g2_xnor2_1
XFILLER_32_155 VPWR VGND sg13g2_decap_4
X_4790_ Tile_X0Y1_DSP_bot.Inst_DSP_bot_ConfigMem.Inst_frame4_bit0.Q Tile_X0Y1_DSP_bot.Inst_DSP_bot_switch_matrix.Q1
+ Tile_X0Y1_DSP_bot.Inst_DSP_bot_switch_matrix.Q2 Tile_X0Y1_DSP_bot.Inst_DSP_bot_switch_matrix.Q3
+ Tile_X0Y1_DSP_bot.Inst_DSP_bot_switch_matrix.Q4 Tile_X0Y1_DSP_bot.Inst_DSP_bot_ConfigMem.Inst_frame4_bit1.Q
+ _0534_ VPWR VGND sg13g2_mux4_1
XFILLER_17_163 VPWR VGND sg13g2_fill_1
XANTENNA_29 VPWR VGND Tile_X0Y1_EE4END[8] sg13g2_antennanp
XANTENNA_18 VPWR VGND Tile_X0Y1_E6END[2] sg13g2_antennanp
X_5411_ Tile_X0Y0_FrameData[10] Tile_X0Y1_FrameStrobe[6] Tile_X0Y0_DSP_top.Inst_DSP_top_ConfigMem.Inst_frame6_bit10.Q
+ VPWR VGND sg13g2_dlhq_1
X_5342_ Tile_X0Y0_FrameData[15] Tile_X0Y1_FrameStrobe[4] Tile_X0Y0_DSP_top.Inst_DSP_top_ConfigMem.Inst_frame4_bit15.Q
+ VPWR VGND sg13g2_dlhq_1
X_2554_ VPWR VGND _0944_ Tile_X0Y0_DSP_top.Inst_DSP_top_ConfigMem.Inst_frame4_bit14.Q
+ _0943_ Tile_X0Y0_DSP_top.Inst_DSP_top_ConfigMem.Inst_frame4_bit13.Q _0945_ _0942_
+ sg13g2_a221oi_1
X_3672_ Tile_X0Y0_DSP_top.Inst_DSP_top_ConfigMem.Inst_frame5_bit29.Q Tile_X0Y1_NN4END[5]
+ Tile_X0Y0_S2END[5] Tile_X0Y0_E2END[5] Tile_X0Y0_W2END[5] Tile_X0Y0_DSP_top.Inst_DSP_top_ConfigMem.Inst_frame5_bit28.Q
+ _2008_ VPWR VGND sg13g2_mux4_1
XFILLER_63_2 VPWR VGND sg13g2_fill_1
X_2623_ _1009_ _1005_ _1011_ VPWR VGND sg13g2_xor2_1
X_6391_ Tile_X0Y1_FrameData[10] Tile_X0Y1_FrameData_O[10] VPWR VGND sg13g2_buf_1
X_6460_ Tile_X0Y0_DSP_top.Inst_DSP_top_switch_matrix.SS4BEG3 Tile_X0Y1_SS4BEG[11]
+ VPWR VGND sg13g2_buf_1
X_5273_ Tile_X0Y0_FrameData[20] Tile_X0Y1_FrameStrobe[2] Tile_X0Y0_DSP_top.Inst_DSP_top_ConfigMem.Inst_frame2_bit20.Q
+ VPWR VGND sg13g2_dlhq_1
XFILLER_101_149 VPWR VGND sg13g2_fill_1
X_4224_ _2462_ VPWR Tile_X0Y1_DSP_bot.Inst_DSP_bot_switch_matrix.W6BEG1 VGND _2455_
+ _2457_ sg13g2_o21ai_1
X_4155_ _2403_ VPWR _2404_ VGND Tile_X0Y1_DSP_bot.Inst_DSP_bot_ConfigMem.Inst_frame11_bit28.Q
+ _2400_ sg13g2_o21ai_1
X_3106_ Tile_X0Y0_DSP_top.Inst_DSP_top_switch_matrix.JW2BEG5 _1481_ _1482_ _1473_
+ _1467_ VPWR VGND sg13g2_a22oi_1
XFILLER_62_18 VPWR VGND sg13g2_fill_2
X_3037_ _1413_ _1412_ _1414_ VPWR VGND sg13g2_nor2b_1
X_4086_ Tile_X0Y1_DSP_bot.Inst_DSP_bot_ConfigMem.Inst_frame2_bit2.Q _2347_ _2348_
+ VPWR VGND sg13g2_nor2_1
X_3939_ VGND VPWR _0021_ Tile_X0Y0_DSP_top.Inst_DSP_top_ConfigMem.Inst_frame11_bit20.Q
+ _2234_ Tile_X0Y0_DSP_top.Inst_DSP_top_ConfigMem.Inst_frame11_bit21.Q sg13g2_a21oi_1
XFILLER_62_29 VPWR VGND sg13g2_fill_1
X_4988_ _0723_ VPWR _0724_ VGND _0077_ Tile_X0Y0_DSP_top.Inst_DSP_top_switch_matrix.JS2BEG0
+ sg13g2_o21ai_1
XFILLER_87_59 VPWR VGND sg13g2_fill_2
X_5609_ _2486_ VGND VPWR _0005_ Tile_X0Y1_DSP_bot.Inst_MULADD.ACC\[5\] clknet_3_2_0_Tile_X0Y1_UserCLK_regs
+ sg13g2_dfrbpq_1
XFILLER_14_122 VPWR VGND sg13g2_fill_2
X_4911_ Tile_X0Y0_DSP_top.Inst_DSP_top_switch_matrix.bot2top8 Tile_X0Y0_DSP_top.Inst_DSP_top_ConfigMem.Inst_frame3_bit0.Q
+ _0651_ VPWR VGND sg13g2_nor2b_1
X_5891_ Tile_X0Y1_FrameData[24] Tile_X0Y1_FrameStrobe[7] Tile_X0Y1_DSP_bot.Inst_DSP_bot_ConfigMem.Inst_frame7_bit24.Q
+ VPWR VGND sg13g2_dlhq_1
X_5960_ Tile_X0Y1_FrameData[19] Tile_X0Y1_FrameStrobe[9] Tile_X0Y1_DSP_bot.Inst_DSP_bot_ConfigMem.Inst_frame9_bit19.Q
+ VPWR VGND sg13g2_dlhq_1
X_4773_ Tile_X0Y0_DSP_top.Inst_DSP_top_ConfigMem.Inst_frame8_bit3.Q VPWR _0518_ VGND
+ Tile_X0Y0_DSP_top.Inst_DSP_top_ConfigMem.Inst_frame8_bit2.Q _0517_ sg13g2_o21ai_1
X_4842_ Tile_X0Y0_DSP_top.Inst_DSP_top_ConfigMem.Inst_frame1_bit6.Q VPWR _0585_ VGND
+ Tile_X0Y0_DSP_top.Inst_DSP_top_ConfigMem.Inst_frame1_bit5.Q _0582_ sg13g2_o21ai_1
X_3724_ _2055_ _2029_ _2056_ VPWR VGND sg13g2_xor2_1
X_6512_ Tile_X0Y1_DSP_bot.Inst_DSP_bot_switch_matrix.WW4BEG3 Tile_X0Y1_WW4BEG[15]
+ VPWR VGND sg13g2_buf_1
XFILLER_20_147 VPWR VGND sg13g2_fill_1
X_5325_ Tile_X0Y0_FrameData[0] Tile_X0Y1_FrameStrobe[3] Tile_X0Y0_DSP_top.Inst_DSP_top_ConfigMem.Inst_frame3_bit0.Q
+ VPWR VGND sg13g2_dlhq_1
X_3655_ _1992_ Tile_X0Y1_DSP_bot.Inst_DSP_bot_ConfigMem.Inst_frame12_bit2.Q Tile_X0Y1_DSP_bot.Inst_MULADD.C_reg\[15\]
+ VPWR VGND sg13g2_nand2b_1
X_3586_ VGND VPWR _1936_ _1937_ _1938_ _1518_ sg13g2_a21oi_1
X_6443_ Tile_X0Y0_DSP_top.Inst_DSP_top_switch_matrix.S4BEG2 Tile_X0Y1_S4BEG[10] VPWR
+ VGND sg13g2_buf_1
X_2606_ _0816_ _0969_ _0994_ VPWR VGND sg13g2_nor2_1
X_2537_ _0927_ _0929_ _0060_ _0930_ VPWR VGND sg13g2_nand3_1
X_6374_ Tile_X0Y1_EE4END[13] Tile_X0Y1_EE4BEG[9] VPWR VGND sg13g2_buf_1
X_5187_ VGND VPWR Tile_X0Y0_E2END[5] Tile_X0Y0_DSP_top.Inst_DSP_top_ConfigMem.Inst_frame3_bit16.Q
+ _0913_ _0912_ sg13g2_a21oi_1
X_5256_ Tile_X0Y0_FrameData[5] Tile_X0Y1_FrameStrobe[1] Tile_X0Y0_DSP_top.Inst_DSP_top_ConfigMem.Inst_frame1_bit5.Q
+ VPWR VGND sg13g2_dlhq_1
X_4207_ Tile_X0Y1_DSP_bot.Inst_DSP_bot_ConfigMem.Inst_frame9_bit14.Q Tile_X0Y1_DSP_bot.Inst_DSP_bot_switch_matrix.Q6
+ Tile_X0Y1_DSP_bot.Inst_DSP_bot_switch_matrix.Q7 Tile_X0Y1_DSP_bot.Inst_DSP_bot_switch_matrix.Q8
+ Tile_X0Y1_DSP_bot.Inst_DSP_bot_switch_matrix.Q9 Tile_X0Y1_DSP_bot.Inst_DSP_bot_ConfigMem.Inst_frame9_bit15.Q
+ _2447_ VPWR VGND sg13g2_mux4_1
X_4138_ _2389_ Tile_X0Y1_DSP_bot.Inst_DSP_bot_ConfigMem.Inst_frame11_bit19.Q _1865_
+ VPWR VGND sg13g2_nand2_1
X_4069_ Tile_X0Y1_DSP_bot.Inst_DSP_bot_ConfigMem.Inst_frame3_bit0.Q Tile_X0Y1_N1END[3]
+ Tile_X0Y1_N2END[1] Tile_X0Y1_N4END[1] Tile_X0Y1_EE4END[1] Tile_X0Y1_DSP_bot.Inst_DSP_bot_ConfigMem.Inst_frame3_bit1.Q
+ _2340_ VPWR VGND sg13g2_mux4_1
XFILLER_66_309 VPWR VGND sg13g2_fill_1
XFILLER_34_239 VPWR VGND sg13g2_fill_1
X_3371_ _1733_ Tile_X0Y1_DSP_bot.Inst_DSP_bot_ConfigMem.Inst_frame8_bit24.Q _0703_
+ VPWR VGND sg13g2_nand2_1
X_3440_ VGND VPWR Tile_X0Y1_DSP_bot.Inst_DSP_bot_ConfigMem.Inst_frame0_bit26.Q _1249_
+ _1798_ _1797_ sg13g2_a21oi_1
X_5110_ _0840_ _0837_ _0839_ VPWR VGND sg13g2_nand2_1
X_5041_ VGND VPWR Tile_X0Y1_N2END[2] Tile_X0Y1_DSP_bot.Inst_DSP_bot_ConfigMem.Inst_frame1_bit4.Q
+ _0776_ _0775_ sg13g2_a21oi_1
X_6090_ VPWR VGND _2488_ sg13g2_tiehi
XFILLER_65_342 VPWR VGND sg13g2_fill_1
X_5874_ Tile_X0Y1_FrameData[9] Tile_X0Y1_FrameStrobe[6] Tile_X0Y1_DSP_bot.Inst_DSP_bot_ConfigMem.Inst_frame6_bit9.Q
+ VPWR VGND sg13g2_dlhq_1
X_5943_ Tile_X0Y1_FrameData[4] Tile_X0Y1_FrameStrobe[8] Tile_X0Y1_DSP_bot.Inst_DSP_bot_ConfigMem.Inst_frame8_bit4.Q
+ VPWR VGND sg13g2_dlhq_1
XFILLER_18_280 VPWR VGND sg13g2_fill_2
X_4756_ VGND VPWR Tile_X0Y0_DSP_top.Inst_DSP_top_ConfigMem.Inst_frame4_bit8.Q Tile_X0Y0_DSP_top.Inst_DSP_top_switch_matrix.bot2top6
+ _0502_ _0501_ sg13g2_a21oi_1
X_3707_ VGND VPWR Tile_X0Y0_S1END[3] Tile_X0Y0_DSP_top.Inst_DSP_top_ConfigMem.Inst_frame1_bit24.Q
+ _2041_ Tile_X0Y0_DSP_top.Inst_DSP_top_ConfigMem.Inst_frame1_bit25.Q sg13g2_a21oi_1
X_4825_ _0567_ VPWR _0568_ VGND _0556_ _0562_ sg13g2_o21ai_1
X_4687_ VGND VPWR _0039_ Tile_X0Y1_DSP_bot.Inst_DSP_bot_ConfigMem.Inst_frame4_bit24.Q
+ _0437_ Tile_X0Y1_DSP_bot.Inst_DSP_bot_ConfigMem.Inst_frame4_bit25.Q sg13g2_a21oi_1
X_3638_ _1976_ VPWR _1977_ VGND _0048_ Tile_X0Y0_DSP_top.Inst_DSP_top_ConfigMem.Inst_frame3_bit24.Q
+ sg13g2_o21ai_1
X_5308_ Tile_X0Y0_FrameData[17] Tile_X0Y1_FrameStrobe[3] Tile_X0Y0_DSP_top.Inst_DSP_top_ConfigMem.Inst_frame3_bit17.Q
+ VPWR VGND sg13g2_dlhq_1
X_6288_ Tile_X0Y0_DSP_top.Inst_DSP_top_switch_matrix.W1BEG3 Tile_X0Y0_W1BEG[3] VPWR
+ VGND sg13g2_buf_1
X_3569_ _1864_ VPWR _1921_ VGND _1919_ _1920_ sg13g2_o21ai_1
X_6426_ Tile_X0Y0_DSP_top.Inst_DSP_top_switch_matrix.JS2BEG1 Tile_X0Y1_S2BEGb[1] VPWR
+ VGND sg13g2_buf_1
X_6357_ Tile_X0Y1_E6END[6] Tile_X0Y1_E6BEG[4] VPWR VGND sg13g2_buf_1
X_5239_ Tile_X0Y0_FrameData[22] Tile_X0Y1_FrameStrobe[1] Tile_X0Y0_DSP_top.Inst_DSP_top_ConfigMem.Inst_frame1_bit22.Q
+ VPWR VGND sg13g2_dlhq_1
XFILLER_71_301 VPWR VGND sg13g2_fill_2
XFILLER_74_71 VPWR VGND sg13g2_fill_2
XFILLER_62_301 VPWR VGND sg13g2_fill_1
X_2940_ _1315_ _1316_ _1317_ VPWR VGND sg13g2_nor2b_1
X_4541_ Tile_X0Y0_DSP_top.Inst_DSP_top_ConfigMem.Inst_frame4_bit25.Q VPWR _0297_ VGND
+ _0052_ Tile_X0Y0_DSP_top.Inst_DSP_top_ConfigMem.Inst_frame4_bit24.Q sg13g2_o21ai_1
X_5590_ Tile_X0Y0_FrameData[23] Tile_X0Y1_FrameStrobe[12] Tile_X0Y0_DSP_top.Inst_DSP_top_ConfigMem.Inst_frame12_bit23.Q
+ VPWR VGND sg13g2_dlhq_1
X_4610_ Tile_X0Y1_DSP_bot.Inst_DSP_bot_ConfigMem.Inst_frame4_bit21.Q VPWR _0363_ VGND
+ Tile_X0Y1_DSP_bot.Inst_DSP_bot_ConfigMem.Inst_frame4_bit20.Q Tile_X0Y1_DSP_bot.Inst_DSP_bot_switch_matrix.Q7
+ sg13g2_o21ai_1
X_2871_ VPWR VGND _1248_ _0086_ _1245_ _1239_ _1250_ _1240_ sg13g2_a221oi_1
X_6211_ Tile_X0Y0_FrameData[31] Tile_X0Y0_FrameData_O[31] VPWR VGND sg13g2_buf_1
X_6142_ Tile_X0Y0_DSP_top.Inst_DSP_top_switch_matrix.E2BEG6 Tile_X0Y0_E2BEG[6] VPWR
+ VGND sg13g2_buf_1
X_3354_ VGND VPWR _0055_ Tile_X0Y1_DSP_bot.Inst_DSP_bot_ConfigMem.Inst_frame1_bit24.Q
+ _1717_ _1716_ sg13g2_a21oi_1
X_4472_ Tile_X0Y1_DSP_bot.Inst_DSP_bot_ConfigMem.Inst_frame1_bit2.Q VPWR _0231_ VGND
+ Tile_X0Y1_DSP_bot.Inst_DSP_bot_ConfigMem.Inst_frame1_bit1.Q _0230_ sg13g2_o21ai_1
X_3423_ Tile_X0Y1_DSP_bot.Inst_DSP_bot_ConfigMem.Inst_frame0_bit28.Q Tile_X0Y1_E6END[1]
+ Tile_X0Y0_S4END[5] Tile_X0Y1_WW4END[3] Tile_X0Y1_DSP_bot.Inst_DSP_bot_switch_matrix.JS2BEG4
+ Tile_X0Y1_DSP_bot.Inst_DSP_bot_ConfigMem.Inst_frame0_bit29.Q _1782_ VPWR VGND sg13g2_mux4_1
XFILLER_31_0 VPWR VGND sg13g2_fill_2
XFILLER_57_128 VPWR VGND sg13g2_fill_1
X_3285_ _1652_ _1644_ _1651_ _1638_ _1635_ VPWR VGND sg13g2_a22oi_1
X_5024_ Tile_X0Y1_DSP_bot.Inst_DSP_bot_switch_matrix.Q3 Tile_X0Y1_DSP_bot.Inst_DSP_bot_switch_matrix.Q4
+ Tile_X0Y1_DSP_bot.Inst_DSP_bot_ConfigMem.Inst_frame1_bit4.Q _0759_ VPWR VGND sg13g2_mux2_1
X_6073_ Tile_X0Y1_FrameData[2] Tile_X0Y1_FrameStrobe[12] Tile_X0Y1_DSP_bot.Inst_DSP_bot_ConfigMem.Inst_frame12_bit2.Q
+ VPWR VGND sg13g2_dlhq_1
XFILLER_110_14 VPWR VGND sg13g2_decap_4
X_5926_ Tile_X0Y1_FrameData[21] Tile_X0Y1_FrameStrobe[8] Tile_X0Y1_DSP_bot.Inst_DSP_bot_ConfigMem.Inst_frame8_bit21.Q
+ VPWR VGND sg13g2_dlhq_1
X_5857_ Tile_X0Y1_FrameData[26] Tile_X0Y1_FrameStrobe[6] Tile_X0Y1_DSP_bot.Inst_DSP_bot_ConfigMem.Inst_frame6_bit26.Q
+ VPWR VGND sg13g2_dlhq_1
X_4808_ Tile_X0Y0_DSP_top.Inst_DSP_top_ConfigMem.Inst_frame7_bit6.Q Tile_X0Y0_DSP_top.Inst_DSP_top_switch_matrix.N2BEGb0
+ _0551_ VPWR VGND sg13g2_nor2b_1
X_6409_ Tile_X0Y1_FrameData[28] Tile_X0Y1_FrameData_O[28] VPWR VGND sg13g2_buf_1
X_4739_ Tile_X0Y1_DSP_bot.Inst_DSP_bot_ConfigMem.Inst_frame4_bit31.Q _0486_ _0487_
+ VPWR VGND sg13g2_and2_1
X_5788_ Tile_X0Y1_FrameData[31] Tile_X0Y1_FrameStrobe[4] Tile_X0Y1_DSP_bot.Inst_DSP_bot_ConfigMem.Inst_frame4_bit31.Q
+ VPWR VGND sg13g2_dlhq_1
XFILLER_0_102 VPWR VGND sg13g2_fill_1
XFILLER_71_131 VPWR VGND sg13g2_fill_1
XFILLER_56_161 VPWR VGND sg13g2_fill_2
X_3070_ _1155_ _1444_ _1154_ _1447_ VPWR VGND sg13g2_nand3_1
Xclkbuf_3_4_0_Tile_X0Y1_UserCLK_regs clknet_0_Tile_X0Y1_UserCLK_regs clknet_3_4_0_Tile_X0Y1_UserCLK_regs
+ VPWR VGND sg13g2_buf_8
XFILLER_47_172 VPWR VGND sg13g2_decap_8
XFILLER_35_323 VPWR VGND sg13g2_fill_2
XFILLER_93_2 VPWR VGND sg13g2_fill_1
X_3972_ Tile_X0Y0_DSP_top.Inst_DSP_top_ConfigMem.Inst_frame10_bit21.Q _0293_ _2262_
+ VPWR VGND sg13g2_nor2_1
XFILLER_62_186 VPWR VGND sg13g2_fill_2
XFILLER_50_348 VPWR VGND sg13g2_fill_1
X_2923_ _1301_ Tile_X0Y1_DSP_bot.Inst_DSP_bot_ConfigMem.Inst_frame6_bit8.Q Tile_X0Y1_E2MID[7]
+ VPWR VGND sg13g2_nand2b_1
X_5711_ Tile_X0Y1_FrameData[12] Tile_X0Y1_FrameStrobe[1] Tile_X0Y1_DSP_bot.Inst_DSP_bot_ConfigMem.Inst_frame1_bit12.Q
+ VPWR VGND sg13g2_dlhq_1
X_2785_ VGND VPWR Tile_X0Y0_E2END[7] Tile_X0Y0_DSP_top.Inst_DSP_top_ConfigMem.Inst_frame2_bit24.Q
+ _1167_ _1166_ sg13g2_a21oi_1
X_5573_ Tile_X0Y0_FrameData[8] Tile_X0Y1_FrameStrobe[11] Tile_X0Y0_DSP_top.Inst_DSP_top_ConfigMem.Inst_frame11_bit8.Q
+ VPWR VGND sg13g2_dlhq_1
XFILLER_79_0 VPWR VGND sg13g2_fill_1
X_2854_ Tile_X0Y1_DSP_bot.Inst_DSP_bot_ConfigMem.Inst_frame3_bit18.Q _1233_ _1234_
+ VPWR VGND sg13g2_nor2_1
X_4524_ _0281_ _0028_ Tile_X0Y1_DSP_bot.Inst_DSP_bot_ConfigMem.Inst_frame1_bit8.Q
+ VPWR VGND sg13g2_nand2_1
X_5642_ _2514_ VGND VPWR Tile_X0Y1_DSP_bot.C2 Tile_X0Y1_DSP_bot.Inst_MULADD.C_reg\[2\]
+ clknet_3_3_0_Tile_X0Y1_UserCLK_regs sg13g2_dfrbpq_1
X_6125_ VPWR VGND _2523_ sg13g2_tiehi
X_4386_ VPWR VGND _0148_ Tile_X0Y0_DSP_top.Inst_DSP_top_ConfigMem.Inst_frame2_bit7.Q
+ _0146_ _0023_ _0149_ _0144_ sg13g2_a221oi_1
X_3337_ Tile_X0Y1_DSP_bot.Inst_DSP_bot_ConfigMem.Inst_frame3_bit26.Q _1700_ _1701_
+ VPWR VGND sg13g2_nor2_1
X_4455_ _0214_ VPWR _0215_ VGND Tile_X0Y1_DSP_bot.Inst_DSP_bot_ConfigMem.Inst_frame2_bit12.Q
+ Tile_X0Y1_DSP_bot.Inst_DSP_bot_switch_matrix.Q7 sg13g2_o21ai_1
X_3406_ _1766_ Tile_X0Y1_E2MID[0] Tile_X0Y1_DSP_bot.Inst_DSP_bot_ConfigMem.Inst_frame7_bit30.Q
+ VPWR VGND sg13g2_nand2_1
X_3199_ _1571_ _1570_ Tile_X0Y0_DSP_top.Inst_DSP_top_ConfigMem.Inst_frame4_bit22.Q
+ VPWR VGND sg13g2_nand2b_1
XANTENNA_119 VPWR VGND Tile_X0Y0_S2MID[4] sg13g2_antennanp
XFILLER_53_131 VPWR VGND sg13g2_fill_2
X_5007_ VGND VPWR _0742_ _0740_ _0739_ sg13g2_or2_1
X_3268_ _1634_ VPWR _1635_ VGND Tile_X0Y1_DSP_bot.Inst_DSP_bot_ConfigMem.Inst_frame1_bit29.Q
+ _1631_ sg13g2_o21ai_1
XANTENNA_108 VPWR VGND Tile_X0Y0_S2MID[4] sg13g2_antennanp
X_6056_ Tile_X0Y1_FrameData[19] Tile_X0Y1_FrameStrobe[12] Tile_X0Y1_DSP_bot.Inst_DSP_bot_ConfigMem.Inst_frame12_bit19.Q
+ VPWR VGND sg13g2_dlhq_1
XFILLER_41_359 VPWR VGND sg13g2_fill_2
XFILLER_14_44 VPWR VGND sg13g2_fill_2
X_5909_ Tile_X0Y1_FrameData[6] Tile_X0Y1_FrameStrobe[7] Tile_X0Y1_DSP_bot.Inst_DSP_bot_ConfigMem.Inst_frame7_bit6.Q
+ VPWR VGND sg13g2_dlhq_1
XFILLER_30_10 VPWR VGND sg13g2_fill_2
XFILLER_76_267 VPWR VGND sg13g2_fill_1
XFILLER_91_248 VPWR VGND sg13g2_fill_1
XFILLER_44_153 VPWR VGND sg13g2_fill_1
XFILLER_71_72 VPWR VGND sg13g2_fill_1
X_2570_ _0959_ VPWR _0960_ VGND _0940_ _0941_ sg13g2_o21ai_1
XFILLER_99_359 VPWR VGND sg13g2_fill_2
XFILLER_99_304 VPWR VGND sg13g2_fill_1
XFILLER_67_212 VPWR VGND sg13g2_fill_1
X_3122_ Tile_X0Y0_DSP_top.Inst_DSP_top_ConfigMem.Inst_frame8_bit16.Q VPWR _1498_ VGND
+ Tile_X0Y0_DSP_top.Inst_DSP_top_ConfigMem.Inst_frame0_bit23.Q _1497_ sg13g2_o21ai_1
X_4171_ Tile_X0Y1_DSP_bot.Inst_DSP_bot_ConfigMem.Inst_frame10_bit21.Q Tile_X0Y1_DSP_bot.Inst_DSP_bot_switch_matrix.Q8
+ _1793_ _1886_ _0734_ Tile_X0Y1_DSP_bot.Inst_DSP_bot_ConfigMem.Inst_frame10_bit20.Q
+ _2417_ VPWR VGND sg13g2_mux4_1
X_4240_ Tile_X0Y1_DSP_bot.Inst_DSP_bot_switch_matrix.clr _1950_ _0003_ VPWR VGND sg13g2_nor2b_1
XFILLER_82_226 VPWR VGND sg13g2_fill_1
XFILLER_67_256 VPWR VGND sg13g2_fill_2
X_3053_ _1429_ VPWR _1430_ VGND _1349_ _1428_ sg13g2_o21ai_1
X_3886_ Tile_X0Y0_DSP_top.Inst_DSP_top_ConfigMem.Inst_frame4_bit2.Q VPWR _2199_ VGND
+ Tile_X0Y0_DSP_top.Inst_DSP_top_ConfigMem.Inst_frame4_bit1.Q _2198_ sg13g2_o21ai_1
X_3955_ Tile_X0Y0_DSP_top.Inst_DSP_top_ConfigMem.Inst_frame11_bit26.Q _1537_ _2248_
+ VPWR VGND sg13g2_nor2_1
X_2906_ _1277_ VPWR _1284_ VGND _1274_ _1278_ sg13g2_o21ai_1
X_5625_ _2497_ VGND VPWR Tile_X0Y1_DSP_bot.A1 Tile_X0Y1_DSP_bot.Inst_MULADD.A_reg\[1\]
+ clknet_3_1_0_Tile_X0Y1_UserCLK_regs sg13g2_dfrbpq_1
XFILLER_104_125 VPWR VGND sg13g2_fill_2
XFILLER_104_103 VPWR VGND sg13g2_fill_1
X_5556_ Tile_X0Y0_FrameData[25] Tile_X0Y1_FrameStrobe[11] Tile_X0Y0_DSP_top.Inst_DSP_top_ConfigMem.Inst_frame11_bit25.Q
+ VPWR VGND sg13g2_dlhq_1
X_4438_ Tile_X0Y0_DSP_top.Inst_DSP_top_ConfigMem.Inst_frame2_bit28.Q Tile_X0Y0_DSP_top.Inst_DSP_top_switch_matrix.bot2top0
+ Tile_X0Y0_DSP_top.Inst_DSP_top_switch_matrix.bot2top1 Tile_X0Y0_DSP_top.Inst_DSP_top_switch_matrix.bot2top2
+ Tile_X0Y0_DSP_top.Inst_DSP_top_switch_matrix.bot2top3 Tile_X0Y0_DSP_top.Inst_DSP_top_ConfigMem.Inst_frame2_bit29.Q
+ _0199_ VPWR VGND sg13g2_mux4_1
X_5487_ Tile_X0Y0_FrameData[30] Tile_X0Y1_FrameStrobe[9] Tile_X0Y0_DSP_top.Inst_DSP_top_ConfigMem.Inst_frame9_bit30.Q
+ VPWR VGND sg13g2_dlhq_1
X_2768_ _1008_ _1010_ _1148_ _1150_ VPWR VGND sg13g2_or3_1
X_2699_ _1084_ _1082_ _1083_ VPWR VGND sg13g2_nand2b_1
X_2837_ _1077_ _1187_ _0939_ _1217_ VPWR VGND sg13g2_nand3_1
X_4507_ _0265_ Tile_X0Y1_DSP_bot.Inst_DSP_bot_ConfigMem.Inst_frame4_bit4.Q _0131_
+ VPWR VGND sg13g2_nand2_1
X_4369_ VPWR _0132_ Tile_X0Y0_DSP_top.Inst_DSP_top_switch_matrix.bot2top8 VGND sg13g2_inv_1
X_6108_ VPWR VGND _2506_ sg13g2_tiehi
X_6039_ Tile_X0Y1_FrameData[4] Tile_X0Y1_FrameStrobe[11] Tile_X0Y1_DSP_bot.Inst_DSP_bot_ConfigMem.Inst_frame11_bit4.Q
+ VPWR VGND sg13g2_dlhq_1
XFILLER_26_175 VPWR VGND sg13g2_decap_4
XFILLER_96_307 VPWR VGND sg13g2_fill_2
XFILLER_1_230 VPWR VGND sg13g2_fill_1
XFILLER_9_0 VPWR VGND sg13g2_fill_1
XFILLER_106_90 VPWR VGND sg13g2_fill_2
XFILLER_64_248 VPWR VGND sg13g2_fill_2
X_3740_ _2052_ VPWR _2070_ VGND _2029_ _2054_ sg13g2_o21ai_1
XANTENNA_19 VPWR VGND Tile_X0Y1_E6END[3] sg13g2_antennanp
X_5341_ Tile_X0Y0_FrameData[16] Tile_X0Y1_FrameStrobe[4] Tile_X0Y0_DSP_top.Inst_DSP_top_ConfigMem.Inst_frame4_bit16.Q
+ VPWR VGND sg13g2_dlhq_1
X_5410_ Tile_X0Y0_FrameData[11] Tile_X0Y1_FrameStrobe[6] Tile_X0Y0_DSP_top.Inst_DSP_top_ConfigMem.Inst_frame6_bit11.Q
+ VPWR VGND sg13g2_dlhq_1
X_2553_ VGND VPWR Tile_X0Y0_DSP_top.Inst_DSP_top_ConfigMem.Inst_frame4_bit12.Q _0133_
+ _0944_ Tile_X0Y0_DSP_top.Inst_DSP_top_ConfigMem.Inst_frame4_bit13.Q sg13g2_a21oi_1
X_3671_ _2003_ _2006_ _2007_ VPWR VGND sg13g2_nor2_1
X_2622_ _1005_ _1009_ _1010_ VPWR VGND sg13g2_nor2_1
X_6390_ Tile_X0Y1_FrameData[9] Tile_X0Y1_FrameData_O[9] VPWR VGND sg13g2_buf_1
X_3105_ Tile_X0Y0_DSP_top.Inst_DSP_top_ConfigMem.Inst_frame1_bit23.Q _1479_ _1482_
+ VPWR VGND sg13g2_nor2_1
X_5272_ Tile_X0Y0_FrameData[21] Tile_X0Y1_FrameStrobe[2] Tile_X0Y0_DSP_top.Inst_DSP_top_ConfigMem.Inst_frame2_bit21.Q
+ VPWR VGND sg13g2_dlhq_1
X_4085_ Tile_X0Y1_DSP_bot.Inst_DSP_bot_ConfigMem.Inst_frame2_bit0.Q Tile_X0Y1_DSP_bot.Inst_DSP_bot_switch_matrix.Q1
+ Tile_X0Y1_DSP_bot.Inst_DSP_bot_switch_matrix.Q2 Tile_X0Y1_DSP_bot.Inst_DSP_bot_switch_matrix.Q3
+ Tile_X0Y1_DSP_bot.Inst_DSP_bot_switch_matrix.Q4 Tile_X0Y1_DSP_bot.Inst_DSP_bot_ConfigMem.Inst_frame2_bit1.Q
+ _2347_ VPWR VGND sg13g2_mux4_1
X_4223_ _2461_ VPWR _2462_ VGND Tile_X0Y1_DSP_bot.Inst_DSP_bot_ConfigMem.Inst_frame9_bit20.Q
+ _2458_ sg13g2_o21ai_1
X_4154_ VGND VPWR Tile_X0Y1_DSP_bot.Inst_DSP_bot_ConfigMem.Inst_frame11_bit28.Q _2402_
+ _2403_ Tile_X0Y1_DSP_bot.Inst_DSP_bot_ConfigMem.Inst_frame11_bit29.Q sg13g2_a21oi_1
X_3036_ _1413_ _1396_ _1400_ VPWR VGND sg13g2_xnor2_1
X_3869_ Tile_X0Y0_DSP_top.Inst_DSP_top_ConfigMem.Inst_frame4_bit0.Q Tile_X0Y0_DSP_top.Inst_DSP_top_switch_matrix.bot2top5
+ _2182_ VPWR VGND sg13g2_nor2b_1
X_3938_ VGND VPWR _2226_ _2228_ Tile_X0Y0_DSP_top.Inst_DSP_top_switch_matrix.EE4BEG1
+ _2233_ sg13g2_a21oi_1
X_4987_ VGND VPWR _0031_ _0077_ _0723_ Tile_X0Y1_DSP_bot.Inst_DSP_bot_ConfigMem.Inst_frame7_bit15.Q
+ sg13g2_a21oi_1
X_5608_ _2487_ VGND VPWR _0004_ Tile_X0Y1_DSP_bot.Inst_MULADD.ACC\[4\] clknet_3_0_0_Tile_X0Y1_UserCLK_regs
+ sg13g2_dfrbpq_1
X_5539_ Tile_X0Y0_FrameData[10] Tile_X0Y1_FrameStrobe[10] Tile_X0Y0_DSP_top.Inst_DSP_top_ConfigMem.Inst_frame10_bit10.Q
+ VPWR VGND sg13g2_dlhq_1
XFILLER_61_229 VPWR VGND sg13g2_decap_8
XFILLER_54_292 VPWR VGND sg13g2_fill_1
XFILLER_108_294 VPWR VGND sg13g2_fill_2
XFILLER_96_115 VPWR VGND sg13g2_fill_2
X_4910_ Tile_X0Y0_DSP_top.Inst_DSP_top_ConfigMem.Inst_frame3_bit1.Q _0648_ _0649_
+ _0650_ VPWR VGND sg13g2_nor3_1
X_4841_ VGND VPWR Tile_X0Y0_DSP_top.Inst_DSP_top_ConfigMem.Inst_frame1_bit4.Q _0134_
+ _0584_ _0583_ sg13g2_a21oi_1
X_5890_ Tile_X0Y1_FrameData[25] Tile_X0Y1_FrameStrobe[7] Tile_X0Y1_DSP_bot.Inst_DSP_bot_ConfigMem.Inst_frame7_bit25.Q
+ VPWR VGND sg13g2_dlhq_1
X_4772_ Tile_X0Y0_DSP_top.Inst_DSP_top_ConfigMem.Inst_frame5_bit9.Q Tile_X0Y1_NN4END[7]
+ Tile_X0Y0_S2END[6] Tile_X0Y0_E2END[6] Tile_X0Y0_W2END[6] Tile_X0Y0_DSP_top.Inst_DSP_top_ConfigMem.Inst_frame5_bit8.Q
+ _0517_ VPWR VGND sg13g2_mux4_1
X_6442_ Tile_X0Y0_DSP_top.Inst_DSP_top_switch_matrix.S4BEG1 Tile_X0Y1_S4BEG[9] VPWR
+ VGND sg13g2_buf_1
X_3654_ _1984_ VPWR Tile_X0Y0_DSP_top.Inst_DSP_top_switch_matrix.inst_cus_mux41_buf_top2bot13.X
+ VGND _1989_ _1991_ sg13g2_o21ai_1
X_3723_ _2055_ _2052_ _2053_ VPWR VGND sg13g2_nand2_1
X_6511_ Tile_X0Y1_DSP_bot.Inst_DSP_bot_switch_matrix.WW4BEG2 Tile_X0Y1_WW4BEG[14]
+ VPWR VGND sg13g2_buf_1
X_5324_ Tile_X0Y0_FrameData[1] Tile_X0Y1_FrameStrobe[3] Tile_X0Y0_DSP_top.Inst_DSP_top_ConfigMem.Inst_frame3_bit1.Q
+ VPWR VGND sg13g2_dlhq_1
X_3585_ _1937_ _1515_ _1517_ VPWR VGND sg13g2_xnor2_1
X_5255_ Tile_X0Y0_FrameData[6] Tile_X0Y1_FrameStrobe[1] Tile_X0Y0_DSP_top.Inst_DSP_top_ConfigMem.Inst_frame1_bit6.Q
+ VPWR VGND sg13g2_dlhq_1
XFILLER_61_0 VPWR VGND sg13g2_fill_2
X_2605_ _0993_ _0939_ _0991_ VPWR VGND sg13g2_nand2_1
X_2536_ _0928_ VPWR _0929_ VGND Tile_X0Y1_DSP_bot.Inst_DSP_bot_ConfigMem.Inst_frame4_bit8.Q
+ Tile_X0Y1_DSP_bot.Inst_DSP_bot_switch_matrix.Q0 sg13g2_o21ai_1
X_6373_ Tile_X0Y1_EE4END[12] Tile_X0Y1_EE4BEG[8] VPWR VGND sg13g2_buf_1
X_5186_ Tile_X0Y0_DSP_top.Inst_DSP_top_ConfigMem.Inst_frame3_bit16.Q Tile_X0Y0_E1END[1]
+ _0912_ VPWR VGND sg13g2_nor2b_1
XFILLER_68_340 VPWR VGND sg13g2_fill_2
X_4206_ Tile_X0Y1_DSP_bot.Inst_DSP_bot_ConfigMem.Inst_frame9_bit14.Q _1018_ _1255_
+ _1885_ _1794_ Tile_X0Y1_DSP_bot.Inst_DSP_bot_ConfigMem.Inst_frame9_bit15.Q _2446_
+ VPWR VGND sg13g2_mux4_1
X_4068_ _2338_ VPWR _2339_ VGND Tile_X0Y1_DSP_bot.Inst_DSP_bot_ConfigMem.Inst_frame3_bit2.Q
+ _2333_ sg13g2_o21ai_1
X_4137_ _2387_ VPWR _2388_ VGND Tile_X0Y1_DSP_bot.Inst_DSP_bot_ConfigMem.Inst_frame11_bit19.Q
+ _1784_ sg13g2_o21ai_1
XFILLER_51_273 VPWR VGND sg13g2_fill_2
X_3019_ _1396_ _1376_ _1393_ VPWR VGND sg13g2_nand2_1
XFILLER_105_275 VPWR VGND sg13g2_fill_2
XFILLER_27_292 VPWR VGND sg13g2_fill_2
XFILLER_8_79 VPWR VGND sg13g2_fill_1
X_3370_ VGND VPWR Tile_X0Y1_DSP_bot.Inst_DSP_bot_ConfigMem.Inst_frame8_bit24.Q _1731_
+ _1732_ _1713_ sg13g2_a21oi_1
XFILLER_6_185 VPWR VGND sg13g2_fill_1
X_5040_ Tile_X0Y1_DSP_bot.Inst_DSP_bot_ConfigMem.Inst_frame1_bit4.Q Tile_X0Y1_N1END[0]
+ _0775_ VPWR VGND sg13g2_nor2b_1
X_4824_ _0566_ VPWR _0567_ VGND Tile_X0Y0_DSP_top.Inst_DSP_top_ConfigMem.Inst_frame1_bit14.Q
+ _0563_ sg13g2_o21ai_1
X_5873_ Tile_X0Y1_FrameData[10] Tile_X0Y1_FrameStrobe[6] Tile_X0Y1_DSP_bot.Inst_DSP_bot_ConfigMem.Inst_frame6_bit10.Q
+ VPWR VGND sg13g2_dlhq_1
X_5942_ Tile_X0Y1_FrameData[5] Tile_X0Y1_FrameStrobe[8] Tile_X0Y1_DSP_bot.Inst_DSP_bot_ConfigMem.Inst_frame8_bit5.Q
+ VPWR VGND sg13g2_dlhq_1
XFILLER_108_14 VPWR VGND sg13g2_decap_8
X_4755_ Tile_X0Y0_DSP_top.Inst_DSP_top_ConfigMem.Inst_frame4_bit8.Q Tile_X0Y0_DSP_top.Inst_DSP_top_switch_matrix.bot2top5
+ _0501_ VPWR VGND sg13g2_nor2b_1
X_3637_ VGND VPWR Tile_X0Y0_S1END[3] Tile_X0Y0_DSP_top.Inst_DSP_top_ConfigMem.Inst_frame3_bit24.Q
+ _1976_ Tile_X0Y0_DSP_top.Inst_DSP_top_ConfigMem.Inst_frame3_bit25.Q sg13g2_a21oi_1
X_3706_ Tile_X0Y0_DSP_top.Inst_DSP_top_ConfigMem.Inst_frame1_bit26.Q _2039_ _2040_
+ VPWR VGND sg13g2_nor2_1
X_4686_ VPWR _0436_ _0435_ VGND sg13g2_inv_1
X_6425_ Tile_X0Y0_DSP_top.Inst_DSP_top_switch_matrix.JS2BEG0 Tile_X0Y1_S2BEGb[0] VPWR
+ VGND sg13g2_buf_1
X_5238_ Tile_X0Y0_FrameData[23] Tile_X0Y1_FrameStrobe[1] Tile_X0Y0_DSP_top.Inst_DSP_top_ConfigMem.Inst_frame1_bit23.Q
+ VPWR VGND sg13g2_dlhq_1
X_5307_ Tile_X0Y0_FrameData[18] Tile_X0Y1_FrameStrobe[3] Tile_X0Y0_DSP_top.Inst_DSP_top_ConfigMem.Inst_frame3_bit18.Q
+ VPWR VGND sg13g2_dlhq_1
X_6287_ Tile_X0Y0_DSP_top.Inst_DSP_top_switch_matrix.W1BEG2 Tile_X0Y0_W1BEG[2] VPWR
+ VGND sg13g2_buf_1
X_3568_ _1863_ _1862_ _1920_ VPWR VGND sg13g2_xor2_1
X_3499_ _1855_ Tile_X0Y1_DSP_bot.Inst_DSP_bot_ConfigMem.Inst_frame6_bit22.Q Tile_X0Y1_E2MID[1]
+ VPWR VGND sg13g2_nand2b_1
X_6356_ Tile_X0Y1_E6END[5] Tile_X0Y1_E6BEG[3] VPWR VGND sg13g2_buf_1
XFILLER_16_207 VPWR VGND sg13g2_decap_4
X_5169_ _0893_ _0895_ Tile_X0Y1_DSP_bot.Inst_DSP_bot_ConfigMem.Inst_frame9_bit27.Q
+ _0896_ VPWR VGND sg13g2_nand3_1
XFILLER_24_251 VPWR VGND sg13g2_fill_2
XFILLER_109_0 VPWR VGND sg13g2_decap_8
XFILLER_3_133 VPWR VGND sg13g2_fill_2
XFILLER_3_100 VPWR VGND sg13g2_fill_1
XFILLER_74_173 VPWR VGND sg13g2_fill_1
X_2870_ VPWR Tile_X0Y1_DSP_bot.Inst_DSP_bot_switch_matrix.E2BEG4 _1249_ VGND sg13g2_inv_1
X_4540_ _0295_ VPWR _0296_ VGND Tile_X0Y0_DSP_top.Inst_DSP_top_ConfigMem.Inst_frame4_bit24.Q
+ _0293_ sg13g2_o21ai_1
X_4471_ Tile_X0Y0_S2MID[1] Tile_X0Y0_S4END[5] Tile_X0Y1_DSP_bot.Inst_DSP_bot_ConfigMem.Inst_frame1_bit0.Q
+ _0230_ VPWR VGND sg13g2_mux2_1
X_6210_ Tile_X0Y0_FrameData[30] Tile_X0Y0_FrameData_O[30] VPWR VGND sg13g2_buf_1
X_6141_ Tile_X0Y0_DSP_top.Inst_DSP_top_switch_matrix.E2BEG5 Tile_X0Y0_E2BEG[5] VPWR
+ VGND sg13g2_buf_1
X_3353_ Tile_X0Y1_DSP_bot.Inst_DSP_bot_ConfigMem.Inst_frame1_bit25.Q VPWR _1716_ VGND
+ Tile_X0Y0_S2MID[7] Tile_X0Y1_DSP_bot.Inst_DSP_bot_ConfigMem.Inst_frame1_bit24.Q
+ sg13g2_o21ai_1
X_3284_ _1650_ Tile_X0Y1_DSP_bot.Inst_DSP_bot_ConfigMem.Inst_frame1_bit31.Q _1651_
+ VPWR VGND sg13g2_nor2b_1
X_3422_ _1781_ Tile_X0Y1_DSP_bot.Inst_DSP_bot_ConfigMem.Inst_frame12_bit3.Q Tile_X0Y1_DSP_bot.Inst_MULADD.ACC\[6\]
+ VPWR VGND sg13g2_nand2_1
X_6072_ Tile_X0Y1_FrameData[3] Tile_X0Y1_FrameStrobe[12] Tile_X0Y1_DSP_bot.Inst_DSP_bot_ConfigMem.Inst_frame12_bit3.Q
+ VPWR VGND sg13g2_dlhq_1
X_5023_ Tile_X0Y1_DSP_bot.Inst_DSP_bot_ConfigMem.Inst_frame9_bit29.Q _0751_ _0757_
+ _0758_ VPWR VGND sg13g2_or3_1
X_5925_ Tile_X0Y1_FrameData[22] Tile_X0Y1_FrameStrobe[8] Tile_X0Y1_DSP_bot.Inst_DSP_bot_ConfigMem.Inst_frame8_bit22.Q
+ VPWR VGND sg13g2_dlhq_1
X_2999_ _0787_ _1260_ _1376_ VPWR VGND sg13g2_nor2_1
X_4807_ Tile_X0Y0_DSP_top.Inst_DSP_top_switch_matrix.N2BEGb0 _0544_ _0550_ _0542_
+ _0535_ VPWR VGND sg13g2_a22oi_1
X_5787_ Tile_X0Y1_FrameData[0] Tile_X0Y1_FrameStrobe[3] Tile_X0Y1_DSP_bot.Inst_DSP_bot_ConfigMem.Inst_frame3_bit0.Q
+ VPWR VGND sg13g2_dlhq_1
XFILLER_21_232 VPWR VGND sg13g2_decap_4
X_5856_ Tile_X0Y1_FrameData[27] Tile_X0Y1_FrameStrobe[6] Tile_X0Y1_DSP_bot.Inst_DSP_bot_ConfigMem.Inst_frame6_bit27.Q
+ VPWR VGND sg13g2_dlhq_1
XFILLER_107_359 VPWR VGND sg13g2_fill_2
XFILLER_107_337 VPWR VGND sg13g2_decap_8
X_4669_ VPWR VGND Tile_X0Y0_DSP_top.Inst_DSP_top_ConfigMem.Inst_frame3_bit6.Q Tile_X0Y0_DSP_top.Inst_DSP_top_ConfigMem.Inst_frame3_bit7.Q
+ _0420_ _0416_ _0421_ _0419_ sg13g2_a221oi_1
X_6408_ Tile_X0Y1_FrameData[27] Tile_X0Y1_FrameData_O[27] VPWR VGND sg13g2_buf_1
X_4738_ _0485_ VPWR _0486_ VGND Tile_X0Y1_DSP_bot.Inst_DSP_bot_ConfigMem.Inst_frame4_bit29.Q
+ _0483_ sg13g2_o21ai_1
XFILLER_88_298 VPWR VGND sg13g2_fill_1
XFILLER_88_276 VPWR VGND sg13g2_fill_1
X_6339_ Tile_X0Y1_DSP_bot.Inst_DSP_bot_switch_matrix.E2BEG2 Tile_X0Y1_E2BEG[2] VPWR
+ VGND sg13g2_buf_1
Xclkbuf_1_0__f_Tile_X0Y1_UserCLK clknet_0_Tile_X0Y1_UserCLK clknet_1_0__leaf_Tile_X0Y1_UserCLK
+ VPWR VGND sg13g2_buf_8
XFILLER_85_71 VPWR VGND sg13g2_fill_1
X_3971_ _2261_ _2260_ Tile_X0Y0_DSP_top.Inst_DSP_top_ConfigMem.Inst_frame10_bit20.Q
+ Tile_X0Y0_DSP_top.Inst_DSP_top_switch_matrix.SS4BEG0 VPWR VGND sg13g2_mux2_1
X_2853_ Tile_X0Y1_DSP_bot.Inst_DSP_bot_ConfigMem.Inst_frame3_bit16.Q Tile_X0Y1_DSP_bot.Inst_DSP_bot_switch_matrix.Q0
+ Tile_X0Y1_DSP_bot.Inst_DSP_bot_switch_matrix.Q1 Tile_X0Y1_DSP_bot.Inst_DSP_bot_switch_matrix.Q2
+ Tile_X0Y1_DSP_bot.Inst_DSP_bot_switch_matrix.Q3 Tile_X0Y1_DSP_bot.Inst_DSP_bot_ConfigMem.Inst_frame3_bit17.Q
+ _1233_ VPWR VGND sg13g2_mux4_1
X_2922_ _1299_ VPWR _1300_ VGND Tile_X0Y1_DSP_bot.Inst_DSP_bot_ConfigMem.Inst_frame6_bit8.Q
+ _0208_ sg13g2_o21ai_1
X_5710_ Tile_X0Y1_FrameData[13] Tile_X0Y1_FrameStrobe[1] Tile_X0Y1_DSP_bot.Inst_DSP_bot_ConfigMem.Inst_frame1_bit13.Q
+ VPWR VGND sg13g2_dlhq_1
X_5641_ _2513_ VGND VPWR Tile_X0Y1_DSP_bot.C1 Tile_X0Y1_DSP_bot.Inst_MULADD.C_reg\[1\]
+ clknet_3_3_0_Tile_X0Y1_UserCLK_regs sg13g2_dfrbpq_1
X_2784_ Tile_X0Y0_DSP_top.Inst_DSP_top_ConfigMem.Inst_frame2_bit25.Q VPWR _1166_ VGND
+ _0052_ Tile_X0Y0_DSP_top.Inst_DSP_top_ConfigMem.Inst_frame2_bit24.Q sg13g2_o21ai_1
X_5572_ Tile_X0Y0_FrameData[9] Tile_X0Y1_FrameStrobe[11] Tile_X0Y0_DSP_top.Inst_DSP_top_ConfigMem.Inst_frame11_bit9.Q
+ VPWR VGND sg13g2_dlhq_1
X_4523_ Tile_X0Y1_DSP_bot.Inst_DSP_bot_ConfigMem.Inst_frame1_bit10.Q _0279_ _0280_
+ VPWR VGND sg13g2_nor2b_1
X_4454_ _0214_ Tile_X0Y1_DSP_bot.Inst_DSP_bot_ConfigMem.Inst_frame2_bit12.Q _0131_
+ VPWR VGND sg13g2_nand2_1
X_4385_ VGND VPWR Tile_X0Y0_DSP_top.Inst_DSP_top_ConfigMem.Inst_frame2_bit5.Q _0147_
+ _0148_ _0023_ sg13g2_a21oi_1
X_6124_ VPWR VGND _2522_ sg13g2_tiehi
X_3336_ Tile_X0Y1_DSP_bot.Inst_DSP_bot_ConfigMem.Inst_frame3_bit24.Q Tile_X0Y1_N1END[3]
+ Tile_X0Y1_N2END[7] Tile_X0Y1_E1END[3] Tile_X0Y1_E2END[7] Tile_X0Y1_DSP_bot.Inst_DSP_bot_ConfigMem.Inst_frame3_bit25.Q
+ _1700_ VPWR VGND sg13g2_mux4_1
X_5006_ _0739_ _0740_ _0741_ VPWR VGND sg13g2_nor2_1
X_3267_ VGND VPWR Tile_X0Y1_DSP_bot.Inst_DSP_bot_ConfigMem.Inst_frame1_bit29.Q _1633_
+ _1634_ _0095_ sg13g2_a21oi_1
X_6055_ Tile_X0Y1_FrameData[20] Tile_X0Y1_FrameStrobe[12] Tile_X0Y1_DSP_bot.Inst_DSP_bot_ConfigMem.Inst_frame12_bit20.Q
+ VPWR VGND sg13g2_dlhq_1
X_3405_ _1731_ Tile_X0Y1_DSP_bot.Inst_DSP_bot_ConfigMem.Inst_frame7_bit30.Q _1764_
+ _1765_ VPWR VGND sg13g2_a21o_1
X_3198_ Tile_X0Y0_DSP_top.Inst_DSP_top_ConfigMem.Inst_frame4_bit21.Q Tile_X0Y0_DSP_top.Inst_DSP_top_switch_matrix.N1END2
+ Tile_X0Y0_E1END[2] Tile_X0Y1_N2MID[6] Tile_X0Y0_E2END[6] Tile_X0Y0_DSP_top.Inst_DSP_top_ConfigMem.Inst_frame4_bit20.Q
+ _1570_ VPWR VGND sg13g2_mux4_1
XANTENNA_109 VPWR VGND Tile_X0Y0_S2MID[4] sg13g2_antennanp
XFILLER_53_154 VPWR VGND sg13g2_fill_1
XFILLER_38_173 VPWR VGND sg13g2_fill_1
XFILLER_26_335 VPWR VGND sg13g2_fill_1
XFILLER_26_346 VPWR VGND sg13g2_fill_2
XFILLER_107_112 VPWR VGND sg13g2_fill_1
X_5839_ Tile_X0Y1_FrameData[12] Tile_X0Y1_FrameStrobe[5] Tile_X0Y1_DSP_bot.Inst_DSP_bot_ConfigMem.Inst_frame5_bit12.Q
+ VPWR VGND sg13g2_dlhq_1
X_5908_ Tile_X0Y1_FrameData[7] Tile_X0Y1_FrameStrobe[7] Tile_X0Y1_DSP_bot.Inst_DSP_bot_ConfigMem.Inst_frame7_bit7.Q
+ VPWR VGND sg13g2_dlhq_1
XFILLER_107_134 VPWR VGND sg13g2_fill_2
XFILLER_44_110 VPWR VGND sg13g2_fill_2
XFILLER_29_140 VPWR VGND sg13g2_fill_1
XFILLER_55_85 VPWR VGND sg13g2_decap_8
XFILLER_44_176 VPWR VGND sg13g2_fill_1
XFILLER_65_7 VPWR VGND sg13g2_decap_4
XFILLER_96_92 VPWR VGND sg13g2_fill_2
X_3121_ VGND VPWR Tile_X0Y0_S4END[0] Tile_X0Y0_DSP_top.Inst_DSP_top_ConfigMem.Inst_frame0_bit22.Q
+ _1497_ _1496_ sg13g2_a21oi_1
X_4170_ _2416_ _2415_ Tile_X0Y1_DSP_bot.Inst_DSP_bot_ConfigMem.Inst_frame10_bit19.Q
+ Tile_X0Y1_DSP_bot.Inst_DSP_bot_switch_matrix.SS4BEG1 VPWR VGND sg13g2_mux2_1
X_3052_ _1429_ _1321_ _1322_ VPWR VGND sg13g2_xnor2_1
XFILLER_50_113 VPWR VGND sg13g2_decap_4
XFILLER_35_176 VPWR VGND sg13g2_decap_4
X_3885_ VGND VPWR Tile_X0Y0_SS4END[1] Tile_X0Y0_DSP_top.Inst_DSP_top_ConfigMem.Inst_frame4_bit0.Q
+ _2198_ _2197_ sg13g2_a21oi_1
X_3954_ Tile_X0Y0_DSP_top.Inst_DSP_top_ConfigMem.Inst_frame11_bit26.Q Tile_X0Y0_DSP_top.Inst_DSP_top_switch_matrix.bot2top2
+ Tile_X0Y0_DSP_top.Inst_DSP_top_switch_matrix.bot2top3 Tile_X0Y0_DSP_top.Inst_DSP_top_switch_matrix.bot2top4
+ Tile_X0Y0_DSP_top.Inst_DSP_top_switch_matrix.bot2top5 Tile_X0Y0_DSP_top.Inst_DSP_top_ConfigMem.Inst_frame11_bit27.Q
+ _2247_ VPWR VGND sg13g2_mux4_1
XFILLER_91_0 VPWR VGND sg13g2_fill_1
X_2836_ _1216_ _0939_ _1077_ _1187_ VPWR VGND sg13g2_and3_1
X_2905_ _0683_ _1260_ _1283_ VPWR VGND sg13g2_nor2_1
X_5624_ _2496_ VGND VPWR Tile_X0Y1_DSP_bot.A0 Tile_X0Y1_DSP_bot.Inst_MULADD.A_reg\[0\]
+ clknet_3_1_0_Tile_X0Y1_UserCLK_regs sg13g2_dfrbpq_1
X_5555_ Tile_X0Y0_FrameData[26] Tile_X0Y1_FrameStrobe[11] Tile_X0Y0_DSP_top.Inst_DSP_top_ConfigMem.Inst_frame11_bit26.Q
+ VPWR VGND sg13g2_dlhq_1
X_4437_ VPWR VGND Tile_X0Y0_DSP_top.Inst_DSP_top_ConfigMem.Inst_frame2_bit30.Q Tile_X0Y0_DSP_top.Inst_DSP_top_ConfigMem.Inst_frame2_bit31.Q
+ _0197_ _0192_ _0198_ _0195_ sg13g2_a221oi_1
X_5486_ Tile_X0Y0_FrameData[31] Tile_X0Y1_FrameStrobe[9] Tile_X0Y0_DSP_top.Inst_DSP_top_ConfigMem.Inst_frame9_bit31.Q
+ VPWR VGND sg13g2_dlhq_1
X_2767_ _1148_ VPWR _1149_ VGND _1008_ _1010_ sg13g2_o21ai_1
X_2698_ _1083_ _0971_ _0972_ VPWR VGND sg13g2_xnor2_1
X_4506_ VGND VPWR Tile_X0Y1_DSP_bot.Inst_DSP_bot_ConfigMem.Inst_frame4_bit4.Q _0126_
+ _0264_ _0263_ sg13g2_a21oi_1
X_4299_ VPWR _0062_ Tile_X0Y0_DSP_top.Inst_DSP_top_ConfigMem.Inst_frame3_bit18.Q VGND
+ sg13g2_inv_1
XFILLER_92_17 VPWR VGND sg13g2_fill_2
X_6107_ VPWR VGND _2505_ sg13g2_tiehi
X_4368_ VPWR _0131_ Tile_X0Y1_DSP_bot.Inst_DSP_bot_switch_matrix.Q9 VGND sg13g2_inv_1
X_3319_ Tile_X0Y1_DSP_bot.Inst_DSP_bot_ConfigMem.Inst_frame8_bit25.Q Tile_X0Y1_DSP_bot.Inst_DSP_bot_switch_matrix.JS2BEG5
+ _1684_ VPWR VGND sg13g2_nor2_1
X_6038_ Tile_X0Y1_FrameData[5] Tile_X0Y1_FrameStrobe[11] Tile_X0Y1_DSP_bot.Inst_DSP_bot_ConfigMem.Inst_frame11_bit5.Q
+ VPWR VGND sg13g2_dlhq_1
XFILLER_41_168 VPWR VGND sg13g2_fill_1
XFILLER_14_327 VPWR VGND sg13g2_fill_2
XFILLER_26_132 VPWR VGND sg13g2_fill_2
XFILLER_103_192 VPWR VGND sg13g2_fill_1
XFILLER_89_360 VPWR VGND sg13g2_fill_1
XFILLER_64_216 VPWR VGND sg13g2_fill_1
XFILLER_82_83 VPWR VGND sg13g2_fill_1
X_3670_ _2006_ Tile_X0Y0_DSP_top.Inst_DSP_top_ConfigMem.Inst_frame8_bit22.Q _2005_
+ VPWR VGND sg13g2_nand2_1
XFILLER_40_190 VPWR VGND sg13g2_fill_1
X_5340_ Tile_X0Y0_FrameData[17] Tile_X0Y1_FrameStrobe[4] Tile_X0Y0_DSP_top.Inst_DSP_top_ConfigMem.Inst_frame4_bit17.Q
+ VPWR VGND sg13g2_dlhq_1
X_5271_ Tile_X0Y0_FrameData[22] Tile_X0Y1_FrameStrobe[2] Tile_X0Y0_DSP_top.Inst_DSP_top_ConfigMem.Inst_frame2_bit22.Q
+ VPWR VGND sg13g2_dlhq_1
XFILLER_87_308 VPWR VGND sg13g2_fill_1
X_2552_ VGND VPWR _0943_ Tile_X0Y0_DSP_top.Inst_DSP_top_switch_matrix.bot2top0 Tile_X0Y0_DSP_top.Inst_DSP_top_ConfigMem.Inst_frame4_bit12.Q
+ sg13g2_or2_1
X_2621_ _1007_ _0994_ _1009_ VPWR VGND sg13g2_xor2_1
X_4222_ VGND VPWR Tile_X0Y1_DSP_bot.Inst_DSP_bot_ConfigMem.Inst_frame9_bit20.Q _2460_
+ _2461_ Tile_X0Y1_DSP_bot.Inst_DSP_bot_ConfigMem.Inst_frame9_bit21.Q sg13g2_a21oi_1
X_3104_ _1481_ _1480_ Tile_X0Y0_DSP_top.Inst_DSP_top_ConfigMem.Inst_frame1_bit22.Q
+ VPWR VGND sg13g2_nand2b_1
XFILLER_95_330 VPWR VGND sg13g2_fill_1
X_3035_ _1410_ VPWR _1412_ VGND _1407_ _1411_ sg13g2_o21ai_1
X_4153_ VPWR _2402_ _2401_ VGND sg13g2_inv_1
X_4084_ Tile_X0Y1_DSP_bot.Inst_DSP_bot_ConfigMem.Inst_frame10_bit26.Q Tile_X0Y1_DSP_bot.Inst_DSP_bot_switch_matrix.Q5
+ _0151_ Tile_X0Y1_DSP_bot.Inst_DSP_bot_switch_matrix.JS2BEG3 _0171_ Tile_X0Y1_DSP_bot.Inst_DSP_bot_ConfigMem.Inst_frame10_bit27.Q
+ Tile_X0Y1_DSP_bot.Inst_DSP_bot_switch_matrix.W1BEG0 VPWR VGND sg13g2_mux4_1
X_3937_ VGND VPWR Tile_X0Y0_DSP_top.Inst_DSP_top_ConfigMem.Inst_frame11_bit18.Q _2229_
+ _2233_ _2232_ sg13g2_a21oi_1
X_4986_ _0715_ VPWR Tile_X0Y0_DSP_top.Inst_DSP_top_switch_matrix.JS2BEG0 VGND Tile_X0Y0_DSP_top.Inst_DSP_top_ConfigMem.Inst_frame2_bit3.Q
+ _0722_ sg13g2_o21ai_1
XFILLER_11_308 VPWR VGND sg13g2_fill_1
X_3868_ Tile_X0Y0_DSP_top.Inst_DSP_top_ConfigMem.Inst_frame4_bit2.Q _2180_ _2181_
+ VPWR VGND sg13g2_nor2_1
X_3799_ VGND VPWR Tile_X0Y1_DSP_bot.Inst_DSP_bot_ConfigMem.Inst_frame12_bit2.Q _0119_
+ _2126_ Tile_X0Y1_DSP_bot.Inst_DSP_bot_ConfigMem.Inst_frame12_bit3.Q sg13g2_a21oi_1
X_5538_ Tile_X0Y0_FrameData[11] Tile_X0Y1_FrameStrobe[10] Tile_X0Y0_DSP_top.Inst_DSP_top_ConfigMem.Inst_frame10_bit11.Q
+ VPWR VGND sg13g2_dlhq_1
X_2819_ _0533_ _0969_ _1199_ VPWR VGND sg13g2_nor2_1
X_5607_ _2488_ VGND VPWR _0003_ Tile_X0Y1_DSP_bot.Inst_MULADD.ACC\[3\] clknet_3_2_0_Tile_X0Y1_UserCLK_regs
+ sg13g2_dfrbpq_1
X_5469_ Tile_X0Y0_FrameData[16] Tile_X0Y1_FrameStrobe[8] Tile_X0Y0_DSP_top.Inst_DSP_top_ConfigMem.Inst_frame8_bit16.Q
+ VPWR VGND sg13g2_dlhq_1
XFILLER_2_8 VPWR VGND sg13g2_fill_1
XFILLER_92_300 VPWR VGND sg13g2_fill_1
X_4840_ Tile_X0Y0_DSP_top.Inst_DSP_top_ConfigMem.Inst_frame1_bit5.Q VPWR _0583_ VGND
+ Tile_X0Y0_DSP_top.Inst_DSP_top_ConfigMem.Inst_frame1_bit4.Q Tile_X0Y0_DSP_top.Inst_DSP_top_switch_matrix.bot2top7
+ sg13g2_o21ai_1
X_3653_ Tile_X0Y0_DSP_top.Inst_DSP_top_ConfigMem.Inst_frame8_bit21.Q VPWR _1991_ VGND
+ Tile_X0Y0_DSP_top.Inst_DSP_top_ConfigMem.Inst_frame8_bit20.Q _1990_ sg13g2_o21ai_1
X_4771_ VGND VPWR Tile_X0Y0_DSP_top.Inst_DSP_top_ConfigMem.Inst_frame0_bit9.Q _0512_
+ _0516_ _0515_ sg13g2_a21oi_1
X_3722_ VPWR _2054_ _2053_ VGND sg13g2_inv_1
X_6441_ Tile_X0Y0_DSP_top.Inst_DSP_top_switch_matrix.S4BEG0 Tile_X0Y1_S4BEG[8] VPWR
+ VGND sg13g2_buf_1
X_2604_ VPWR _0992_ _0991_ VGND sg13g2_inv_1
X_6510_ Tile_X0Y1_DSP_bot.Inst_DSP_bot_switch_matrix.WW4BEG1 Tile_X0Y1_WW4BEG[13]
+ VPWR VGND sg13g2_buf_1
X_6372_ Tile_X0Y1_EE4END[11] Tile_X0Y1_EE4BEG[7] VPWR VGND sg13g2_buf_1
X_5185_ VGND VPWR Tile_X0Y1_N2MID[5] Tile_X0Y0_DSP_top.Inst_DSP_top_ConfigMem.Inst_frame3_bit16.Q
+ _0911_ Tile_X0Y0_DSP_top.Inst_DSP_top_ConfigMem.Inst_frame3_bit17.Q sg13g2_a21oi_1
X_5323_ Tile_X0Y0_FrameData[2] Tile_X0Y1_FrameStrobe[3] Tile_X0Y0_DSP_top.Inst_DSP_top_ConfigMem.Inst_frame3_bit2.Q
+ VPWR VGND sg13g2_dlhq_1
X_5254_ Tile_X0Y0_FrameData[7] Tile_X0Y1_FrameStrobe[1] Tile_X0Y0_DSP_top.Inst_DSP_top_ConfigMem.Inst_frame1_bit7.Q
+ VPWR VGND sg13g2_dlhq_1
XFILLER_68_330 VPWR VGND sg13g2_fill_2
X_3584_ _1558_ VPWR _1936_ VGND _1934_ _1935_ sg13g2_o21ai_1
XFILLER_54_0 VPWR VGND sg13g2_decap_8
X_2535_ VGND VPWR Tile_X0Y1_DSP_bot.Inst_DSP_bot_ConfigMem.Inst_frame4_bit8.Q _0128_
+ _0928_ Tile_X0Y1_DSP_bot.Inst_DSP_bot_ConfigMem.Inst_frame4_bit9.Q sg13g2_a21oi_1
X_4205_ VGND VPWR Tile_X0Y1_DSP_bot.Inst_DSP_bot_ConfigMem.Inst_frame9_bit16.Q _2443_
+ _2445_ _2444_ sg13g2_a21oi_1
X_3018_ _0900_ _1260_ _1395_ VPWR VGND sg13g2_nor2_1
X_4067_ _2337_ Tile_X0Y1_DSP_bot.Inst_DSP_bot_ConfigMem.Inst_frame3_bit3.Q _2338_
+ VPWR VGND sg13g2_nor2b_1
X_4136_ _2387_ Tile_X0Y1_DSP_bot.Inst_DSP_bot_ConfigMem.Inst_frame11_bit19.Q _1185_
+ VPWR VGND sg13g2_nand2_1
X_4969_ Tile_X0Y1_DSP_bot.Inst_DSP_bot_ConfigMem.Inst_frame7_bit15.Q VPWR _0706_ VGND
+ Tile_X0Y1_DSP_bot.Inst_DSP_bot_ConfigMem.Inst_frame7_bit14.Q Tile_X0Y1_W2MID[0]
+ sg13g2_o21ai_1
XFILLER_3_359 VPWR VGND sg13g2_fill_2
XFILLER_105_298 VPWR VGND sg13g2_fill_1
XFILLER_27_271 VPWR VGND sg13g2_fill_2
XFILLER_8_47 VPWR VGND sg13g2_fill_1
XFILLER_69_127 VPWR VGND sg13g2_fill_2
XFILLER_25_219 VPWR VGND sg13g2_decap_4
X_5941_ Tile_X0Y1_FrameData[6] Tile_X0Y1_FrameStrobe[8] Tile_X0Y1_DSP_bot.Inst_DSP_bot_ConfigMem.Inst_frame8_bit6.Q
+ VPWR VGND sg13g2_dlhq_1
X_4754_ VPWR VGND _0499_ Tile_X0Y0_DSP_top.Inst_DSP_top_ConfigMem.Inst_frame4_bit10.Q
+ _0498_ Tile_X0Y0_DSP_top.Inst_DSP_top_ConfigMem.Inst_frame4_bit9.Q _0500_ _0497_
+ sg13g2_a221oi_1
X_4823_ VGND VPWR Tile_X0Y0_DSP_top.Inst_DSP_top_ConfigMem.Inst_frame1_bit14.Q _0565_
+ _0566_ Tile_X0Y0_DSP_top.Inst_DSP_top_ConfigMem.Inst_frame1_bit15.Q sg13g2_a21oi_1
X_5872_ Tile_X0Y1_FrameData[11] Tile_X0Y1_FrameStrobe[6] Tile_X0Y1_DSP_bot.Inst_DSP_bot_ConfigMem.Inst_frame6_bit11.Q
+ VPWR VGND sg13g2_dlhq_1
X_3636_ Tile_X0Y0_DSP_top.Inst_DSP_top_ConfigMem.Inst_frame3_bit26.Q _1974_ _1975_
+ VPWR VGND sg13g2_nor2_1
X_3705_ VGND VPWR Tile_X0Y0_E2END[7] Tile_X0Y0_DSP_top.Inst_DSP_top_ConfigMem.Inst_frame1_bit24.Q
+ _2039_ _2038_ sg13g2_a21oi_1
X_4685_ Tile_X0Y0_DSP_top.Inst_DSP_top_ConfigMem.Inst_frame10_bit9.Q Tile_X0Y0_DSP_top.Inst_DSP_top_switch_matrix.bot2top7
+ Tile_X0Y0_DSP_top.Inst_DSP_top_switch_matrix.E2BEG2 _0433_ _0357_ Tile_X0Y0_DSP_top.Inst_DSP_top_ConfigMem.Inst_frame10_bit8.Q
+ _0435_ VPWR VGND sg13g2_mux4_1
X_6424_ Tile_X0Y1_DSP_bot.Inst_DSP_bot_switch_matrix.JS2BEG7 Tile_X0Y1_S2BEG[7] VPWR
+ VGND sg13g2_buf_1
X_6355_ Tile_X0Y1_E6END[4] Tile_X0Y1_E6BEG[2] VPWR VGND sg13g2_buf_1
X_3567_ VGND VPWR _1916_ _1917_ _1919_ _1875_ sg13g2_a21oi_1
X_5237_ Tile_X0Y0_FrameData[24] Tile_X0Y1_FrameStrobe[1] Tile_X0Y0_DSP_top.Inst_DSP_top_ConfigMem.Inst_frame1_bit24.Q
+ VPWR VGND sg13g2_dlhq_1
X_5306_ Tile_X0Y0_FrameData[19] Tile_X0Y1_FrameStrobe[3] Tile_X0Y0_DSP_top.Inst_DSP_top_ConfigMem.Inst_frame3_bit19.Q
+ VPWR VGND sg13g2_dlhq_1
X_6286_ Tile_X0Y0_DSP_top.Inst_DSP_top_switch_matrix.W1BEG1 Tile_X0Y0_W1BEG[1] VPWR
+ VGND sg13g2_buf_1
X_5168_ _0895_ _0894_ Tile_X0Y1_DSP_bot.Inst_DSP_bot_ConfigMem.Inst_frame9_bit26.Q
+ VPWR VGND sg13g2_nand2b_1
X_3498_ _1853_ VPWR _1854_ VGND Tile_X0Y1_DSP_bot.Inst_DSP_bot_ConfigMem.Inst_frame6_bit22.Q
+ _0150_ sg13g2_o21ai_1
X_5099_ _0829_ VPWR _0830_ VGND Tile_X0Y0_W2END[3] Tile_X0Y0_DSP_top.Inst_DSP_top_ConfigMem.Inst_frame2_bit8.Q
+ sg13g2_o21ai_1
XFILLER_83_196 VPWR VGND sg13g2_decap_4
XFILLER_17_56 VPWR VGND sg13g2_decap_4
XFILLER_17_89 VPWR VGND sg13g2_decap_8
X_4119_ Tile_X0Y1_DSP_bot.Inst_DSP_bot_ConfigMem.Inst_frame11_bit0.Q Tile_X0Y1_N1END[1]
+ Tile_X0Y1_W1END[1] Tile_X0Y1_E1END[1] Tile_X0Y1_DSP_bot.Inst_DSP_bot_switch_matrix.Q5
+ Tile_X0Y1_DSP_bot.Inst_DSP_bot_ConfigMem.Inst_frame12_bit31.Q _2374_ VPWR VGND sg13g2_mux4_1
XFILLER_3_145 VPWR VGND sg13g2_fill_2
XFILLER_30_200 VPWR VGND sg13g2_fill_2
X_4470_ _0228_ VPWR _0229_ VGND Tile_X0Y1_DSP_bot.Inst_DSP_bot_ConfigMem.Inst_frame1_bit0.Q
+ Tile_X0Y1_W2END[1] sg13g2_o21ai_1
X_3421_ _1780_ _1777_ _1779_ VPWR VGND sg13g2_nand2_1
XFILLER_97_200 VPWR VGND sg13g2_fill_1
X_6140_ Tile_X0Y0_DSP_top.Inst_DSP_top_switch_matrix.E2BEG4 Tile_X0Y0_E2BEG[4] VPWR
+ VGND sg13g2_buf_1
X_6071_ Tile_X0Y1_FrameData[4] Tile_X0Y1_FrameStrobe[12] Tile_X0Y1_DSP_bot.Inst_DSP_bot_ConfigMem.Inst_frame12_bit4.Q
+ VPWR VGND sg13g2_dlhq_1
X_3352_ VGND VPWR Tile_X0Y1_DSP_bot.Inst_DSP_bot_ConfigMem.Inst_frame1_bit24.Q _0436_
+ _1715_ _1714_ sg13g2_a21oi_1
X_3283_ VGND VPWR Tile_X0Y1_DSP_bot.Inst_DSP_bot_ConfigMem.Inst_frame1_bit29.Q _1646_
+ _1650_ _1649_ sg13g2_a21oi_1
X_5022_ VGND VPWR Tile_X0Y1_DSP_bot.Inst_DSP_bot_ConfigMem.Inst_frame6_bit7.Q _0753_
+ _0757_ _0756_ sg13g2_a21oi_1
XFILLER_80_166 VPWR VGND sg13g2_fill_1
XFILLER_53_314 VPWR VGND sg13g2_fill_1
X_5924_ Tile_X0Y1_FrameData[23] Tile_X0Y1_FrameStrobe[8] Tile_X0Y1_DSP_bot.Inst_DSP_bot_ConfigMem.Inst_frame8_bit23.Q
+ VPWR VGND sg13g2_dlhq_1
X_2998_ _1375_ _1355_ _1357_ VPWR VGND sg13g2_xnor2_1
X_4737_ VGND VPWR Tile_X0Y1_DSP_bot.Inst_DSP_bot_ConfigMem.Inst_frame4_bit29.Q _0484_
+ _0485_ Tile_X0Y1_DSP_bot.Inst_DSP_bot_ConfigMem.Inst_frame4_bit30.Q sg13g2_a21oi_1
X_5786_ Tile_X0Y1_FrameData[1] Tile_X0Y1_FrameStrobe[3] Tile_X0Y1_DSP_bot.Inst_DSP_bot_ConfigMem.Inst_frame3_bit1.Q
+ VPWR VGND sg13g2_dlhq_1
X_4806_ Tile_X0Y1_DSP_bot.Inst_DSP_bot_ConfigMem.Inst_frame4_bit3.Q _0549_ _0550_
+ VPWR VGND sg13g2_nor2_1
X_5855_ Tile_X0Y1_FrameData[28] Tile_X0Y1_FrameStrobe[6] Tile_X0Y1_DSP_bot.Inst_DSP_bot_ConfigMem.Inst_frame6_bit28.Q
+ VPWR VGND sg13g2_dlhq_1
XFILLER_21_288 VPWR VGND sg13g2_fill_2
XFILLER_107_305 VPWR VGND sg13g2_fill_1
X_4599_ VGND VPWR Tile_X0Y0_DSP_top.Inst_DSP_top_ConfigMem.Inst_frame4_bit5.Q _0351_
+ _0353_ _0352_ sg13g2_a21oi_1
X_3619_ _1960_ Tile_X0Y1_DSP_bot.Inst_MULADD.ACC\[11\] Tile_X0Y1_DSP_bot.Inst_DSP_bot_ConfigMem.Inst_frame12_bit5.Q
+ VPWR VGND sg13g2_nand2_1
X_4668_ Tile_X0Y0_DSP_top.Inst_DSP_top_ConfigMem.Inst_frame3_bit5.Q Tile_X0Y0_E6END[0]
+ Tile_X0Y0_W2END[2] Tile_X0Y0_S2END[2] Tile_X0Y0_WW4END[3] Tile_X0Y0_DSP_top.Inst_DSP_top_ConfigMem.Inst_frame3_bit4.Q
+ _0420_ VPWR VGND sg13g2_mux4_1
X_6407_ Tile_X0Y1_FrameData[26] Tile_X0Y1_FrameData_O[26] VPWR VGND sg13g2_buf_1
X_6338_ Tile_X0Y1_DSP_bot.Inst_DSP_bot_switch_matrix.E2BEG1 Tile_X0Y1_E2BEG[1] VPWR
+ VGND sg13g2_buf_1
X_6269_ Tile_X0Y1_NN4END[9] Tile_X0Y0_NN4BEG[1] VPWR VGND sg13g2_buf_1
X_3970_ Tile_X0Y0_DSP_top.Inst_DSP_top_ConfigMem.Inst_frame10_bit18.Q Tile_X0Y0_DSP_top.Inst_DSP_top_switch_matrix.N1END2
+ Tile_X0Y0_E1END[2] Tile_X0Y0_W1END[2] Tile_X0Y0_DSP_top.Inst_DSP_top_switch_matrix.bot2top2
+ Tile_X0Y0_DSP_top.Inst_DSP_top_ConfigMem.Inst_frame10_bit19.Q _2261_ VPWR VGND sg13g2_mux4_1
X_2783_ _1164_ VPWR _1165_ VGND Tile_X0Y0_DSP_top.Inst_DSP_top_ConfigMem.Inst_frame2_bit24.Q
+ _0293_ sg13g2_o21ai_1
X_5571_ Tile_X0Y0_FrameData[10] Tile_X0Y1_FrameStrobe[11] Tile_X0Y0_DSP_top.Inst_DSP_top_ConfigMem.Inst_frame11_bit10.Q
+ VPWR VGND sg13g2_dlhq_1
X_2852_ _1231_ _0171_ Tile_X0Y1_DSP_bot.Inst_DSP_bot_ConfigMem.Inst_frame8_bit0.Q
+ _1232_ VPWR VGND sg13g2_mux2_1
X_2921_ _1299_ Tile_X0Y1_W2MID[7] Tile_X0Y1_DSP_bot.Inst_DSP_bot_ConfigMem.Inst_frame6_bit8.Q
+ VPWR VGND sg13g2_nand2_1
X_5640_ _2512_ VGND VPWR Tile_X0Y1_DSP_bot.C0 Tile_X0Y1_DSP_bot.Inst_MULADD.C_reg\[0\]
+ clknet_3_3_0_Tile_X0Y1_UserCLK_regs sg13g2_dfrbpq_1
X_4384_ Tile_X0Y0_W2END[2] Tile_X0Y0_W6END[0] Tile_X0Y0_DSP_top.Inst_DSP_top_ConfigMem.Inst_frame2_bit4.Q
+ _0147_ VPWR VGND sg13g2_mux2_1
X_4522_ Tile_X0Y1_DSP_bot.Inst_DSP_bot_ConfigMem.Inst_frame1_bit8.Q Tile_X0Y1_N1END[1]
+ Tile_X0Y1_N2END[3] Tile_X0Y1_E2END[3] Tile_X0Y1_E6END[1] Tile_X0Y1_DSP_bot.Inst_DSP_bot_ConfigMem.Inst_frame1_bit9.Q
+ _0279_ VPWR VGND sg13g2_mux4_1
X_4453_ VGND VPWR Tile_X0Y1_DSP_bot.Inst_DSP_bot_ConfigMem.Inst_frame2_bit12.Q _0126_
+ _0213_ _0212_ sg13g2_a21oi_1
X_3404_ Tile_X0Y1_DSP_bot.Inst_DSP_bot_ConfigMem.Inst_frame7_bit31.Q VPWR _1764_ VGND
+ Tile_X0Y1_W2MID[0] Tile_X0Y1_DSP_bot.Inst_DSP_bot_ConfigMem.Inst_frame7_bit30.Q
+ sg13g2_o21ai_1
X_3197_ _1568_ VPWR _1569_ VGND Tile_X0Y0_DSP_top.Inst_DSP_top_ConfigMem.Inst_frame4_bit22.Q
+ _1567_ sg13g2_o21ai_1
X_3335_ _1696_ _1698_ Tile_X0Y1_DSP_bot.Inst_DSP_bot_ConfigMem.Inst_frame3_bit26.Q
+ _1699_ VPWR VGND sg13g2_nand3_1
X_5005_ _0074_ Tile_X0Y1_DSP_bot.Inst_MULADD.B_reg\[3\] _0740_ VPWR VGND sg13g2_nor2_1
X_3266_ _1632_ VPWR _1633_ VGND _0037_ Tile_X0Y1_DSP_bot.Inst_DSP_bot_ConfigMem.Inst_frame1_bit28.Q
+ sg13g2_o21ai_1
X_6123_ VPWR VGND _2521_ sg13g2_tiehi
X_6054_ Tile_X0Y1_FrameData[21] Tile_X0Y1_FrameStrobe[12] Tile_X0Y1_DSP_bot.Inst_DSP_bot_ConfigMem.Inst_frame12_bit21.Q
+ VPWR VGND sg13g2_dlhq_1
X_5907_ Tile_X0Y1_FrameData[8] Tile_X0Y1_FrameStrobe[7] Tile_X0Y1_DSP_bot.Inst_DSP_bot_ConfigMem.Inst_frame7_bit8.Q
+ VPWR VGND sg13g2_dlhq_1
X_5769_ Tile_X0Y1_FrameData[18] Tile_X0Y1_FrameStrobe[3] Tile_X0Y1_DSP_bot.Inst_DSP_bot_ConfigMem.Inst_frame3_bit18.Q
+ VPWR VGND sg13g2_dlhq_1
XFILLER_5_229 VPWR VGND sg13g2_fill_1
XFILLER_14_46 VPWR VGND sg13g2_fill_1
X_5838_ Tile_X0Y1_FrameData[13] Tile_X0Y1_FrameStrobe[5] Tile_X0Y1_DSP_bot.Inst_DSP_bot_ConfigMem.Inst_frame5_bit13.Q
+ VPWR VGND sg13g2_dlhq_1
XFILLER_30_12 VPWR VGND sg13g2_fill_1
XFILLER_30_56 VPWR VGND sg13g2_fill_1
XFILLER_91_228 VPWR VGND sg13g2_fill_2
XFILLER_91_206 VPWR VGND sg13g2_fill_2
XFILLER_40_350 VPWR VGND sg13g2_fill_1
XFILLER_67_269 VPWR VGND sg13g2_fill_1
X_3120_ Tile_X0Y0_DSP_top.Inst_DSP_top_ConfigMem.Inst_frame0_bit22.Q Tile_X0Y0_EE4END[3]
+ _1496_ VPWR VGND sg13g2_nor2b_1
X_3051_ _1350_ _1373_ _1427_ _1428_ VPWR VGND sg13g2_nor3_1
X_3953_ Tile_X0Y0_DSP_top.Inst_DSP_top_ConfigMem.Inst_frame11_bit26.Q Tile_X0Y0_E1END[3]
+ Tile_X0Y0_W1END[3] Tile_X0Y0_DSP_top.Inst_DSP_top_switch_matrix.bot2top0 Tile_X0Y0_DSP_top.Inst_DSP_top_switch_matrix.bot2top1
+ Tile_X0Y0_DSP_top.Inst_DSP_top_ConfigMem.Inst_frame11_bit27.Q _2246_ VPWR VGND sg13g2_mux4_1
XFILLER_90_261 VPWR VGND sg13g2_fill_2
X_3884_ Tile_X0Y0_DSP_top.Inst_DSP_top_ConfigMem.Inst_frame4_bit0.Q Tile_X0Y0_E6END[1]
+ _2197_ VPWR VGND sg13g2_nor2b_1
X_5554_ Tile_X0Y0_FrameData[27] Tile_X0Y1_FrameStrobe[11] Tile_X0Y0_DSP_top.Inst_DSP_top_ConfigMem.Inst_frame11_bit27.Q
+ VPWR VGND sg13g2_dlhq_1
X_5623_ _2495_ VGND VPWR _0019_ Tile_X0Y1_DSP_bot.Inst_MULADD.ACC\[19\] clknet_3_7_0_Tile_X0Y1_UserCLK_regs
+ sg13g2_dfrbpq_1
X_2766_ _1147_ _1143_ _1148_ VPWR VGND sg13g2_xor2_1
X_2904_ _1280_ _1281_ _1282_ VPWR VGND sg13g2_nor2_1
X_2835_ _1215_ _0939_ _1187_ VPWR VGND sg13g2_nand2_1
XFILLER_100_300 VPWR VGND sg13g2_fill_1
X_4436_ VPWR _0197_ _0196_ VGND sg13g2_inv_1
X_5485_ Tile_X0Y0_FrameData[0] Tile_X0Y1_FrameStrobe[8] Tile_X0Y0_DSP_top.Inst_DSP_top_ConfigMem.Inst_frame8_bit0.Q
+ VPWR VGND sg13g2_dlhq_1
X_2697_ _1079_ VPWR _1082_ VGND _1080_ _1081_ sg13g2_o21ai_1
X_6106_ VPWR VGND _2504_ sg13g2_tiehi
X_4367_ VPWR _0130_ Tile_X0Y1_DSP_bot.Inst_DSP_bot_switch_matrix.Q8 VGND sg13g2_inv_1
X_4505_ Tile_X0Y1_DSP_bot.Inst_DSP_bot_ConfigMem.Inst_frame4_bit4.Q Tile_X0Y1_DSP_bot.Inst_DSP_bot_switch_matrix.Q5
+ _0263_ VPWR VGND sg13g2_nor2_1
X_3318_ VPWR Tile_X0Y1_DSP_bot.Inst_DSP_bot_switch_matrix.JS2BEG5 _1683_ VGND sg13g2_inv_1
X_3249_ Tile_X0Y1_DSP_bot.Inst_DSP_bot_ConfigMem.Inst_frame1_bit21.Q Tile_X0Y1_N1END[2]
+ Tile_X0Y1_E1END[2] Tile_X0Y1_N2END[6] Tile_X0Y1_E2END[6] Tile_X0Y1_DSP_bot.Inst_DSP_bot_ConfigMem.Inst_frame1_bit20.Q
+ _1617_ VPWR VGND sg13g2_mux4_1
X_4298_ VPWR _0061_ Tile_X0Y1_DSP_bot.Inst_DSP_bot_ConfigMem.Inst_frame4_bit11.Q VGND
+ sg13g2_inv_1
X_6037_ Tile_X0Y1_FrameData[6] Tile_X0Y1_FrameStrobe[11] Tile_X0Y1_DSP_bot.Inst_DSP_bot_ConfigMem.Inst_frame11_bit6.Q
+ VPWR VGND sg13g2_dlhq_1
X_2620_ _0816_ _0969_ _1007_ _1008_ VPWR VGND sg13g2_nor3_1
X_5270_ Tile_X0Y0_FrameData[23] Tile_X0Y1_FrameStrobe[2] Tile_X0Y0_DSP_top.Inst_DSP_top_ConfigMem.Inst_frame2_bit23.Q
+ VPWR VGND sg13g2_dlhq_1
X_2551_ Tile_X0Y0_DSP_top.Inst_DSP_top_switch_matrix.bot2top2 Tile_X0Y0_DSP_top.Inst_DSP_top_switch_matrix.bot2top4
+ Tile_X0Y0_DSP_top.Inst_DSP_top_ConfigMem.Inst_frame4_bit12.Q _0942_ VPWR VGND sg13g2_mux2_1
XFILLER_56_4 VPWR VGND sg13g2_fill_1
X_4221_ VPWR _2460_ _2459_ VGND sg13g2_inv_1
X_3103_ Tile_X0Y0_DSP_top.Inst_DSP_top_ConfigMem.Inst_frame1_bit21.Q Tile_X0Y0_DSP_top.Inst_DSP_top_switch_matrix.N1END2
+ Tile_X0Y0_E1END[2] Tile_X0Y1_N2MID[6] Tile_X0Y0_E2END[6] Tile_X0Y0_DSP_top.Inst_DSP_top_ConfigMem.Inst_frame1_bit20.Q
+ _1480_ VPWR VGND sg13g2_mux4_1
X_3034_ _1411_ _1404_ _1409_ VPWR VGND sg13g2_xnor2_1
X_4083_ Tile_X0Y1_DSP_bot.Inst_DSP_bot_ConfigMem.Inst_frame10_bit12.Q Tile_X0Y0_S2MID[1]
+ Tile_X0Y0_S4END[4] Tile_X0Y1_W6END[0] Tile_X0Y1_DSP_bot.Inst_DSP_bot_switch_matrix.Q3
+ Tile_X0Y1_DSP_bot.Inst_DSP_bot_ConfigMem.Inst_frame10_bit13.Q Tile_X0Y1_DSP_bot.Inst_DSP_bot_switch_matrix.S4BEG3
+ VPWR VGND sg13g2_mux4_1
X_4152_ Tile_X0Y1_DSP_bot.Inst_DSP_bot_ConfigMem.Inst_frame11_bit27.Q Tile_X0Y1_DSP_bot.Inst_DSP_bot_switch_matrix.Q2
+ Tile_X0Y1_DSP_bot.Inst_DSP_bot_switch_matrix.Q4 Tile_X0Y1_DSP_bot.Inst_DSP_bot_switch_matrix.Q3
+ Tile_X0Y1_DSP_bot.Inst_DSP_bot_switch_matrix.Q5 Tile_X0Y1_DSP_bot.Inst_DSP_bot_ConfigMem.Inst_frame11_bit26.Q
+ _2401_ VPWR VGND sg13g2_mux4_1
X_3936_ Tile_X0Y0_DSP_top.Inst_DSP_top_ConfigMem.Inst_frame11_bit19.Q VPWR _2232_
+ VGND Tile_X0Y0_DSP_top.Inst_DSP_top_ConfigMem.Inst_frame11_bit18.Q _2231_ sg13g2_o21ai_1
X_4985_ _0721_ VPWR _0722_ VGND Tile_X0Y0_DSP_top.Inst_DSP_top_ConfigMem.Inst_frame2_bit2.Q
+ _0716_ sg13g2_o21ai_1
XFILLER_23_158 VPWR VGND sg13g2_fill_2
XFILLER_109_219 VPWR VGND sg13g2_fill_2
X_3798_ _2097_ Tile_X0Y0_DSP_top.Inst_DSP_top_ConfigMem.Inst_frame8_bit31.Q _2125_
+ Tile_X0Y0_DSP_top.Inst_DSP_top_switch_matrix.inst_cus_mux81_buf_top2bot17.X VPWR
+ VGND sg13g2_a21o_1
X_3867_ Tile_X0Y0_DSP_top.Inst_DSP_top_ConfigMem.Inst_frame4_bit0.Q Tile_X0Y0_DSP_top.Inst_DSP_top_switch_matrix.bot2top1
+ Tile_X0Y0_DSP_top.Inst_DSP_top_switch_matrix.bot2top2 Tile_X0Y0_DSP_top.Inst_DSP_top_switch_matrix.bot2top3
+ Tile_X0Y0_DSP_top.Inst_DSP_top_switch_matrix.bot2top4 Tile_X0Y0_DSP_top.Inst_DSP_top_ConfigMem.Inst_frame4_bit1.Q
+ _2180_ VPWR VGND sg13g2_mux4_1
X_5537_ Tile_X0Y0_FrameData[12] Tile_X0Y1_FrameStrobe[10] Tile_X0Y0_DSP_top.Inst_DSP_top_ConfigMem.Inst_frame10_bit12.Q
+ VPWR VGND sg13g2_dlhq_1
X_2749_ VGND VPWR _1131_ _1130_ _0743_ sg13g2_or2_1
X_2818_ VGND VPWR _0967_ _0968_ _1198_ _0742_ sg13g2_a21oi_1
XFILLER_11_25 VPWR VGND sg13g2_fill_2
X_5606_ _2489_ VGND VPWR _0002_ Tile_X0Y1_DSP_bot.Inst_MULADD.ACC\[2\] clknet_3_2_0_Tile_X0Y1_UserCLK_regs
+ sg13g2_dfrbpq_1
X_5468_ Tile_X0Y0_FrameData[17] Tile_X0Y1_FrameStrobe[8] Tile_X0Y0_DSP_top.Inst_DSP_top_ConfigMem.Inst_frame8_bit17.Q
+ VPWR VGND sg13g2_dlhq_1
X_5399_ Tile_X0Y0_FrameData[22] Tile_X0Y1_FrameStrobe[6] Tile_X0Y0_DSP_top.Inst_DSP_top_ConfigMem.Inst_frame6_bit22.Q
+ VPWR VGND sg13g2_dlhq_1
X_4419_ Tile_X0Y1_W2END[4] Tile_X0Y1_W6END[0] Tile_X0Y1_DSP_bot.Inst_DSP_bot_ConfigMem.Inst_frame1_bit12.Q
+ _0180_ VPWR VGND sg13g2_mux2_1
XFILLER_36_77 VPWR VGND sg13g2_fill_2
XFILLER_14_103 VPWR VGND sg13g2_fill_2
XFILLER_108_296 VPWR VGND sg13g2_fill_1
XFILLER_108_230 VPWR VGND sg13g2_fill_1
XFILLER_96_117 VPWR VGND sg13g2_fill_1
XFILLER_89_191 VPWR VGND sg13g2_decap_4
XFILLER_77_353 VPWR VGND sg13g2_fill_2
XFILLER_37_228 VPWR VGND sg13g2_fill_1
X_4770_ Tile_X0Y0_DSP_top.Inst_DSP_top_ConfigMem.Inst_frame8_bit2.Q VPWR _0515_ VGND
+ Tile_X0Y0_DSP_top.Inst_DSP_top_ConfigMem.Inst_frame0_bit9.Q _0514_ sg13g2_o21ai_1
XFILLER_60_297 VPWR VGND sg13g2_fill_1
XFILLER_20_106 VPWR VGND sg13g2_decap_4
X_6440_ Tile_X0Y0_S4END[15] Tile_X0Y1_S4BEG[7] VPWR VGND sg13g2_buf_1
X_3652_ Tile_X0Y0_DSP_top.Inst_DSP_top_ConfigMem.Inst_frame5_bit26.Q Tile_X0Y1_N2MID[3]
+ Tile_X0Y0_E2END[3] Tile_X0Y0_SS4END[0] Tile_X0Y0_W2END[3] Tile_X0Y0_DSP_top.Inst_DSP_top_ConfigMem.Inst_frame5_bit27.Q
+ _1990_ VPWR VGND sg13g2_mux4_1
X_5322_ Tile_X0Y0_FrameData[3] Tile_X0Y1_FrameStrobe[3] Tile_X0Y0_DSP_top.Inst_DSP_top_ConfigMem.Inst_frame3_bit3.Q
+ VPWR VGND sg13g2_dlhq_1
X_3721_ _2053_ _2000_ _2051_ VPWR VGND sg13g2_nand2_1
X_3583_ _1935_ _1555_ _1557_ VPWR VGND sg13g2_xnor2_1
X_2603_ Tile_X0Y1_DSP_bot.Inst_MULADD.A_reg\[5\] Tile_X0Y0_DSP_top.Inst_DSP_top_switch_matrix.inst_cus_mux41_buf_top2bot1.X
+ _0073_ _0991_ VPWR VGND sg13g2_mux2_1
X_2534_ _0927_ Tile_X0Y1_DSP_bot.Inst_DSP_bot_ConfigMem.Inst_frame4_bit9.Q _0926_
+ VPWR VGND sg13g2_nand2_1
X_6371_ Tile_X0Y1_EE4END[10] Tile_X0Y1_EE4BEG[6] VPWR VGND sg13g2_buf_1
X_5253_ Tile_X0Y0_FrameData[8] Tile_X0Y1_FrameStrobe[1] Tile_X0Y0_DSP_top.Inst_DSP_top_ConfigMem.Inst_frame1_bit8.Q
+ VPWR VGND sg13g2_dlhq_1
X_5184_ _0910_ _0237_ Tile_X0Y0_DSP_top.Inst_DSP_top_ConfigMem.Inst_frame3_bit16.Q
+ VPWR VGND sg13g2_nand2b_1
XFILLER_68_320 VPWR VGND sg13g2_fill_2
XFILLER_47_0 VPWR VGND sg13g2_fill_1
X_4135_ _2385_ _2386_ Tile_X0Y1_DSP_bot.Inst_DSP_bot_ConfigMem.Inst_frame11_bit18.Q
+ Tile_X0Y1_DSP_bot.Inst_DSP_bot_switch_matrix.EE4BEG2 VPWR VGND sg13g2_mux2_1
X_4204_ Tile_X0Y1_DSP_bot.Inst_DSP_bot_ConfigMem.Inst_frame9_bit16.Q _2442_ _2444_
+ VPWR VGND sg13g2_nor2b_1
XFILLER_95_172 VPWR VGND sg13g2_decap_8
X_3017_ _0787_ _1308_ _1394_ VPWR VGND sg13g2_nor2_1
X_4066_ VGND VPWR Tile_X0Y1_DSP_bot.Inst_DSP_bot_ConfigMem.Inst_frame3_bit1.Q _2335_
+ _2337_ _2336_ sg13g2_a21oi_1
X_3919_ _0115_ VPWR _2218_ VGND Tile_X0Y0_DSP_top.Inst_DSP_top_ConfigMem.Inst_frame11_bit0.Q
+ Tile_X0Y0_DSP_top.Inst_DSP_top_switch_matrix.bot2top8 sg13g2_o21ai_1
XFILLER_51_297 VPWR VGND sg13g2_fill_2
XFILLER_51_253 VPWR VGND sg13g2_fill_1
X_4899_ VGND VPWR Tile_X0Y1_DSP_bot.Inst_DSP_bot_ConfigMem.Inst_frame4_bit16.Q _0130_
+ _0639_ _0638_ sg13g2_a21oi_1
X_4968_ VPWR VGND _0702_ _0077_ _0696_ _0688_ _0705_ _0691_ sg13g2_a221oi_1
XFILLER_3_327 VPWR VGND sg13g2_fill_1
XFILLER_86_183 VPWR VGND sg13g2_fill_2
XFILLER_63_20 VPWR VGND sg13g2_fill_2
XFILLER_42_264 VPWR VGND sg13g2_fill_2
XFILLER_27_294 VPWR VGND sg13g2_fill_1
XFILLER_10_161 VPWR VGND sg13g2_fill_1
XFILLER_92_164 VPWR VGND sg13g2_fill_2
XFILLER_80_359 VPWR VGND sg13g2_fill_2
XFILLER_77_150 VPWR VGND sg13g2_fill_2
X_5940_ Tile_X0Y1_FrameData[7] Tile_X0Y1_FrameStrobe[8] Tile_X0Y1_DSP_bot.Inst_DSP_bot_ConfigMem.Inst_frame8_bit7.Q
+ VPWR VGND sg13g2_dlhq_1
X_4753_ VGND VPWR Tile_X0Y0_DSP_top.Inst_DSP_top_ConfigMem.Inst_frame4_bit8.Q _0133_
+ _0499_ Tile_X0Y0_DSP_top.Inst_DSP_top_ConfigMem.Inst_frame4_bit9.Q sg13g2_a21oi_1
X_3704_ Tile_X0Y0_DSP_top.Inst_DSP_top_ConfigMem.Inst_frame1_bit25.Q VPWR _2038_ VGND
+ _0052_ Tile_X0Y0_DSP_top.Inst_DSP_top_ConfigMem.Inst_frame1_bit24.Q sg13g2_o21ai_1
X_4822_ VPWR _0565_ _0564_ VGND sg13g2_inv_1
X_5871_ Tile_X0Y1_FrameData[12] Tile_X0Y1_FrameStrobe[6] Tile_X0Y1_DSP_bot.Inst_DSP_bot_ConfigMem.Inst_frame6_bit12.Q
+ VPWR VGND sg13g2_dlhq_1
X_5305_ Tile_X0Y0_FrameData[20] Tile_X0Y1_FrameStrobe[3] Tile_X0Y0_DSP_top.Inst_DSP_top_ConfigMem.Inst_frame3_bit20.Q
+ VPWR VGND sg13g2_dlhq_1
X_3635_ VGND VPWR Tile_X0Y0_E2END[7] Tile_X0Y0_DSP_top.Inst_DSP_top_ConfigMem.Inst_frame3_bit24.Q
+ _1974_ _1973_ sg13g2_a21oi_1
X_4684_ VPWR _0434_ _0433_ VGND sg13g2_inv_1
X_6285_ Tile_X0Y0_DSP_top.Inst_DSP_top_switch_matrix.W1BEG0 Tile_X0Y0_W1BEG[0] VPWR
+ VGND sg13g2_buf_1
XFILLER_0_308 VPWR VGND sg13g2_fill_2
X_6423_ Tile_X0Y1_DSP_bot.Inst_DSP_bot_switch_matrix.JS2BEG6 Tile_X0Y1_S2BEG[6] VPWR
+ VGND sg13g2_buf_1
X_3497_ _1853_ Tile_X0Y1_W2MID[1] Tile_X0Y1_DSP_bot.Inst_DSP_bot_ConfigMem.Inst_frame6_bit22.Q
+ VPWR VGND sg13g2_nand2_1
X_6354_ Tile_X0Y1_E6END[3] Tile_X0Y1_E6BEG[1] VPWR VGND sg13g2_buf_1
X_3566_ _1918_ _1917_ _1875_ VPWR VGND sg13g2_nand2b_1
XFILLER_102_258 VPWR VGND sg13g2_fill_2
X_5236_ Tile_X0Y0_FrameData[25] Tile_X0Y1_FrameStrobe[1] Tile_X0Y0_DSP_top.Inst_DSP_top_ConfigMem.Inst_frame1_bit25.Q
+ VPWR VGND sg13g2_dlhq_1
X_5098_ _0829_ _0036_ Tile_X0Y0_DSP_top.Inst_DSP_top_ConfigMem.Inst_frame2_bit8.Q
+ VPWR VGND sg13g2_nand2_1
X_5167_ Tile_X0Y1_DSP_bot.Inst_DSP_bot_ConfigMem.Inst_frame5_bit5.Q Tile_X0Y1_N2END[4]
+ Tile_X0Y0_S2MID[4] Tile_X0Y1_EE4END[0] Tile_X0Y1_W2END[4] Tile_X0Y1_DSP_bot.Inst_DSP_bot_ConfigMem.Inst_frame5_bit4.Q
+ _0894_ VPWR VGND sg13g2_mux4_1
X_4118_ Tile_X0Y1_DSP_bot.Inst_DSP_bot_ConfigMem.Inst_frame11_bit0.Q Tile_X0Y1_DSP_bot.Inst_DSP_bot_switch_matrix.Q9
+ _1785_ _1866_ _1064_ Tile_X0Y1_DSP_bot.Inst_DSP_bot_ConfigMem.Inst_frame12_bit31.Q
+ _2373_ VPWR VGND sg13g2_mux4_1
X_4049_ VGND VPWR Tile_X0Y0_DSP_top.Inst_DSP_top_ConfigMem.Inst_frame9_bit24.Q _2330_
+ _2331_ Tile_X0Y0_DSP_top.Inst_DSP_top_ConfigMem.Inst_frame9_bit25.Q sg13g2_a21oi_1
XFILLER_24_297 VPWR VGND sg13g2_fill_1
X_3351_ _0099_ VPWR _1714_ VGND Tile_X0Y1_DSP_bot.Inst_DSP_bot_ConfigMem.Inst_frame1_bit24.Q
+ _0669_ sg13g2_o21ai_1
X_3420_ _1779_ _1426_ _1778_ VPWR VGND sg13g2_xnor2_1
X_3282_ Tile_X0Y1_DSP_bot.Inst_DSP_bot_ConfigMem.Inst_frame1_bit30.Q VPWR _1649_ VGND
+ Tile_X0Y1_DSP_bot.Inst_DSP_bot_ConfigMem.Inst_frame1_bit29.Q _1648_ sg13g2_o21ai_1
X_5021_ Tile_X0Y1_DSP_bot.Inst_DSP_bot_ConfigMem.Inst_frame9_bit28.Q VPWR _0756_ VGND
+ Tile_X0Y1_DSP_bot.Inst_DSP_bot_ConfigMem.Inst_frame6_bit7.Q _0755_ sg13g2_o21ai_1
X_6070_ Tile_X0Y1_FrameData[5] Tile_X0Y1_FrameStrobe[12] Tile_X0Y1_DSP_bot.Inst_DSP_bot_ConfigMem.Inst_frame12_bit5.Q
+ VPWR VGND sg13g2_dlhq_1
X_5923_ Tile_X0Y1_FrameData[24] Tile_X0Y1_FrameStrobe[8] Tile_X0Y1_DSP_bot.Inst_DSP_bot_ConfigMem.Inst_frame8_bit24.Q
+ VPWR VGND sg13g2_dlhq_1
X_5854_ Tile_X0Y1_FrameData[29] Tile_X0Y1_FrameStrobe[6] Tile_X0Y1_DSP_bot.Inst_DSP_bot_ConfigMem.Inst_frame6_bit29.Q
+ VPWR VGND sg13g2_dlhq_1
X_4667_ VGND VPWR Tile_X0Y0_DSP_top.Inst_DSP_top_ConfigMem.Inst_frame3_bit5.Q _0418_
+ _0419_ Tile_X0Y0_DSP_top.Inst_DSP_top_ConfigMem.Inst_frame3_bit6.Q sg13g2_a21oi_1
X_2997_ _1374_ _1351_ _1363_ VPWR VGND sg13g2_xnor2_1
X_4736_ Tile_X0Y1_DSP_bot.Inst_DSP_bot_switch_matrix.Q2 Tile_X0Y1_DSP_bot.Inst_DSP_bot_switch_matrix.Q3
+ Tile_X0Y1_DSP_bot.Inst_DSP_bot_ConfigMem.Inst_frame4_bit28.Q _0484_ VPWR VGND sg13g2_mux2_1
X_5785_ Tile_X0Y1_FrameData[2] Tile_X0Y1_FrameStrobe[3] Tile_X0Y1_DSP_bot.Inst_DSP_bot_ConfigMem.Inst_frame3_bit2.Q
+ VPWR VGND sg13g2_dlhq_1
X_4805_ VGND VPWR Tile_X0Y1_DSP_bot.Inst_DSP_bot_ConfigMem.Inst_frame4_bit1.Q _0546_
+ _0549_ _0548_ sg13g2_a21oi_1
X_4598_ Tile_X0Y0_DSP_top.Inst_DSP_top_ConfigMem.Inst_frame4_bit6.Q VPWR _0352_ VGND
+ Tile_X0Y0_DSP_top.Inst_DSP_top_ConfigMem.Inst_frame4_bit5.Q _0350_ sg13g2_o21ai_1
X_3618_ _1959_ _1934_ _1935_ VPWR VGND sg13g2_xnor2_1
X_6406_ Tile_X0Y1_FrameData[25] Tile_X0Y1_FrameData_O[25] VPWR VGND sg13g2_buf_1
X_6337_ Tile_X0Y1_DSP_bot.Inst_DSP_bot_switch_matrix.E2BEG0 Tile_X0Y1_E2BEG[0] VPWR
+ VGND sg13g2_buf_1
X_6268_ Tile_X0Y1_NN4END[8] Tile_X0Y0_NN4BEG[0] VPWR VGND sg13g2_buf_1
X_3549_ Tile_X0Y1_DSP_bot.Inst_DSP_bot_ConfigMem.Inst_frame8_bit7.Q VPWR _1902_ VGND
+ Tile_X0Y1_DSP_bot.Inst_DSP_bot_ConfigMem.Inst_frame8_bit6.Q _1901_ sg13g2_o21ai_1
X_6199_ Tile_X0Y0_FrameData[19] Tile_X0Y0_FrameData_O[19] VPWR VGND sg13g2_buf_1
X_5219_ Tile_X0Y0_FrameData[10] Tile_X0Y1_FrameStrobe[0] Tile_X0Y0_DSP_top.Inst_DSP_top_ConfigMem.Inst_frame0_bit10.Q
+ VPWR VGND sg13g2_dlhq_1
XFILLER_44_359 VPWR VGND sg13g2_fill_2
XFILLER_94_248 VPWR VGND sg13g2_fill_1
XFILLER_39_109 VPWR VGND sg13g2_decap_4
X_2920_ VPWR VGND _0089_ Tile_X0Y1_DSP_bot.Inst_DSP_bot_ConfigMem.Inst_frame9_bit30.Q
+ _1297_ _1294_ _1298_ _1296_ sg13g2_a221oi_1
X_2782_ VGND VPWR Tile_X0Y1_N2MID[7] Tile_X0Y0_DSP_top.Inst_DSP_top_ConfigMem.Inst_frame2_bit24.Q
+ _1164_ Tile_X0Y0_DSP_top.Inst_DSP_top_ConfigMem.Inst_frame2_bit25.Q sg13g2_a21oi_1
X_5570_ Tile_X0Y0_FrameData[11] Tile_X0Y1_FrameStrobe[11] Tile_X0Y0_DSP_top.Inst_DSP_top_ConfigMem.Inst_frame11_bit11.Q
+ VPWR VGND sg13g2_dlhq_1
X_2851_ Tile_X0Y1_DSP_bot.Inst_DSP_bot_ConfigMem.Inst_frame5_bit10.Q Tile_X0Y1_N2END[2]
+ Tile_X0Y1_E2END[2] Tile_X0Y0_S2MID[2] Tile_X0Y1_WW4END[2] Tile_X0Y1_DSP_bot.Inst_DSP_bot_ConfigMem.Inst_frame5_bit11.Q
+ _1231_ VPWR VGND sg13g2_mux4_1
X_4521_ _0278_ Tile_X0Y1_DSP_bot.Inst_DSP_bot_ConfigMem.Inst_frame1_bit11.Q _0277_
+ VPWR VGND sg13g2_nand2b_1
X_4383_ _0146_ _0145_ Tile_X0Y0_DSP_top.Inst_DSP_top_ConfigMem.Inst_frame2_bit5.Q
+ VPWR VGND sg13g2_nand2b_1
X_3334_ Tile_X0Y1_DSP_bot.Inst_DSP_bot_ConfigMem.Inst_frame3_bit24.Q _0055_ _1697_
+ _1698_ VPWR VGND sg13g2_a21o_1
X_6122_ VPWR VGND _2520_ sg13g2_tiehi
X_4452_ Tile_X0Y1_DSP_bot.Inst_DSP_bot_ConfigMem.Inst_frame2_bit12.Q Tile_X0Y1_DSP_bot.Inst_DSP_bot_switch_matrix.Q5
+ _0212_ VPWR VGND sg13g2_nor2_1
X_3403_ _1762_ _1761_ Tile_X0Y1_DSP_bot.Inst_DSP_bot_ConfigMem.Inst_frame8_bit20.Q
+ _1763_ VPWR VGND sg13g2_mux2_1
X_3196_ _1568_ Tile_X0Y0_DSP_top.Inst_DSP_top_ConfigMem.Inst_frame4_bit22.Q _1566_
+ VPWR VGND sg13g2_nand2b_1
X_5004_ VPWR VGND _0737_ Tile_X0Y1_DSP_bot.Inst_DSP_bot_ConfigMem.Inst_frame12_bit1.Q
+ _0736_ _0726_ _0739_ _0727_ sg13g2_a221oi_1
X_6053_ Tile_X0Y1_FrameData[22] Tile_X0Y1_FrameStrobe[12] Tile_X0Y1_DSP_bot.Inst_DSP_bot_ConfigMem.Inst_frame12_bit22.Q
+ VPWR VGND sg13g2_dlhq_1
X_3265_ _1632_ Tile_X0Y1_W1END[0] Tile_X0Y1_DSP_bot.Inst_DSP_bot_ConfigMem.Inst_frame1_bit28.Q
+ VPWR VGND sg13g2_nand2_1
X_5906_ Tile_X0Y1_FrameData[9] Tile_X0Y1_FrameStrobe[7] Tile_X0Y1_DSP_bot.Inst_DSP_bot_ConfigMem.Inst_frame7_bit9.Q
+ VPWR VGND sg13g2_dlhq_1
X_5837_ Tile_X0Y1_FrameData[14] Tile_X0Y1_FrameStrobe[5] Tile_X0Y1_DSP_bot.Inst_DSP_bot_ConfigMem.Inst_frame5_bit14.Q
+ VPWR VGND sg13g2_dlhq_1
XFILLER_26_359 VPWR VGND sg13g2_fill_2
X_4719_ Tile_X0Y0_DSP_top.Inst_DSP_top_ConfigMem.Inst_frame10_bit3.Q Tile_X0Y0_DSP_top.Inst_DSP_top_switch_matrix.bot2top4
+ Tile_X0Y0_DSP_top.Inst_DSP_top_switch_matrix.E2BEG3 _0465_ _0447_ Tile_X0Y0_DSP_top.Inst_DSP_top_ConfigMem.Inst_frame10_bit2.Q
+ _0467_ VPWR VGND sg13g2_mux4_1
X_5699_ Tile_X0Y1_FrameData[24] Tile_X0Y1_FrameStrobe[1] Tile_X0Y1_DSP_bot.Inst_DSP_bot_ConfigMem.Inst_frame1_bit24.Q
+ VPWR VGND sg13g2_dlhq_1
X_5768_ Tile_X0Y1_FrameData[19] Tile_X0Y1_FrameStrobe[3] Tile_X0Y1_DSP_bot.Inst_DSP_bot_ConfigMem.Inst_frame3_bit19.Q
+ VPWR VGND sg13g2_dlhq_1
XFILLER_76_237 VPWR VGND sg13g2_fill_1
XFILLER_84_270 VPWR VGND sg13g2_decap_8
X_3050_ VPWR VGND _1425_ _1390_ _1424_ _1370_ _1427_ _1372_ sg13g2_a221oi_1
X_3883_ VGND VPWR _0036_ Tile_X0Y0_DSP_top.Inst_DSP_top_ConfigMem.Inst_frame4_bit0.Q
+ _2196_ _2195_ sg13g2_a21oi_1
X_3952_ _2244_ _2245_ Tile_X0Y0_DSP_top.Inst_DSP_top_ConfigMem.Inst_frame11_bit25.Q
+ Tile_X0Y0_DSP_top.Inst_DSP_top_switch_matrix.EE4BEG3 VPWR VGND sg13g2_mux2_1
X_2903_ _1281_ _1224_ _1225_ VPWR VGND sg13g2_xnor2_1
X_5553_ Tile_X0Y0_FrameData[28] Tile_X0Y1_FrameStrobe[11] Tile_X0Y0_DSP_top.Inst_DSP_top_ConfigMem.Inst_frame11_bit28.Q
+ VPWR VGND sg13g2_dlhq_1
X_5622_ _2493_ VGND VPWR _0018_ Tile_X0Y1_DSP_bot.Inst_MULADD.ACC\[18\] clknet_3_7_0_Tile_X0Y1_UserCLK_regs
+ sg13g2_dfrbpq_1
X_2765_ _1147_ _1006_ _1145_ VPWR VGND sg13g2_xnor2_1
X_2834_ _1210_ _1209_ _1214_ VPWR VGND sg13g2_xor2_1
X_5484_ Tile_X0Y0_FrameData[1] Tile_X0Y1_FrameStrobe[8] Tile_X0Y0_DSP_top.Inst_DSP_top_ConfigMem.Inst_frame8_bit1.Q
+ VPWR VGND sg13g2_dlhq_1
X_2696_ _1081_ _0901_ _1078_ VPWR VGND sg13g2_xnor2_1
X_4504_ _0262_ _0261_ Tile_X0Y1_DSP_bot.Inst_DSP_bot_ConfigMem.Inst_frame4_bit6.Q
+ VPWR VGND sg13g2_nand2b_1
X_4366_ VPWR _0129_ Tile_X0Y0_DSP_top.Inst_DSP_top_switch_matrix.bot2top7 VGND sg13g2_inv_1
X_4435_ Tile_X0Y0_DSP_top.Inst_DSP_top_ConfigMem.Inst_frame2_bit28.Q Tile_X0Y0_S1END[0]
+ Tile_X0Y0_S2END[0] Tile_X0Y0_W1END[0] Tile_X0Y0_W1END[2] Tile_X0Y0_DSP_top.Inst_DSP_top_ConfigMem.Inst_frame2_bit29.Q
+ _0196_ VPWR VGND sg13g2_mux4_1
X_6105_ VPWR VGND _2503_ sg13g2_tiehi
X_3317_ _1683_ _1682_ _0092_ _1679_ _1678_ VPWR VGND sg13g2_a22oi_1
X_4297_ VPWR _0060_ Tile_X0Y1_DSP_bot.Inst_DSP_bot_ConfigMem.Inst_frame4_bit10.Q VGND
+ sg13g2_inv_1
XFILLER_92_19 VPWR VGND sg13g2_fill_1
X_3179_ VGND VPWR Tile_X0Y0_DSP_top.Inst_DSP_top_ConfigMem.Inst_frame8_bit13.Q _1542_
+ _1552_ Tile_X0Y0_DSP_top.Inst_DSP_top_ConfigMem.Inst_frame8_bit12.Q sg13g2_a21oi_1
X_3248_ VGND VPWR _0094_ _1612_ _1616_ _1615_ sg13g2_a21oi_1
XFILLER_14_329 VPWR VGND sg13g2_fill_1
X_6036_ Tile_X0Y1_FrameData[7] Tile_X0Y1_FrameStrobe[11] Tile_X0Y1_DSP_bot.Inst_DSP_bot_ConfigMem.Inst_frame11_bit7.Q
+ VPWR VGND sg13g2_dlhq_1
XFILLER_26_134 VPWR VGND sg13g2_fill_1
XFILLER_2_17 VPWR VGND sg13g2_decap_4
XFILLER_72_284 VPWR VGND sg13g2_fill_2
XFILLER_32_148 VPWR VGND sg13g2_decap_8
X_2550_ Tile_X0Y0_DSP_top.Inst_DSP_top_ConfigMem.Inst_frame7_bit0.Q Tile_X0Y0_S2MID[6]
+ Tile_X0Y0_DSP_top.Inst_DSP_top_ConfigMem.Inst_frame7_bit1.Q _0941_ VPWR VGND sg13g2_a21o_1
XFILLER_99_159 VPWR VGND sg13g2_fill_1
X_4220_ Tile_X0Y1_DSP_bot.Inst_DSP_bot_ConfigMem.Inst_frame9_bit19.Q Tile_X0Y1_DSP_bot.Inst_DSP_bot_switch_matrix.Q2
+ Tile_X0Y1_DSP_bot.Inst_DSP_bot_switch_matrix.Q4 Tile_X0Y1_DSP_bot.Inst_DSP_bot_switch_matrix.Q3
+ Tile_X0Y1_DSP_bot.Inst_DSP_bot_switch_matrix.Q5 Tile_X0Y1_DSP_bot.Inst_DSP_bot_ConfigMem.Inst_frame9_bit18.Q
+ _2459_ VPWR VGND sg13g2_mux4_1
X_4151_ Tile_X0Y1_DSP_bot.Inst_DSP_bot_ConfigMem.Inst_frame11_bit26.Q Tile_X0Y1_E1END[2]
+ Tile_X0Y1_W1END[2] Tile_X0Y1_DSP_bot.Inst_DSP_bot_switch_matrix.Q0 Tile_X0Y1_DSP_bot.Inst_DSP_bot_switch_matrix.Q1
+ Tile_X0Y1_DSP_bot.Inst_DSP_bot_ConfigMem.Inst_frame11_bit27.Q _2400_ VPWR VGND sg13g2_mux4_1
X_3102_ VGND VPWR Tile_X0Y0_DSP_top.Inst_DSP_top_ConfigMem.Inst_frame1_bit21.Q _1477_
+ _1479_ _1478_ sg13g2_a21oi_1
XFILLER_63_262 VPWR VGND sg13g2_fill_2
X_3033_ _1410_ _1404_ _1409_ VPWR VGND sg13g2_nand2_1
X_4082_ Tile_X0Y1_DSP_bot.Inst_DSP_bot_ConfigMem.Inst_frame10_bit10.Q Tile_X0Y0_S2MID[0]
+ Tile_X0Y0_S4END[7] Tile_X0Y1_W6END[1] Tile_X0Y1_DSP_bot.Inst_DSP_bot_switch_matrix.Q2
+ Tile_X0Y1_DSP_bot.Inst_DSP_bot_ConfigMem.Inst_frame10_bit11.Q Tile_X0Y1_DSP_bot.Inst_DSP_bot_switch_matrix.S4BEG2
+ VPWR VGND sg13g2_mux4_1
XFILLER_23_104 VPWR VGND sg13g2_decap_4
X_3935_ VGND VPWR Tile_X0Y0_DSP_top.Inst_DSP_top_ConfigMem.Inst_frame11_bit17.Q _0679_
+ _2231_ _2230_ sg13g2_a21oi_1
X_3866_ Tile_X0Y0_DSP_top.Inst_DSP_top_ConfigMem.Inst_frame11_bit6.Q Tile_X0Y0_DSP_top.Inst_DSP_top_switch_matrix.bot2top3
+ _0465_ Tile_X0Y0_DSP_top.Inst_DSP_top_switch_matrix.JN2BEG3 _0447_ Tile_X0Y0_DSP_top.Inst_DSP_top_ConfigMem.Inst_frame11_bit7.Q
+ Tile_X0Y0_DSP_top.Inst_DSP_top_switch_matrix.E1BEG0 VPWR VGND sg13g2_mux4_1
X_4984_ _0717_ Tile_X0Y0_DSP_top.Inst_DSP_top_ConfigMem.Inst_frame2_bit1.Q _0720_
+ _0721_ VPWR VGND sg13g2_a21o_1
XFILLER_63_295 VPWR VGND sg13g2_fill_2
XFILLER_23_137 VPWR VGND sg13g2_decap_4
X_5605_ _2490_ VGND VPWR _0001_ Tile_X0Y1_DSP_bot.Inst_MULADD.ACC\[1\] clknet_3_3_0_Tile_X0Y1_UserCLK_regs
+ sg13g2_dfrbpq_1
X_3797_ VPWR VGND _2124_ Tile_X0Y0_DSP_top.Inst_DSP_top_ConfigMem.Inst_frame8_bit31.Q
+ _2123_ _2110_ _2125_ _2111_ sg13g2_a221oi_1
X_5536_ Tile_X0Y0_FrameData[13] Tile_X0Y1_FrameStrobe[10] Tile_X0Y0_DSP_top.Inst_DSP_top_ConfigMem.Inst_frame10_bit13.Q
+ VPWR VGND sg13g2_dlhq_1
X_5467_ Tile_X0Y0_FrameData[18] Tile_X0Y1_FrameStrobe[8] Tile_X0Y0_DSP_top.Inst_DSP_top_ConfigMem.Inst_frame8_bit18.Q
+ VPWR VGND sg13g2_dlhq_1
X_2748_ _1130_ _0991_ _0533_ VPWR VGND sg13g2_nand2b_1
X_2817_ _1197_ _0682_ _1127_ VPWR VGND sg13g2_nand2_1
X_2679_ Tile_X0Y1_DSP_bot.Inst_DSP_bot_ConfigMem.Inst_frame9_bit25.Q VPWR _1065_ VGND
+ Tile_X0Y1_DSP_bot.Inst_DSP_bot_ConfigMem.Inst_frame0_bit3.Q _1063_ sg13g2_o21ai_1
X_4418_ Tile_X0Y1_DSP_bot.Inst_DSP_bot_ConfigMem.Inst_frame1_bit12.Q Tile_X0Y1_N1END[2]
+ Tile_X0Y1_N2END[4] Tile_X0Y1_E2END[4] Tile_X0Y1_E6END[0] Tile_X0Y1_DSP_bot.Inst_DSP_bot_ConfigMem.Inst_frame1_bit13.Q
+ _0179_ VPWR VGND sg13g2_mux4_1
X_4349_ VPWR _0112_ Tile_X0Y1_DSP_bot.Inst_MULADD.ACC\[18\] VGND sg13g2_inv_1
X_5398_ Tile_X0Y0_FrameData[23] Tile_X0Y1_FrameStrobe[6] Tile_X0Y0_DSP_top.Inst_DSP_top_ConfigMem.Inst_frame6_bit23.Q
+ VPWR VGND sg13g2_dlhq_1
X_6019_ Tile_X0Y1_FrameData[24] Tile_X0Y1_FrameStrobe[11] Tile_X0Y1_DSP_bot.Inst_DSP_bot_ConfigMem.Inst_frame11_bit24.Q
+ VPWR VGND sg13g2_dlhq_1
XFILLER_22_181 VPWR VGND sg13g2_fill_1
XFILLER_7_0 VPWR VGND sg13g2_fill_2
XFILLER_93_40 VPWR VGND sg13g2_fill_1
X_3720_ VGND VPWR _2052_ _2051_ _2000_ sg13g2_or2_1
X_3651_ VGND VPWR Tile_X0Y0_DSP_top.Inst_DSP_top_ConfigMem.Inst_frame0_bit27.Q _1985_
+ _1989_ _1988_ sg13g2_a21oi_1
X_2602_ _0983_ VPWR Tile_X0Y0_DSP_top.Inst_DSP_top_switch_matrix.inst_cus_mux41_buf_top2bot1.X
+ VGND _0988_ _0990_ sg13g2_o21ai_1
X_5321_ Tile_X0Y0_FrameData[4] Tile_X0Y1_FrameStrobe[3] Tile_X0Y0_DSP_top.Inst_DSP_top_ConfigMem.Inst_frame3_bit4.Q
+ VPWR VGND sg13g2_dlhq_1
X_3582_ VGND VPWR _1587_ _1933_ _1934_ _1586_ sg13g2_a21oi_1
XFILLER_9_196 VPWR VGND sg13g2_fill_1
X_2533_ Tile_X0Y1_DSP_bot.Inst_DSP_bot_switch_matrix.Q3 Tile_X0Y1_DSP_bot.Inst_DSP_bot_switch_matrix.Q4
+ Tile_X0Y1_DSP_bot.Inst_DSP_bot_ConfigMem.Inst_frame4_bit8.Q _0926_ VPWR VGND sg13g2_mux2_1
X_6370_ Tile_X0Y1_EE4END[9] Tile_X0Y1_EE4BEG[5] VPWR VGND sg13g2_buf_1
X_5252_ Tile_X0Y0_FrameData[9] Tile_X0Y1_FrameStrobe[1] Tile_X0Y0_DSP_top.Inst_DSP_top_ConfigMem.Inst_frame1_bit9.Q
+ VPWR VGND sg13g2_dlhq_1
X_5183_ VGND VPWR Tile_X0Y0_DSP_top.Inst_DSP_top_ConfigMem.Inst_frame3_bit18.Q _0907_
+ _0909_ _0908_ sg13g2_a21oi_1
XFILLER_68_310 VPWR VGND sg13g2_fill_1
X_4134_ Tile_X0Y1_DSP_bot.Inst_DSP_bot_ConfigMem.Inst_frame11_bit17.Q Tile_X0Y1_DSP_bot.Inst_DSP_bot_switch_matrix.Q8
+ _1793_ _1886_ _1290_ Tile_X0Y1_DSP_bot.Inst_DSP_bot_ConfigMem.Inst_frame11_bit16.Q
+ _2386_ VPWR VGND sg13g2_mux4_1
X_4203_ Tile_X0Y1_DSP_bot.Inst_DSP_bot_ConfigMem.Inst_frame9_bit15.Q Tile_X0Y1_DSP_bot.Inst_DSP_bot_switch_matrix.Q2
+ Tile_X0Y1_DSP_bot.Inst_DSP_bot_switch_matrix.Q4 Tile_X0Y1_DSP_bot.Inst_DSP_bot_switch_matrix.Q3
+ Tile_X0Y1_DSP_bot.Inst_DSP_bot_switch_matrix.Q5 Tile_X0Y1_DSP_bot.Inst_DSP_bot_ConfigMem.Inst_frame9_bit14.Q
+ _2443_ VPWR VGND sg13g2_mux4_1
X_3016_ _0900_ _1308_ _1393_ VPWR VGND sg13g2_nor2_1
XFILLER_36_284 VPWR VGND sg13g2_fill_1
X_4065_ Tile_X0Y1_DSP_bot.Inst_DSP_bot_ConfigMem.Inst_frame3_bit2.Q VPWR _2336_ VGND
+ Tile_X0Y1_DSP_bot.Inst_DSP_bot_ConfigMem.Inst_frame3_bit1.Q _2334_ sg13g2_o21ai_1
X_3849_ VGND VPWR Tile_X0Y0_DSP_top.Inst_DSP_top_ConfigMem.Inst_frame1_bit1.Q _2167_
+ _2170_ Tile_X0Y0_DSP_top.Inst_DSP_top_ConfigMem.Inst_frame1_bit2.Q sg13g2_a21oi_1
X_3918_ _2217_ Tile_X0Y0_DSP_top.Inst_DSP_top_ConfigMem.Inst_frame11_bit1.Q _2216_
+ VPWR VGND sg13g2_nand2_1
X_4898_ Tile_X0Y1_DSP_bot.Inst_DSP_bot_ConfigMem.Inst_frame4_bit17.Q VPWR _0638_ VGND
+ Tile_X0Y1_DSP_bot.Inst_DSP_bot_ConfigMem.Inst_frame4_bit16.Q Tile_X0Y1_DSP_bot.Inst_DSP_bot_switch_matrix.Q7
+ sg13g2_o21ai_1
X_4967_ VPWR _0704_ _0703_ VGND sg13g2_inv_1
XFILLER_105_212 VPWR VGND sg13g2_fill_1
X_5519_ Tile_X0Y0_FrameData[30] Tile_X0Y1_FrameStrobe[10] Tile_X0Y0_DSP_top.Inst_DSP_top_ConfigMem.Inst_frame10_bit30.Q
+ VPWR VGND sg13g2_dlhq_1
X_6499_ Tile_X0Y1_WW4END[6] Tile_X0Y1_WW4BEG[2] VPWR VGND sg13g2_buf_1
XFILLER_74_313 VPWR VGND sg13g2_fill_1
XFILLER_19_218 VPWR VGND sg13g2_fill_2
XFILLER_103_94 VPWR VGND sg13g2_fill_2
XFILLER_63_43 VPWR VGND sg13g2_fill_2
XFILLER_69_107 VPWR VGND sg13g2_fill_2
XFILLER_77_195 VPWR VGND sg13g2_fill_1
X_4821_ Tile_X0Y0_DSP_top.Inst_DSP_top_ConfigMem.Inst_frame1_bit13.Q Tile_X0Y0_S2END[4]
+ Tile_X0Y0_W2END[4] Tile_X0Y0_S4END[0] Tile_X0Y0_W6END[0] Tile_X0Y0_DSP_top.Inst_DSP_top_ConfigMem.Inst_frame1_bit12.Q
+ _0564_ VPWR VGND sg13g2_mux4_1
X_5870_ Tile_X0Y1_FrameData[13] Tile_X0Y1_FrameStrobe[6] Tile_X0Y1_DSP_bot.Inst_DSP_bot_ConfigMem.Inst_frame6_bit13.Q
+ VPWR VGND sg13g2_dlhq_1
X_4752_ VGND VPWR _0498_ Tile_X0Y0_DSP_top.Inst_DSP_top_switch_matrix.bot2top0 Tile_X0Y0_DSP_top.Inst_DSP_top_ConfigMem.Inst_frame4_bit8.Q
+ sg13g2_or2_1
X_3634_ Tile_X0Y0_DSP_top.Inst_DSP_top_ConfigMem.Inst_frame3_bit25.Q VPWR _1973_ VGND
+ _0052_ Tile_X0Y0_DSP_top.Inst_DSP_top_ConfigMem.Inst_frame3_bit24.Q sg13g2_o21ai_1
X_3703_ _2036_ VPWR _2037_ VGND Tile_X0Y0_DSP_top.Inst_DSP_top_ConfigMem.Inst_frame1_bit24.Q
+ _0293_ sg13g2_o21ai_1
X_4683_ Tile_X0Y0_DSP_top.Inst_DSP_top_ConfigMem.Inst_frame6_bit5.Q Tile_X0Y0_DSP_top.Inst_DSP_top_switch_matrix.N2BEGb5
+ Tile_X0Y0_S2MID[5] Tile_X0Y0_E2MID[5] Tile_X0Y0_W2MID[5] Tile_X0Y0_DSP_top.Inst_DSP_top_ConfigMem.Inst_frame6_bit4.Q
+ _0433_ VPWR VGND sg13g2_mux4_1
X_6422_ Tile_X0Y1_DSP_bot.Inst_DSP_bot_switch_matrix.JS2BEG5 Tile_X0Y1_S2BEG[5] VPWR
+ VGND sg13g2_buf_1
X_5304_ Tile_X0Y0_FrameData[21] Tile_X0Y1_FrameStrobe[3] Tile_X0Y0_DSP_top.Inst_DSP_top_ConfigMem.Inst_frame3_bit21.Q
+ VPWR VGND sg13g2_dlhq_1
X_5235_ Tile_X0Y0_FrameData[26] Tile_X0Y1_FrameStrobe[1] Tile_X0Y0_DSP_top.Inst_DSP_top_ConfigMem.Inst_frame1_bit26.Q
+ VPWR VGND sg13g2_dlhq_1
X_6284_ clknet_1_0__leaf_Tile_X0Y1_UserCLK Tile_X0Y0_UserCLKo VPWR VGND sg13g2_buf_1
X_3496_ Tile_X0Y1_DSP_bot.Inst_DSP_bot_ConfigMem.Inst_frame8_bit12.Q _1848_ _1851_
+ _1852_ VPWR VGND sg13g2_nor3_1
X_6353_ Tile_X0Y1_E6END[2] Tile_X0Y1_E6BEG[0] VPWR VGND sg13g2_buf_1
X_3565_ _1917_ _1872_ _1874_ VPWR VGND sg13g2_nand2_1
X_5097_ _0827_ VPWR _0828_ VGND _0035_ Tile_X0Y0_DSP_top.Inst_DSP_top_ConfigMem.Inst_frame2_bit8.Q
+ sg13g2_o21ai_1
X_4048_ VPWR _2330_ _2329_ VGND sg13g2_inv_1
XFILLER_56_324 VPWR VGND sg13g2_fill_1
X_4117_ _2372_ _2371_ Tile_X0Y1_DSP_bot.Inst_DSP_bot_ConfigMem.Inst_frame12_bit30.Q
+ Tile_X0Y0_DSP_top.NN4BEG_outbuf_10.A VPWR VGND sg13g2_mux2_1
X_5166_ _0893_ Tile_X0Y1_DSP_bot.Inst_DSP_bot_ConfigMem.Inst_frame9_bit26.Q _0892_
+ VPWR VGND sg13g2_nand2_1
X_5999_ Tile_X0Y1_FrameData[12] Tile_X0Y1_FrameStrobe[10] Tile_X0Y1_DSP_bot.Inst_DSP_bot_ConfigMem.Inst_frame10_bit12.Q
+ VPWR VGND sg13g2_dlhq_1
XFILLER_101_270 VPWR VGND sg13g2_fill_1
XFILLER_74_143 VPWR VGND sg13g2_fill_1
X_3350_ Tile_X0Y1_DSP_bot.Inst_DSP_bot_ConfigMem.Inst_frame8_bit24.Q Tile_X0Y1_DSP_bot.Inst_DSP_bot_switch_matrix.E2BEG6
+ _1713_ VPWR VGND sg13g2_nor2_1
X_3281_ VGND VPWR Tile_X0Y1_DSP_bot.Inst_DSP_bot_ConfigMem.Inst_frame1_bit28.Q Tile_X0Y1_DSP_bot.Inst_DSP_bot_switch_matrix.Q5
+ _1648_ _1647_ sg13g2_a21oi_1
X_5020_ _0754_ VPWR _0755_ VGND Tile_X0Y1_N2MID[1] Tile_X0Y1_DSP_bot.Inst_DSP_bot_ConfigMem.Inst_frame6_bit6.Q
+ sg13g2_o21ai_1
XFILLER_110_18 VPWR VGND sg13g2_fill_1
X_5922_ Tile_X0Y1_FrameData[25] Tile_X0Y1_FrameStrobe[8] Tile_X0Y1_DSP_bot.Inst_DSP_bot_ConfigMem.Inst_frame8_bit25.Q
+ VPWR VGND sg13g2_dlhq_1
X_4804_ Tile_X0Y1_DSP_bot.Inst_DSP_bot_ConfigMem.Inst_frame4_bit2.Q VPWR _0548_ VGND
+ Tile_X0Y1_DSP_bot.Inst_DSP_bot_ConfigMem.Inst_frame4_bit1.Q _0547_ sg13g2_o21ai_1
XFILLER_0_72 VPWR VGND sg13g2_fill_1
X_5784_ Tile_X0Y1_FrameData[3] Tile_X0Y1_FrameStrobe[3] Tile_X0Y1_DSP_bot.Inst_DSP_bot_ConfigMem.Inst_frame3_bit3.Q
+ VPWR VGND sg13g2_dlhq_1
X_5853_ Tile_X0Y1_FrameData[30] Tile_X0Y1_FrameStrobe[6] Tile_X0Y1_DSP_bot.Inst_DSP_bot_ConfigMem.Inst_frame6_bit30.Q
+ VPWR VGND sg13g2_dlhq_1
X_4597_ Tile_X0Y0_W2END[2] Tile_X0Y0_W6END[0] Tile_X0Y0_DSP_top.Inst_DSP_top_ConfigMem.Inst_frame4_bit4.Q
+ _0351_ VPWR VGND sg13g2_mux2_1
X_4666_ VGND VPWR Tile_X0Y0_E2END[2] Tile_X0Y0_DSP_top.Inst_DSP_top_ConfigMem.Inst_frame3_bit4.Q
+ _0418_ _0417_ sg13g2_a21oi_1
X_3617_ _1958_ VPWR Tile_X0Y0_DSP_top.Inst_DSP_top_switch_matrix.bot2top0 VGND Tile_X0Y1_DSP_bot.Inst_DSP_bot_ConfigMem.Inst_frame12_bit5.Q
+ _1957_ sg13g2_o21ai_1
X_6405_ Tile_X0Y1_FrameData[24] Tile_X0Y1_FrameData_O[24] VPWR VGND sg13g2_buf_1
X_2996_ _1370_ _1372_ _1373_ VPWR VGND sg13g2_nor2_1
X_4735_ _0482_ VPWR _0483_ VGND Tile_X0Y1_DSP_bot.Inst_DSP_bot_ConfigMem.Inst_frame4_bit28.Q
+ Tile_X0Y1_DSP_bot.Inst_DSP_bot_switch_matrix.Q0 sg13g2_o21ai_1
X_6267_ Tile_X0Y0_DSP_top.Inst_DSP_top_switch_matrix.N4BEG3 Tile_X0Y0_N4BEG[15] VPWR
+ VGND sg13g2_buf_1
X_6198_ Tile_X0Y0_FrameData[18] Tile_X0Y0_FrameData_O[18] VPWR VGND sg13g2_buf_1
XFILLER_95_19 VPWR VGND sg13g2_fill_2
XFILLER_88_246 VPWR VGND sg13g2_fill_1
X_5218_ Tile_X0Y0_FrameData[11] Tile_X0Y1_FrameStrobe[0] Tile_X0Y0_DSP_top.Inst_DSP_top_ConfigMem.Inst_frame0_bit11.Q
+ VPWR VGND sg13g2_dlhq_1
Xclkbuf_3_7_0_Tile_X0Y1_UserCLK_regs clknet_0_Tile_X0Y1_UserCLK_regs clknet_3_7_0_Tile_X0Y1_UserCLK_regs
+ VPWR VGND sg13g2_buf_8
X_3479_ _1810_ VPWR _1835_ VGND Tile_X0Y1_DSP_bot.Inst_DSP_bot_ConfigMem.Inst_frame12_bit3.Q
+ _1834_ sg13g2_o21ai_1
X_6336_ Tile_X0Y1_DSP_bot.Inst_DSP_bot_switch_matrix.E1BEG3 Tile_X0Y1_E1BEG[3] VPWR
+ VGND sg13g2_buf_1
X_3548_ Tile_X0Y1_DSP_bot.Inst_DSP_bot_ConfigMem.Inst_frame5_bit16.Q Tile_X0Y1_N2END[7]
+ Tile_X0Y1_EE4END[2] Tile_X0Y0_S2MID[7] Tile_X0Y1_W2END[7] Tile_X0Y1_DSP_bot.Inst_DSP_bot_ConfigMem.Inst_frame5_bit17.Q
+ _1901_ VPWR VGND sg13g2_mux4_1
XFILLER_56_132 VPWR VGND sg13g2_fill_1
X_5149_ _0876_ VPWR _0877_ VGND Tile_X0Y1_DSP_bot.Inst_DSP_bot_ConfigMem.Inst_frame9_bit26.Q
+ _0874_ sg13g2_o21ai_1
XFILLER_109_93 VPWR VGND sg13g2_fill_1
XFILLER_107_0 VPWR VGND sg13g2_decap_8
XFILLER_94_227 VPWR VGND sg13g2_decap_4
X_2850_ _1222_ VPWR _1230_ VGND _1219_ _1223_ sg13g2_o21ai_1
XFILLER_43_360 VPWR VGND sg13g2_fill_1
X_2781_ VGND VPWR Tile_X0Y0_DSP_top.Inst_DSP_top_ConfigMem.Inst_frame2_bit26.Q _1161_
+ _1163_ _1162_ sg13g2_a21oi_1
X_4520_ _0275_ _0276_ Tile_X0Y1_DSP_bot.Inst_DSP_bot_ConfigMem.Inst_frame1_bit10.Q
+ _0277_ VPWR VGND sg13g2_mux2_1
X_4451_ _0211_ _0210_ Tile_X0Y1_DSP_bot.Inst_DSP_bot_ConfigMem.Inst_frame2_bit14.Q
+ VPWR VGND sg13g2_nand2b_1
X_4382_ Tile_X0Y0_S4END[2] Tile_X0Y0_SS4END[2] Tile_X0Y0_DSP_top.Inst_DSP_top_ConfigMem.Inst_frame2_bit4.Q
+ _0145_ VPWR VGND sg13g2_mux2_1
X_3333_ Tile_X0Y1_DSP_bot.Inst_DSP_bot_ConfigMem.Inst_frame3_bit25.Q VPWR _1697_ VGND
+ Tile_X0Y0_S2MID[7] Tile_X0Y1_DSP_bot.Inst_DSP_bot_ConfigMem.Inst_frame3_bit24.Q
+ sg13g2_o21ai_1
X_3264_ VGND VPWR Tile_X0Y1_DSP_bot.Inst_DSP_bot_ConfigMem.Inst_frame1_bit28.Q _0422_
+ _1631_ _1630_ sg13g2_a21oi_1
X_6052_ Tile_X0Y1_FrameData[23] Tile_X0Y1_FrameStrobe[12] Tile_X0Y1_DSP_bot.Inst_DSP_bot_ConfigMem.Inst_frame12_bit23.Q
+ VPWR VGND sg13g2_dlhq_1
X_6121_ VPWR VGND _2519_ sg13g2_tiehi
X_3402_ Tile_X0Y1_DSP_bot.Inst_DSP_bot_ConfigMem.Inst_frame5_bit30.Q Tile_X0Y1_N2END[1]
+ Tile_X0Y1_EE4END[3] Tile_X0Y0_S2MID[1] Tile_X0Y1_W2END[1] Tile_X0Y1_DSP_bot.Inst_DSP_bot_ConfigMem.Inst_frame5_bit31.Q
+ _1762_ VPWR VGND sg13g2_mux4_1
X_3195_ Tile_X0Y0_DSP_top.Inst_DSP_top_ConfigMem.Inst_frame4_bit20.Q Tile_X0Y0_DSP_top.Inst_DSP_top_switch_matrix.bot2top0
+ Tile_X0Y0_DSP_top.Inst_DSP_top_switch_matrix.bot2top1 Tile_X0Y0_DSP_top.Inst_DSP_top_switch_matrix.bot2top2
+ Tile_X0Y0_DSP_top.Inst_DSP_top_switch_matrix.bot2top3 Tile_X0Y0_DSP_top.Inst_DSP_top_ConfigMem.Inst_frame4_bit21.Q
+ _1567_ VPWR VGND sg13g2_mux4_1
X_5003_ VPWR Tile_X0Y1_DSP_bot.B3 _0738_ VGND sg13g2_inv_1
XFILLER_38_154 VPWR VGND sg13g2_fill_2
X_2979_ VGND VPWR _0741_ _1076_ _1356_ _1353_ sg13g2_a21oi_1
X_5905_ Tile_X0Y1_FrameData[10] Tile_X0Y1_FrameStrobe[7] Tile_X0Y1_DSP_bot.Inst_DSP_bot_ConfigMem.Inst_frame7_bit10.Q
+ VPWR VGND sg13g2_dlhq_1
X_5767_ Tile_X0Y1_FrameData[20] Tile_X0Y1_FrameStrobe[3] Tile_X0Y1_DSP_bot.Inst_DSP_bot_ConfigMem.Inst_frame3_bit20.Q
+ VPWR VGND sg13g2_dlhq_1
XFILLER_41_319 VPWR VGND sg13g2_fill_1
X_5836_ Tile_X0Y1_FrameData[15] Tile_X0Y1_FrameStrobe[5] Tile_X0Y1_DSP_bot.Inst_DSP_bot_ConfigMem.Inst_frame5_bit15.Q
+ VPWR VGND sg13g2_dlhq_1
X_4649_ VGND VPWR Tile_X0Y0_DSP_top.Inst_DSP_top_ConfigMem.Inst_frame1_bit17.Q _0400_
+ _0401_ Tile_X0Y0_DSP_top.Inst_DSP_top_ConfigMem.Inst_frame1_bit18.Q sg13g2_a21oi_1
X_4718_ VPWR _0466_ _0465_ VGND sg13g2_inv_1
X_5698_ Tile_X0Y1_FrameData[25] Tile_X0Y1_FrameStrobe[1] Tile_X0Y1_DSP_bot.Inst_DSP_bot_ConfigMem.Inst_frame1_bit25.Q
+ VPWR VGND sg13g2_dlhq_1
X_6319_ Tile_X0Y0_WW4END[6] Tile_X0Y0_WW4BEG[2] VPWR VGND sg13g2_buf_1
XFILLER_39_34 VPWR VGND sg13g2_fill_2
XFILLER_25_360 VPWR VGND sg13g2_fill_1
X_3882_ Tile_X0Y0_DSP_top.Inst_DSP_top_ConfigMem.Inst_frame4_bit1.Q VPWR _2195_ VGND
+ Tile_X0Y0_W2END[1] Tile_X0Y0_DSP_top.Inst_DSP_top_ConfigMem.Inst_frame4_bit0.Q sg13g2_o21ai_1
X_3951_ Tile_X0Y0_DSP_top.Inst_DSP_top_ConfigMem.Inst_frame11_bit23.Q Tile_X0Y0_DSP_top.Inst_DSP_top_switch_matrix.bot2top9
+ _1510_ _2015_ _0964_ Tile_X0Y0_DSP_top.Inst_DSP_top_ConfigMem.Inst_frame11_bit24.Q
+ _2245_ VPWR VGND sg13g2_mux4_1
X_5621_ _2474_ VGND VPWR _0017_ Tile_X0Y1_DSP_bot.Inst_MULADD.ACC\[17\] clknet_3_6_0_Tile_X0Y1_UserCLK_regs
+ sg13g2_dfrbpq_1
X_2833_ _1213_ _1212_ _1211_ VPWR VGND sg13g2_nand2b_1
X_2902_ _1280_ _1273_ _1279_ VPWR VGND sg13g2_nand2_1
XFILLER_35_168 VPWR VGND sg13g2_fill_2
XFILLER_31_330 VPWR VGND sg13g2_fill_2
XFILLER_104_118 VPWR VGND sg13g2_decap_8
X_5552_ Tile_X0Y0_FrameData[29] Tile_X0Y1_FrameStrobe[11] Tile_X0Y0_DSP_top.Inst_DSP_top_ConfigMem.Inst_frame11_bit29.Q
+ VPWR VGND sg13g2_dlhq_1
X_4434_ VGND VPWR Tile_X0Y0_DSP_top.Inst_DSP_top_ConfigMem.Inst_frame2_bit29.Q _0194_
+ _0195_ Tile_X0Y0_DSP_top.Inst_DSP_top_ConfigMem.Inst_frame2_bit30.Q sg13g2_a21oi_1
X_5483_ Tile_X0Y0_FrameData[2] Tile_X0Y1_FrameStrobe[8] Tile_X0Y0_DSP_top.Inst_DSP_top_ConfigMem.Inst_frame8_bit2.Q
+ VPWR VGND sg13g2_dlhq_1
X_2764_ _1146_ _1006_ _1145_ VPWR VGND sg13g2_nand2_1
X_2695_ _1080_ _0786_ _0939_ VPWR VGND sg13g2_nand2_1
X_4503_ Tile_X0Y1_DSP_bot.Inst_DSP_bot_ConfigMem.Inst_frame4_bit4.Q Tile_X0Y1_DSP_bot.Inst_DSP_bot_switch_matrix.Q0
+ Tile_X0Y1_DSP_bot.Inst_DSP_bot_switch_matrix.Q2 Tile_X0Y1_DSP_bot.Inst_DSP_bot_switch_matrix.Q3
+ Tile_X0Y1_DSP_bot.Inst_DSP_bot_switch_matrix.Q4 Tile_X0Y1_DSP_bot.Inst_DSP_bot_ConfigMem.Inst_frame4_bit5.Q
+ _0261_ VPWR VGND sg13g2_mux4_1
X_4296_ VPWR _0059_ Tile_X0Y0_DSP_top.Inst_DSP_top_ConfigMem.Inst_frame4_bit18.Q VGND
+ sg13g2_inv_1
X_6104_ VPWR VGND _2502_ sg13g2_tiehi
XFILLER_58_249 VPWR VGND sg13g2_fill_2
X_3247_ Tile_X0Y1_DSP_bot.Inst_DSP_bot_ConfigMem.Inst_frame1_bit22.Q VPWR _1615_ VGND
+ _1613_ _1614_ sg13g2_o21ai_1
X_3316_ _1680_ _1681_ Tile_X0Y1_DSP_bot.Inst_DSP_bot_ConfigMem.Inst_frame2_bit22.Q
+ _1682_ VPWR VGND sg13g2_mux2_1
X_4365_ VPWR _0128_ Tile_X0Y1_DSP_bot.Inst_DSP_bot_switch_matrix.Q1 VGND sg13g2_inv_1
X_6035_ Tile_X0Y1_FrameData[8] Tile_X0Y1_FrameStrobe[11] Tile_X0Y1_DSP_bot.Inst_DSP_bot_ConfigMem.Inst_frame11_bit8.Q
+ VPWR VGND sg13g2_dlhq_1
X_3178_ _1548_ VPWR _1551_ VGND Tile_X0Y0_DSP_top.Inst_DSP_top_ConfigMem.Inst_frame7_bit19.Q
+ _1550_ sg13g2_o21ai_1
XFILLER_81_285 VPWR VGND sg13g2_fill_2
XFILLER_26_179 VPWR VGND sg13g2_fill_2
X_5819_ Tile_X0Y1_FrameData[0] Tile_X0Y1_FrameStrobe[4] Tile_X0Y1_DSP_bot.Inst_DSP_bot_ConfigMem.Inst_frame4_bit0.Q
+ VPWR VGND sg13g2_dlhq_1
XFILLER_106_50 VPWR VGND sg13g2_fill_1
X_3101_ Tile_X0Y0_DSP_top.Inst_DSP_top_ConfigMem.Inst_frame1_bit22.Q VPWR _1478_ VGND
+ Tile_X0Y0_DSP_top.Inst_DSP_top_ConfigMem.Inst_frame1_bit21.Q _1475_ sg13g2_o21ai_1
X_4150_ Tile_X0Y1_DSP_bot.Inst_DSP_bot_ConfigMem.Inst_frame11_bit24.Q _2398_ _2399_
+ _2397_ _2396_ Tile_X0Y1_DSP_bot.Inst_DSP_bot_ConfigMem.Inst_frame11_bit25.Q Tile_X0Y1_DSP_bot.Inst_DSP_bot_switch_matrix.E6BEG0
+ VPWR VGND sg13g2_mux4_1
X_4081_ Tile_X0Y1_DSP_bot.Inst_DSP_bot_ConfigMem.Inst_frame10_bit8.Q Tile_X0Y1_E6END[0]
+ Tile_X0Y0_S2MID[3] Tile_X0Y0_S4END[6] Tile_X0Y1_DSP_bot.Inst_DSP_bot_switch_matrix.Q1
+ Tile_X0Y1_DSP_bot.Inst_DSP_bot_ConfigMem.Inst_frame10_bit9.Q Tile_X0Y1_DSP_bot.Inst_DSP_bot_switch_matrix.S4BEG1
+ VPWR VGND sg13g2_mux4_1
X_4983_ Tile_X0Y0_DSP_top.Inst_DSP_top_ConfigMem.Inst_frame2_bit2.Q VPWR _0720_ VGND
+ Tile_X0Y0_DSP_top.Inst_DSP_top_ConfigMem.Inst_frame2_bit1.Q _0719_ sg13g2_o21ai_1
X_3032_ _1377_ _1408_ _1409_ VPWR VGND sg13g2_nor2_1
X_3796_ VGND VPWR _0116_ Tile_X0Y0_DSP_top.Inst_DSP_top_switch_matrix.E2BEG5 _2124_
+ _0117_ sg13g2_a21oi_1
X_3934_ Tile_X0Y0_DSP_top.Inst_DSP_top_ConfigMem.Inst_frame11_bit17.Q _0129_ _2230_
+ VPWR VGND sg13g2_nor2_1
X_3865_ Tile_X0Y0_DSP_top.Inst_DSP_top_ConfigMem.Inst_frame12_bit25.Q Tile_X0Y1_N2MID[1]
+ Tile_X0Y0_W6END[0] Tile_X0Y1_N4END[4] Tile_X0Y0_DSP_top.Inst_DSP_top_switch_matrix.bot2top7
+ Tile_X0Y0_DSP_top.Inst_DSP_top_ConfigMem.Inst_frame12_bit24.Q Tile_X0Y0_DSP_top.Inst_DSP_top_switch_matrix.N4BEG3
+ VPWR VGND sg13g2_mux4_1
X_2816_ _1196_ _1193_ _1194_ VPWR VGND sg13g2_xnor2_1
X_5604_ _2494_ VGND VPWR _0000_ Tile_X0Y1_DSP_bot.Inst_MULADD.ACC\[0\] clknet_3_2_0_Tile_X0Y1_UserCLK_regs
+ sg13g2_dfrbpq_1
X_5466_ Tile_X0Y0_FrameData[19] Tile_X0Y1_FrameStrobe[8] Tile_X0Y0_DSP_top.Inst_DSP_top_ConfigMem.Inst_frame8_bit19.Q
+ VPWR VGND sg13g2_dlhq_1
X_5397_ Tile_X0Y0_FrameData[24] Tile_X0Y1_FrameStrobe[6] Tile_X0Y0_DSP_top.Inst_DSP_top_ConfigMem.Inst_frame6_bit24.Q
+ VPWR VGND sg13g2_dlhq_1
X_5535_ Tile_X0Y0_FrameData[14] Tile_X0Y1_FrameStrobe[10] Tile_X0Y0_DSP_top.Inst_DSP_top_ConfigMem.Inst_frame10_bit14.Q
+ VPWR VGND sg13g2_dlhq_1
X_2747_ _0742_ _0992_ _1129_ VPWR VGND sg13g2_nor2_1
X_2678_ Tile_X0Y1_DSP_bot.Inst_DSP_bot_ConfigMem.Inst_frame5_bit3.Q Tile_X0Y1_NN4END[0]
+ Tile_X0Y0_S2MID[2] Tile_X0Y1_E2END[2] Tile_X0Y1_W2END[2] Tile_X0Y1_DSP_bot.Inst_DSP_bot_ConfigMem.Inst_frame5_bit2.Q
+ _1064_ VPWR VGND sg13g2_mux4_1
X_4417_ _0173_ _0177_ Tile_X0Y1_DSP_bot.Inst_DSP_bot_ConfigMem.Inst_frame1_bit15.Q
+ _0178_ VPWR VGND sg13g2_nand3_1
X_4348_ VPWR _0111_ Tile_X0Y0_DSP_top.Inst_DSP_top_ConfigMem.Inst_frame12_bit29.Q
+ VGND sg13g2_inv_1
X_6018_ Tile_X0Y1_FrameData[25] Tile_X0Y1_FrameStrobe[11] Tile_X0Y1_DSP_bot.Inst_DSP_bot_ConfigMem.Inst_frame11_bit25.Q
+ VPWR VGND sg13g2_dlhq_1
X_4279_ VPWR _0042_ Tile_X0Y1_DSP_bot.Inst_DSP_bot_ConfigMem.Inst_frame12_bit13.Q
+ VGND sg13g2_inv_1
XFILLER_52_56 VPWR VGND sg13g2_fill_1
XFILLER_36_79 VPWR VGND sg13g2_fill_1
XFILLER_52_78 VPWR VGND sg13g2_fill_2
X_3650_ Tile_X0Y0_DSP_top.Inst_DSP_top_ConfigMem.Inst_frame8_bit20.Q VPWR _1988_ VGND
+ Tile_X0Y0_DSP_top.Inst_DSP_top_ConfigMem.Inst_frame0_bit27.Q _1987_ sg13g2_o21ai_1
X_5251_ Tile_X0Y0_FrameData[10] Tile_X0Y1_FrameStrobe[1] Tile_X0Y0_DSP_top.Inst_DSP_top_ConfigMem.Inst_frame1_bit10.Q
+ VPWR VGND sg13g2_dlhq_1
X_2601_ Tile_X0Y0_DSP_top.Inst_DSP_top_ConfigMem.Inst_frame9_bit29.Q VPWR _0990_ VGND
+ Tile_X0Y0_DSP_top.Inst_DSP_top_ConfigMem.Inst_frame9_bit28.Q _0989_ sg13g2_o21ai_1
X_5320_ Tile_X0Y0_FrameData[5] Tile_X0Y1_FrameStrobe[3] Tile_X0Y0_DSP_top.Inst_DSP_top_ConfigMem.Inst_frame3_bit5.Q
+ VPWR VGND sg13g2_dlhq_1
X_3581_ _1694_ VPWR _1933_ VGND _1693_ _1932_ sg13g2_o21ai_1
X_4202_ Tile_X0Y1_DSP_bot.Inst_DSP_bot_ConfigMem.Inst_frame9_bit14.Q Tile_X0Y1_E1END[3]
+ Tile_X0Y1_W1END[3] Tile_X0Y1_DSP_bot.Inst_DSP_bot_switch_matrix.Q0 Tile_X0Y1_DSP_bot.Inst_DSP_bot_switch_matrix.Q1
+ Tile_X0Y1_DSP_bot.Inst_DSP_bot_ConfigMem.Inst_frame9_bit15.Q _2442_ VPWR VGND sg13g2_mux4_1
X_2532_ _0060_ _0924_ _0925_ VPWR VGND sg13g2_nor2_1
X_5182_ Tile_X0Y0_DSP_top.Inst_DSP_top_ConfigMem.Inst_frame3_bit19.Q VPWR _0908_ VGND
+ Tile_X0Y0_DSP_top.Inst_DSP_top_ConfigMem.Inst_frame3_bit18.Q _0906_ sg13g2_o21ai_1
X_3015_ VGND VPWR _1392_ _1391_ _1378_ sg13g2_or2_1
X_4133_ Tile_X0Y1_DSP_bot.Inst_DSP_bot_ConfigMem.Inst_frame11_bit16.Q Tile_X0Y1_N1END[0]
+ Tile_X0Y1_E1END[0] _0467_ Tile_X0Y1_DSP_bot.Inst_DSP_bot_switch_matrix.Q4 Tile_X0Y1_DSP_bot.Inst_DSP_bot_ConfigMem.Inst_frame11_bit17.Q
+ _2385_ VPWR VGND sg13g2_mux4_1
X_4064_ Tile_X0Y1_DSP_bot.Inst_DSP_bot_switch_matrix.Q7 Tile_X0Y1_DSP_bot.Inst_DSP_bot_switch_matrix.Q9
+ Tile_X0Y1_DSP_bot.Inst_DSP_bot_ConfigMem.Inst_frame3_bit0.Q _2335_ VPWR VGND sg13g2_mux2_1
X_4966_ _0703_ _0696_ _0702_ _0691_ _0688_ VPWR VGND sg13g2_a22oi_1
XFILLER_36_252 VPWR VGND sg13g2_fill_2
XFILLER_36_241 VPWR VGND sg13g2_fill_1
X_3779_ VPWR VGND Tile_X0Y0_DSP_top.Inst_DSP_top_ConfigMem.Inst_frame4_bit30.Q Tile_X0Y0_DSP_top.Inst_DSP_top_ConfigMem.Inst_frame4_bit31.Q
+ _2108_ _2104_ _2109_ _2107_ sg13g2_a221oi_1
X_3848_ VGND VPWR Tile_X0Y0_DSP_top.Inst_DSP_top_ConfigMem.Inst_frame1_bit0.Q Tile_X0Y0_DSP_top.Inst_DSP_top_switch_matrix.bot2top2
+ _2169_ _2168_ sg13g2_a21oi_1
X_3917_ _2215_ VPWR _2216_ VGND Tile_X0Y0_DSP_top.Inst_DSP_top_ConfigMem.Inst_frame11_bit0.Q
+ _0388_ sg13g2_o21ai_1
X_5518_ Tile_X0Y0_FrameData[31] Tile_X0Y1_FrameStrobe[10] Tile_X0Y0_DSP_top.Inst_DSP_top_ConfigMem.Inst_frame10_bit31.Q
+ VPWR VGND sg13g2_dlhq_1
X_4897_ _0125_ _0126_ Tile_X0Y1_DSP_bot.Inst_DSP_bot_ConfigMem.Inst_frame4_bit16.Q
+ _0637_ VPWR VGND sg13g2_mux2_1
X_5449_ Tile_X0Y0_FrameData[4] Tile_X0Y1_FrameStrobe[7] Tile_X0Y0_DSP_top.Inst_DSP_top_ConfigMem.Inst_frame7_bit4.Q
+ VPWR VGND sg13g2_dlhq_1
X_6498_ Tile_X0Y1_WW4END[5] Tile_X0Y1_WW4BEG[1] VPWR VGND sg13g2_buf_1
XFILLER_86_185 VPWR VGND sg13g2_fill_1
XFILLER_6_167 VPWR VGND sg13g2_fill_2
XFILLER_6_145 VPWR VGND sg13g2_fill_1
XFILLER_92_166 VPWR VGND sg13g2_fill_1
X_4820_ Tile_X0Y0_DSP_top.Inst_DSP_top_ConfigMem.Inst_frame1_bit13.Q Tile_X0Y0_DSP_top.Inst_DSP_top_switch_matrix.N1END2
+ Tile_X0Y0_E2END[4] Tile_X0Y1_N2MID[4] Tile_X0Y0_E6END[0] Tile_X0Y0_DSP_top.Inst_DSP_top_ConfigMem.Inst_frame1_bit12.Q
+ _0563_ VPWR VGND sg13g2_mux4_1
X_4751_ Tile_X0Y0_DSP_top.Inst_DSP_top_switch_matrix.bot2top3 Tile_X0Y0_DSP_top.Inst_DSP_top_switch_matrix.bot2top4
+ Tile_X0Y0_DSP_top.Inst_DSP_top_ConfigMem.Inst_frame4_bit8.Q _0497_ VPWR VGND sg13g2_mux2_1
X_3633_ _1971_ VPWR _1972_ VGND Tile_X0Y0_DSP_top.Inst_DSP_top_ConfigMem.Inst_frame3_bit24.Q
+ _0293_ sg13g2_o21ai_1
X_3702_ VGND VPWR Tile_X0Y1_N2MID[7] Tile_X0Y0_DSP_top.Inst_DSP_top_ConfigMem.Inst_frame1_bit24.Q
+ _2036_ Tile_X0Y0_DSP_top.Inst_DSP_top_ConfigMem.Inst_frame1_bit25.Q sg13g2_a21oi_1
X_4682_ VPWR Tile_X0Y0_DSP_top.Inst_DSP_top_switch_matrix.N2BEGb5 _0432_ VGND sg13g2_inv_1
X_6421_ Tile_X0Y1_DSP_bot.Inst_DSP_bot_switch_matrix.JS2BEG4 Tile_X0Y1_S2BEG[4] VPWR
+ VGND sg13g2_buf_1
X_6283_ Tile_X0Y0_DSP_top.Inst_DSP_top_switch_matrix.NN4BEG3 Tile_X0Y0_NN4BEG[15]
+ VPWR VGND sg13g2_buf_1
X_5303_ Tile_X0Y0_FrameData[22] Tile_X0Y1_FrameStrobe[3] Tile_X0Y0_DSP_top.Inst_DSP_top_ConfigMem.Inst_frame3_bit22.Q
+ VPWR VGND sg13g2_dlhq_1
X_5234_ Tile_X0Y0_FrameData[27] Tile_X0Y1_FrameStrobe[1] Tile_X0Y0_DSP_top.Inst_DSP_top_ConfigMem.Inst_frame1_bit27.Q
+ VPWR VGND sg13g2_dlhq_1
XFILLER_52_0 VPWR VGND sg13g2_fill_2
X_5165_ Tile_X0Y1_DSP_bot.Inst_DSP_bot_ConfigMem.Inst_frame0_bit5.Q Tile_X0Y1_N4END[1]
+ Tile_X0Y1_W6END[1] Tile_X0Y1_E6END[1] Tile_X0Y1_DSP_bot.Inst_DSP_bot_switch_matrix.JS2BEG1
+ Tile_X0Y1_DSP_bot.Inst_DSP_bot_ConfigMem.Inst_frame0_bit4.Q _0892_ VPWR VGND sg13g2_mux4_1
X_6352_ Tile_X0Y1_E2MID[7] Tile_X0Y1_E2BEGb[7] VPWR VGND sg13g2_buf_1
X_3495_ Tile_X0Y1_DSP_bot.Inst_DSP_bot_ConfigMem.Inst_frame7_bit23.Q _1850_ _1851_
+ VPWR VGND sg13g2_nor2_1
X_3564_ _1894_ VPWR _1916_ VGND _1914_ _1915_ sg13g2_o21ai_1
X_5096_ _0827_ Tile_X0Y0_S4END[3] Tile_X0Y0_DSP_top.Inst_DSP_top_ConfigMem.Inst_frame2_bit8.Q
+ VPWR VGND sg13g2_nand2_1
X_4047_ Tile_X0Y0_DSP_top.Inst_DSP_top_ConfigMem.Inst_frame9_bit22.Q Tile_X0Y0_DSP_top.Inst_DSP_top_switch_matrix.bot2top2
+ Tile_X0Y0_DSP_top.Inst_DSP_top_switch_matrix.bot2top3 Tile_X0Y0_DSP_top.Inst_DSP_top_switch_matrix.bot2top4
+ Tile_X0Y0_DSP_top.Inst_DSP_top_switch_matrix.bot2top5 Tile_X0Y0_DSP_top.Inst_DSP_top_ConfigMem.Inst_frame9_bit23.Q
+ _2329_ VPWR VGND sg13g2_mux4_1
X_4116_ Tile_X0Y1_DSP_bot.Inst_DSP_bot_ConfigMem.Inst_frame12_bit28.Q Tile_X0Y1_N1END[0]
+ Tile_X0Y1_E1END[0] Tile_X0Y1_W1END[0] Tile_X0Y1_DSP_bot.Inst_DSP_bot_switch_matrix.Q4
+ Tile_X0Y1_DSP_bot.Inst_DSP_bot_ConfigMem.Inst_frame12_bit29.Q _2372_ VPWR VGND sg13g2_mux4_1
X_4949_ Tile_X0Y1_DSP_bot.Inst_DSP_bot_ConfigMem.Inst_frame1_bit17.Q VPWR _0686_ VGND
+ Tile_X0Y0_S2MID[5] Tile_X0Y1_DSP_bot.Inst_DSP_bot_ConfigMem.Inst_frame1_bit16.Q
+ sg13g2_o21ai_1
X_5998_ Tile_X0Y1_FrameData[13] Tile_X0Y1_FrameStrobe[10] Tile_X0Y1_DSP_bot.Inst_DSP_bot_ConfigMem.Inst_frame10_bit13.Q
+ VPWR VGND sg13g2_dlhq_1
X_3280_ Tile_X0Y1_DSP_bot.Inst_DSP_bot_ConfigMem.Inst_frame1_bit28.Q Tile_X0Y1_DSP_bot.Inst_DSP_bot_switch_matrix.Q4
+ _1647_ VPWR VGND sg13g2_nor2b_1
XFILLER_2_170 VPWR VGND sg13g2_fill_1
XFILLER_65_177 VPWR VGND sg13g2_fill_2
XFILLER_65_166 VPWR VGND sg13g2_fill_1
X_5921_ Tile_X0Y1_FrameData[26] Tile_X0Y1_FrameStrobe[8] Tile_X0Y1_DSP_bot.Inst_DSP_bot_ConfigMem.Inst_frame8_bit26.Q
+ VPWR VGND sg13g2_dlhq_1
XFILLER_80_125 VPWR VGND sg13g2_fill_2
X_2995_ VPWR _1372_ _1371_ VGND sg13g2_inv_1
X_4734_ _0482_ Tile_X0Y1_DSP_bot.Inst_DSP_bot_ConfigMem.Inst_frame4_bit28.Q _0128_
+ VPWR VGND sg13g2_nand2_1
X_5783_ Tile_X0Y1_FrameData[4] Tile_X0Y1_FrameStrobe[3] Tile_X0Y1_DSP_bot.Inst_DSP_bot_ConfigMem.Inst_frame3_bit4.Q
+ VPWR VGND sg13g2_dlhq_1
XFILLER_0_95 VPWR VGND sg13g2_fill_2
X_4803_ Tile_X0Y1_E6END[1] Tile_X0Y0_SS4END[5] Tile_X0Y1_DSP_bot.Inst_DSP_bot_ConfigMem.Inst_frame4_bit0.Q
+ _0547_ VPWR VGND sg13g2_mux2_1
X_5852_ Tile_X0Y1_FrameData[31] Tile_X0Y1_FrameStrobe[6] Tile_X0Y1_DSP_bot.Inst_DSP_bot_ConfigMem.Inst_frame6_bit31.Q
+ VPWR VGND sg13g2_dlhq_1
X_4596_ VGND VPWR Tile_X0Y0_S2END[2] Tile_X0Y0_DSP_top.Inst_DSP_top_ConfigMem.Inst_frame4_bit4.Q
+ _0350_ _0349_ sg13g2_a21oi_1
X_4665_ Tile_X0Y0_DSP_top.Inst_DSP_top_ConfigMem.Inst_frame3_bit4.Q Tile_X0Y1_N4END[6]
+ _0417_ VPWR VGND sg13g2_nor2b_1
X_3616_ _1958_ Tile_X0Y1_DSP_bot.Inst_MULADD.ACC\[10\] Tile_X0Y1_DSP_bot.Inst_DSP_bot_ConfigMem.Inst_frame12_bit5.Q
+ VPWR VGND sg13g2_nand2_1
X_6404_ Tile_X0Y1_FrameData[23] Tile_X0Y1_FrameData_O[23] VPWR VGND sg13g2_buf_1
X_6335_ Tile_X0Y1_DSP_bot.Inst_DSP_bot_switch_matrix.E1BEG2 Tile_X0Y1_E1BEG[2] VPWR
+ VGND sg13g2_buf_1
X_3547_ VGND VPWR Tile_X0Y1_DSP_bot.Inst_DSP_bot_ConfigMem.Inst_frame0_bit17.Q _1896_
+ _1900_ _1899_ sg13g2_a21oi_1
X_6197_ Tile_X0Y0_FrameData[17] Tile_X0Y0_FrameData_O[17] VPWR VGND sg13g2_buf_1
X_6266_ Tile_X0Y0_DSP_top.Inst_DSP_top_switch_matrix.N4BEG2 Tile_X0Y0_N4BEG[14] VPWR
+ VGND sg13g2_buf_1
X_5217_ Tile_X0Y0_FrameData[12] Tile_X0Y1_FrameStrobe[0] Tile_X0Y0_DSP_top.Inst_DSP_top_ConfigMem.Inst_frame0_bit12.Q
+ VPWR VGND sg13g2_dlhq_1
X_3478_ VGND VPWR _0072_ Tile_X0Y1_DSP_bot.C4 _1834_ _1833_ sg13g2_a21oi_1
X_5148_ VGND VPWR Tile_X0Y1_DSP_bot.Inst_DSP_bot_ConfigMem.Inst_frame9_bit26.Q _0288_
+ _0876_ Tile_X0Y1_DSP_bot.Inst_DSP_bot_ConfigMem.Inst_frame9_bit27.Q sg13g2_a21oi_1
X_5079_ _0810_ VPWR _0811_ VGND Tile_X0Y0_DSP_top.Inst_DSP_top_ConfigMem.Inst_frame7_bit14.Q
+ Tile_X0Y0_DSP_top.Inst_DSP_top_switch_matrix.N2BEGb0 sg13g2_o21ai_1
XFILLER_71_158 VPWR VGND sg13g2_decap_4
XFILLER_56_155 VPWR VGND sg13g2_fill_1
XFILLER_69_32 VPWR VGND sg13g2_fill_1
X_2780_ Tile_X0Y0_DSP_top.Inst_DSP_top_ConfigMem.Inst_frame2_bit27.Q VPWR _1162_ VGND
+ Tile_X0Y0_DSP_top.Inst_DSP_top_ConfigMem.Inst_frame2_bit26.Q _1160_ sg13g2_o21ai_1
X_4381_ VPWR _0144_ _0143_ VGND sg13g2_inv_1
X_3401_ Tile_X0Y1_DSP_bot.Inst_DSP_bot_ConfigMem.Inst_frame0_bit31.Q Tile_X0Y1_NN4END[0]
+ Tile_X0Y1_W2END[0] Tile_X0Y1_E6END[0] _0704_ Tile_X0Y1_DSP_bot.Inst_DSP_bot_ConfigMem.Inst_frame0_bit30.Q
+ _1761_ VPWR VGND sg13g2_mux4_1
X_4450_ Tile_X0Y1_DSP_bot.Inst_DSP_bot_ConfigMem.Inst_frame2_bit12.Q Tile_X0Y1_DSP_bot.Inst_DSP_bot_switch_matrix.Q0
+ Tile_X0Y1_DSP_bot.Inst_DSP_bot_switch_matrix.Q1 Tile_X0Y1_DSP_bot.Inst_DSP_bot_switch_matrix.Q2
+ Tile_X0Y1_DSP_bot.Inst_DSP_bot_switch_matrix.Q4 Tile_X0Y1_DSP_bot.Inst_DSP_bot_ConfigMem.Inst_frame2_bit13.Q
+ _0210_ VPWR VGND sg13g2_mux4_1
X_3194_ Tile_X0Y0_DSP_top.Inst_DSP_top_ConfigMem.Inst_frame4_bit21.Q Tile_X0Y0_DSP_top.Inst_DSP_top_switch_matrix.bot2top4
+ Tile_X0Y0_DSP_top.Inst_DSP_top_switch_matrix.bot2top7 Tile_X0Y0_DSP_top.Inst_DSP_top_switch_matrix.bot2top6
+ Tile_X0Y0_DSP_top.Inst_DSP_top_switch_matrix.bot2top8 Tile_X0Y0_DSP_top.Inst_DSP_top_ConfigMem.Inst_frame4_bit20.Q
+ _1566_ VPWR VGND sg13g2_mux4_1
XFILLER_85_206 VPWR VGND sg13g2_decap_4
X_3332_ _1695_ VPWR _1696_ VGND Tile_X0Y1_DSP_bot.Inst_DSP_bot_ConfigMem.Inst_frame3_bit24.Q
+ _0669_ sg13g2_o21ai_1
X_5002_ _0738_ _0736_ _0737_ _0727_ _0726_ VPWR VGND sg13g2_a22oi_1
X_6051_ Tile_X0Y1_FrameData[24] Tile_X0Y1_FrameStrobe[12] Tile_X0Y1_DSP_bot.Inst_DSP_bot_ConfigMem.Inst_frame12_bit24.Q
+ VPWR VGND sg13g2_dlhq_1
X_3263_ Tile_X0Y1_DSP_bot.Inst_DSP_bot_ConfigMem.Inst_frame1_bit28.Q _0467_ _1630_
+ VPWR VGND sg13g2_nor2b_1
X_6120_ VPWR VGND _2518_ sg13g2_tiehi
X_5904_ Tile_X0Y1_FrameData[11] Tile_X0Y1_FrameStrobe[7] Tile_X0Y1_DSP_bot.Inst_DSP_bot_ConfigMem.Inst_frame7_bit11.Q
+ VPWR VGND sg13g2_dlhq_1
XFILLER_15_0 VPWR VGND sg13g2_fill_1
X_4717_ Tile_X0Y0_DSP_top.Inst_DSP_top_ConfigMem.Inst_frame6_bit15.Q Tile_X0Y0_DSP_top.Inst_DSP_top_switch_matrix.N2BEGb1
+ Tile_X0Y0_S2MID[1] Tile_X0Y0_E2MID[1] Tile_X0Y0_W2MID[1] Tile_X0Y0_DSP_top.Inst_DSP_top_ConfigMem.Inst_frame6_bit14.Q
+ _0465_ VPWR VGND sg13g2_mux4_1
X_5697_ Tile_X0Y1_FrameData[26] Tile_X0Y1_FrameStrobe[1] Tile_X0Y1_DSP_bot.Inst_DSP_bot_ConfigMem.Inst_frame1_bit26.Q
+ VPWR VGND sg13g2_dlhq_1
X_2978_ _1355_ _0899_ _1127_ VPWR VGND sg13g2_nand2_1
X_5766_ Tile_X0Y1_FrameData[21] Tile_X0Y1_FrameStrobe[3] Tile_X0Y1_DSP_bot.Inst_DSP_bot_ConfigMem.Inst_frame3_bit21.Q
+ VPWR VGND sg13g2_dlhq_1
X_5835_ Tile_X0Y1_FrameData[16] Tile_X0Y1_FrameStrobe[5] Tile_X0Y1_DSP_bot.Inst_DSP_bot_ConfigMem.Inst_frame5_bit16.Q
+ VPWR VGND sg13g2_dlhq_1
X_4648_ Tile_X0Y0_E1END[1] Tile_X0Y0_E2END[5] Tile_X0Y0_DSP_top.Inst_DSP_top_ConfigMem.Inst_frame1_bit16.Q
+ _0400_ VPWR VGND sg13g2_mux2_1
X_4579_ VGND VPWR Tile_X0Y0_DSP_top.Inst_DSP_top_ConfigMem.Inst_frame3_bit8.Q _0036_
+ _0334_ _0333_ sg13g2_a21oi_1
X_6318_ Tile_X0Y0_WW4END[5] Tile_X0Y0_WW4BEG[1] VPWR VGND sg13g2_buf_1
X_6249_ Tile_X0Y0_DSP_top.Inst_DSP_top_switch_matrix.N2BEGb5 Tile_X0Y0_N2BEGb[5] VPWR
+ VGND sg13g2_buf_1
XFILLER_4_221 VPWR VGND sg13g2_fill_2
XFILLER_4_276 VPWR VGND sg13g2_fill_2
XFILLER_90_231 VPWR VGND sg13g2_fill_2
X_3950_ Tile_X0Y0_DSP_top.Inst_DSP_top_ConfigMem.Inst_frame11_bit24.Q _0237_ Tile_X0Y0_S1END[1]
+ Tile_X0Y0_E1END[1] Tile_X0Y0_DSP_top.Inst_DSP_top_switch_matrix.bot2top5 Tile_X0Y0_DSP_top.Inst_DSP_top_ConfigMem.Inst_frame11_bit23.Q
+ _2244_ VPWR VGND sg13g2_mux4_1
X_5551_ Tile_X0Y0_FrameData[30] Tile_X0Y1_FrameStrobe[11] Tile_X0Y0_DSP_top.Inst_DSP_top_ConfigMem.Inst_frame11_bit30.Q
+ VPWR VGND sg13g2_dlhq_1
X_3881_ _2193_ VPWR _2194_ VGND Tile_X0Y0_DSP_top.Inst_DSP_top_ConfigMem.Inst_frame4_bit1.Q
+ _2192_ sg13g2_o21ai_1
X_5620_ _2475_ VGND VPWR _0016_ Tile_X0Y1_DSP_bot.Inst_MULADD.ACC\[16\] clknet_3_6_0_Tile_X0Y1_UserCLK_regs
+ sg13g2_dfrbpq_1
X_2763_ _0682_ _0869_ _1145_ VPWR VGND sg13g2_and2_1
X_2832_ _1212_ _1017_ _1141_ VPWR VGND sg13g2_xnor2_1
X_2901_ _1278_ _1274_ _1279_ VPWR VGND sg13g2_xor2_1
X_4502_ VGND VPWR Tile_X0Y0_DSP_top.Inst_DSP_top_ConfigMem.Inst_frame4_bit26.Q _0258_
+ _0260_ _0259_ sg13g2_a21oi_1
X_5482_ Tile_X0Y0_FrameData[3] Tile_X0Y1_FrameStrobe[8] Tile_X0Y0_DSP_top.Inst_DSP_top_ConfigMem.Inst_frame8_bit3.Q
+ VPWR VGND sg13g2_dlhq_1
X_4433_ _0193_ VPWR _0194_ VGND _0021_ Tile_X0Y0_DSP_top.Inst_DSP_top_ConfigMem.Inst_frame2_bit28.Q
+ sg13g2_o21ai_1
X_2694_ _1079_ _0903_ _1077_ VPWR VGND sg13g2_nand2_1
X_4364_ VPWR _0127_ Tile_X0Y1_DSP_bot.Inst_DSP_bot_switch_matrix.Q2 VGND sg13g2_inv_1
X_3177_ _1549_ VPWR _1550_ VGND Tile_X0Y0_DSP_top.Inst_DSP_top_ConfigMem.Inst_frame7_bit18.Q
+ _0935_ sg13g2_o21ai_1
X_6103_ VPWR VGND _2501_ sg13g2_tiehi
X_4295_ VPWR _0058_ Tile_X0Y0_E2MID[4] VGND sg13g2_inv_1
X_3246_ Tile_X0Y1_DSP_bot.Inst_DSP_bot_ConfigMem.Inst_frame1_bit21.Q VPWR _1614_ VGND
+ Tile_X0Y0_S2MID[6] Tile_X0Y1_DSP_bot.Inst_DSP_bot_ConfigMem.Inst_frame1_bit20.Q
+ sg13g2_o21ai_1
X_3315_ Tile_X0Y1_DSP_bot.Inst_DSP_bot_ConfigMem.Inst_frame2_bit20.Q _0422_ Tile_X0Y0_S2MID[6]
+ Tile_X0Y1_W1END[0] Tile_X0Y1_W1END[2] Tile_X0Y1_DSP_bot.Inst_DSP_bot_ConfigMem.Inst_frame2_bit21.Q
+ _1681_ VPWR VGND sg13g2_mux4_1
X_6034_ Tile_X0Y1_FrameData[9] Tile_X0Y1_FrameStrobe[11] Tile_X0Y1_DSP_bot.Inst_DSP_bot_ConfigMem.Inst_frame11_bit9.Q
+ VPWR VGND sg13g2_dlhq_1
XFILLER_66_294 VPWR VGND sg13g2_fill_1
X_5818_ Tile_X0Y1_FrameData[1] Tile_X0Y1_FrameStrobe[4] Tile_X0Y1_DSP_bot.Inst_DSP_bot_ConfigMem.Inst_frame4_bit1.Q
+ VPWR VGND sg13g2_dlhq_1
X_5749_ Tile_X0Y1_FrameData[6] Tile_X0Y1_FrameStrobe[2] Tile_X0Y1_DSP_bot.Inst_DSP_bot_ConfigMem.Inst_frame2_bit6.Q
+ VPWR VGND sg13g2_dlhq_1
XFILLER_13_331 VPWR VGND sg13g2_decap_4
X_3100_ _1476_ VPWR _1477_ VGND Tile_X0Y0_S2END[6] Tile_X0Y0_DSP_top.Inst_DSP_top_ConfigMem.Inst_frame1_bit20.Q
+ sg13g2_o21ai_1
X_3031_ _1408_ _1393_ _1406_ VPWR VGND sg13g2_xnor2_1
X_4080_ Tile_X0Y1_DSP_bot.Inst_DSP_bot_ConfigMem.Inst_frame10_bit7.Q Tile_X0Y1_E6END[1]
+ Tile_X0Y0_S4END[5] Tile_X0Y0_S2MID[2] Tile_X0Y1_DSP_bot.Inst_DSP_bot_switch_matrix.Q0
+ Tile_X0Y1_DSP_bot.Inst_DSP_bot_ConfigMem.Inst_frame10_bit6.Q Tile_X0Y1_DSP_bot.Inst_DSP_bot_switch_matrix.S4BEG0
+ VPWR VGND sg13g2_mux4_1
X_3933_ _0860_ _1564_ Tile_X0Y0_DSP_top.Inst_DSP_top_ConfigMem.Inst_frame11_bit17.Q
+ _2229_ VPWR VGND sg13g2_mux2_1
X_4982_ VGND VPWR Tile_X0Y0_S4END[1] Tile_X0Y0_DSP_top.Inst_DSP_top_ConfigMem.Inst_frame2_bit0.Q
+ _0719_ _0718_ sg13g2_a21oi_1
XFILLER_63_297 VPWR VGND sg13g2_fill_1
X_3795_ _2123_ Tile_X0Y0_DSP_top.Inst_DSP_top_ConfigMem.Inst_frame8_bit29.Q Tile_X0Y0_DSP_top.Inst_DSP_top_switch_matrix.E2BEG7
+ VPWR VGND sg13g2_nand2_1
X_3864_ Tile_X0Y0_DSP_top.Inst_DSP_top_ConfigMem.Inst_frame12_bit22.Q Tile_X0Y1_N2MID[0]
+ Tile_X0Y1_N4END[7] Tile_X0Y0_W6END[1] Tile_X0Y0_DSP_top.Inst_DSP_top_switch_matrix.bot2top6
+ Tile_X0Y0_DSP_top.Inst_DSP_top_ConfigMem.Inst_frame12_bit23.Q Tile_X0Y0_DSP_top.Inst_DSP_top_switch_matrix.N4BEG2
+ VPWR VGND sg13g2_mux4_1
XFILLER_82_0 VPWR VGND sg13g2_fill_2
X_5603_ Tile_X0Y0_FrameData[10] Tile_X0Y1_FrameStrobe[12] Tile_X0Y0_DSP_top.Inst_DSP_top_ConfigMem.Inst_frame12_bit10.Q
+ VPWR VGND sg13g2_dlhq_1
X_5534_ Tile_X0Y0_FrameData[15] Tile_X0Y1_FrameStrobe[10] Tile_X0Y0_DSP_top.Inst_DSP_top_ConfigMem.Inst_frame10_bit15.Q
+ VPWR VGND sg13g2_dlhq_1
X_2815_ _1195_ _1193_ _1194_ VPWR VGND sg13g2_nand2_1
X_2746_ _1128_ _1127_ _0608_ VPWR VGND sg13g2_nand2b_1
X_5465_ Tile_X0Y0_FrameData[20] Tile_X0Y1_FrameStrobe[8] Tile_X0Y0_DSP_top.Inst_DSP_top_ConfigMem.Inst_frame8_bit20.Q
+ VPWR VGND sg13g2_dlhq_1
X_5396_ Tile_X0Y0_FrameData[25] Tile_X0Y1_FrameStrobe[6] Tile_X0Y0_DSP_top.Inst_DSP_top_ConfigMem.Inst_frame6_bit25.Q
+ VPWR VGND sg13g2_dlhq_1
X_4347_ VPWR _0110_ Tile_X0Y1_DSP_bot.Inst_MULADD.ACC\[17\] VGND sg13g2_inv_1
X_2677_ _1062_ VPWR _1063_ VGND Tile_X0Y1_EE4END[2] Tile_X0Y1_DSP_bot.Inst_DSP_bot_ConfigMem.Inst_frame0_bit2.Q
+ sg13g2_o21ai_1
X_4416_ _0176_ VPWR _0177_ VGND Tile_X0Y1_DSP_bot.Inst_DSP_bot_ConfigMem.Inst_frame1_bit13.Q
+ _0174_ sg13g2_o21ai_1
X_4278_ VPWR _0041_ Tile_X0Y0_DSP_top.Inst_DSP_top_ConfigMem.Inst_frame2_bit22.Q VGND
+ sg13g2_inv_1
X_3229_ Tile_X0Y1_DSP_bot.Inst_DSP_bot_ConfigMem.Inst_frame3_bit30.Q _1597_ _1598_
+ VPWR VGND sg13g2_nor2_1
X_6017_ Tile_X0Y1_FrameData[26] Tile_X0Y1_FrameStrobe[11] Tile_X0Y1_DSP_bot.Inst_DSP_bot_ConfigMem.Inst_frame11_bit26.Q
+ VPWR VGND sg13g2_dlhq_1
XFILLER_7_2 VPWR VGND sg13g2_fill_1
XFILLER_45_297 VPWR VGND sg13g2_fill_1
XFILLER_45_220 VPWR VGND sg13g2_fill_1
X_2600_ Tile_X0Y0_DSP_top.Inst_DSP_top_ConfigMem.Inst_frame5_bit3.Q Tile_X0Y1_NN4END[4]
+ Tile_X0Y0_S2END[2] Tile_X0Y0_E2END[2] Tile_X0Y0_W2END[2] Tile_X0Y0_DSP_top.Inst_DSP_top_ConfigMem.Inst_frame5_bit2.Q
+ _0989_ VPWR VGND sg13g2_mux4_1
X_3580_ VGND VPWR _1930_ _1931_ _1932_ _1760_ sg13g2_a21oi_1
XFILLER_9_143 VPWR VGND sg13g2_fill_2
X_5181_ Tile_X0Y0_DSP_top.Inst_DSP_top_ConfigMem.Inst_frame3_bit16.Q Tile_X0Y0_DSP_top.Inst_DSP_top_switch_matrix.bot2top5
+ Tile_X0Y0_DSP_top.Inst_DSP_top_switch_matrix.bot2top6 Tile_X0Y0_DSP_top.Inst_DSP_top_switch_matrix.bot2top7
+ Tile_X0Y0_DSP_top.Inst_DSP_top_switch_matrix.bot2top8 Tile_X0Y0_DSP_top.Inst_DSP_top_ConfigMem.Inst_frame3_bit17.Q
+ _0907_ VPWR VGND sg13g2_mux4_1
X_5250_ Tile_X0Y0_FrameData[11] Tile_X0Y1_FrameStrobe[1] Tile_X0Y0_DSP_top.Inst_DSP_top_ConfigMem.Inst_frame1_bit11.Q
+ VPWR VGND sg13g2_dlhq_1
X_4201_ _2435_ _2441_ Tile_X0Y1_DSP_bot.Inst_DSP_bot_switch_matrix.WW4BEG3 VPWR VGND
+ sg13g2_nor2_1
X_2531_ VGND VPWR Tile_X0Y1_DSP_bot.Inst_DSP_bot_ConfigMem.Inst_frame4_bit8.Q _0130_
+ _0924_ _0923_ sg13g2_a21oi_1
XFILLER_83_359 VPWR VGND sg13g2_fill_2
X_3014_ _1391_ _1187_ _0741_ _1127_ _1076_ VPWR VGND sg13g2_a22oi_1
X_4132_ _2378_ _2384_ Tile_X0Y1_DSP_bot.Inst_DSP_bot_switch_matrix.EE4BEG1 VPWR VGND
+ sg13g2_nor2_1
X_4063_ _0125_ _0126_ Tile_X0Y1_DSP_bot.Inst_DSP_bot_ConfigMem.Inst_frame3_bit0.Q
+ _2334_ VPWR VGND sg13g2_mux2_1
X_3916_ _2215_ Tile_X0Y0_DSP_top.Inst_DSP_top_ConfigMem.Inst_frame11_bit0.Q _0938_
+ VPWR VGND sg13g2_nand2_1
XFILLER_51_234 VPWR VGND sg13g2_decap_4
X_4896_ Tile_X0Y1_DSP_bot.Inst_DSP_bot_ConfigMem.Inst_frame4_bit18.Q _0635_ _0636_
+ VPWR VGND sg13g2_nor2_1
X_4965_ Tile_X0Y1_DSP_bot.Inst_DSP_bot_ConfigMem.Inst_frame1_bit19.Q _0701_ _0702_
+ VPWR VGND sg13g2_and2_1
X_3778_ Tile_X0Y0_DSP_top.Inst_DSP_top_ConfigMem.Inst_frame4_bit28.Q Tile_X0Y0_S1END[0]
+ Tile_X0Y0_S2END[0] Tile_X0Y0_W1END[0] Tile_X0Y0_W1END[2] Tile_X0Y0_DSP_top.Inst_DSP_top_ConfigMem.Inst_frame4_bit29.Q
+ _2108_ VPWR VGND sg13g2_mux4_1
X_3847_ Tile_X0Y0_DSP_top.Inst_DSP_top_ConfigMem.Inst_frame1_bit0.Q _0133_ _2168_
+ VPWR VGND sg13g2_nor2_1
X_5517_ Tile_X0Y0_FrameData[0] Tile_X0Y1_FrameStrobe[9] Tile_X0Y0_DSP_top.Inst_DSP_top_ConfigMem.Inst_frame9_bit0.Q
+ VPWR VGND sg13g2_dlhq_1
X_2729_ _1112_ VPWR _1113_ VGND Tile_X0Y1_DSP_bot.Inst_DSP_bot_ConfigMem.Inst_frame2_bit16.Q
+ _0669_ sg13g2_o21ai_1
X_6497_ Tile_X0Y1_WW4END[4] Tile_X0Y1_WW4BEG[0] VPWR VGND sg13g2_buf_1
X_5379_ Tile_X0Y0_FrameData[10] Tile_X0Y1_FrameStrobe[5] Tile_X0Y0_DSP_top.Inst_DSP_top_ConfigMem.Inst_frame5_bit10.Q
+ VPWR VGND sg13g2_dlhq_1
X_5448_ Tile_X0Y0_FrameData[5] Tile_X0Y1_FrameStrobe[7] Tile_X0Y0_DSP_top.Inst_DSP_top_ConfigMem.Inst_frame7_bit5.Q
+ VPWR VGND sg13g2_dlhq_1
XFILLER_103_63 VPWR VGND sg13g2_decap_4
XFILLER_63_45 VPWR VGND sg13g2_fill_1
XFILLER_27_286 VPWR VGND sg13g2_fill_2
XFILLER_69_109 VPWR VGND sg13g2_fill_1
XFILLER_12_82 VPWR VGND sg13g2_fill_1
XFILLER_92_112 VPWR VGND sg13g2_decap_4
XFILLER_18_231 VPWR VGND sg13g2_fill_2
X_4750_ VPWR _0496_ _0495_ VGND sg13g2_inv_1
X_3632_ VGND VPWR Tile_X0Y1_N2MID[7] Tile_X0Y0_DSP_top.Inst_DSP_top_ConfigMem.Inst_frame3_bit24.Q
+ _1971_ Tile_X0Y0_DSP_top.Inst_DSP_top_ConfigMem.Inst_frame3_bit25.Q sg13g2_a21oi_1
X_5302_ Tile_X0Y0_FrameData[23] Tile_X0Y1_FrameStrobe[3] Tile_X0Y0_DSP_top.Inst_DSP_top_ConfigMem.Inst_frame3_bit23.Q
+ VPWR VGND sg13g2_dlhq_1
X_3701_ VGND VPWR Tile_X0Y0_DSP_top.Inst_DSP_top_ConfigMem.Inst_frame1_bit26.Q _2033_
+ _2035_ _2034_ sg13g2_a21oi_1
X_4681_ VGND VPWR _0365_ _0366_ _0432_ _0431_ sg13g2_a21oi_1
X_6420_ Tile_X0Y1_DSP_bot.Inst_DSP_bot_switch_matrix.JS2BEG3 Tile_X0Y1_S2BEG[3] VPWR
+ VGND sg13g2_buf_1
X_6351_ Tile_X0Y1_E2MID[6] Tile_X0Y1_E2BEGb[6] VPWR VGND sg13g2_buf_1
X_3563_ _1915_ _1892_ _1893_ VPWR VGND sg13g2_xnor2_1
X_6282_ Tile_X0Y0_DSP_top.Inst_DSP_top_switch_matrix.NN4BEG2 Tile_X0Y0_NN4BEG[14]
+ VPWR VGND sg13g2_buf_1
X_5233_ Tile_X0Y0_FrameData[28] Tile_X0Y1_FrameStrobe[1] Tile_X0Y0_DSP_top.Inst_DSP_top_ConfigMem.Inst_frame1_bit28.Q
+ VPWR VGND sg13g2_dlhq_1
XFILLER_68_164 VPWR VGND sg13g2_fill_2
XFILLER_45_0 VPWR VGND sg13g2_fill_1
X_4115_ Tile_X0Y1_DSP_bot.Inst_DSP_bot_ConfigMem.Inst_frame12_bit29.Q Tile_X0Y1_DSP_bot.Inst_DSP_bot_switch_matrix.Q8
+ _1793_ _1886_ _1231_ Tile_X0Y1_DSP_bot.Inst_DSP_bot_ConfigMem.Inst_frame12_bit28.Q
+ _2371_ VPWR VGND sg13g2_mux4_1
X_5164_ _0891_ VPWR Tile_X0Y1_DSP_bot.Inst_DSP_bot_switch_matrix.JS2BEG1 VGND _0882_
+ _0883_ sg13g2_o21ai_1
X_3494_ VGND VPWR Tile_X0Y1_DSP_bot.Inst_DSP_bot_ConfigMem.Inst_frame7_bit22.Q Tile_X0Y0_DSP_top.Inst_DSP_top_switch_matrix.JS2BEG0
+ _1850_ _1849_ sg13g2_a21oi_1
X_5095_ VGND VPWR _0054_ _0819_ _0826_ _0825_ sg13g2_a21oi_1
X_4046_ Tile_X0Y0_DSP_top.Inst_DSP_top_ConfigMem.Inst_frame9_bit23.Q Tile_X0Y0_E1END[2]
+ Tile_X0Y0_DSP_top.Inst_DSP_top_switch_matrix.bot2top0 Tile_X0Y0_W1END[2] Tile_X0Y0_DSP_top.Inst_DSP_top_switch_matrix.bot2top1
+ Tile_X0Y0_DSP_top.Inst_DSP_top_ConfigMem.Inst_frame9_bit22.Q _2328_ VPWR VGND sg13g2_mux4_1
X_4879_ _0619_ VPWR _0620_ VGND Tile_X0Y0_DSP_top.Inst_DSP_top_ConfigMem.Inst_frame2_bit12.Q
+ Tile_X0Y0_DSP_top.Inst_DSP_top_switch_matrix.bot2top2 sg13g2_o21ai_1
X_4948_ Tile_X0Y1_W1END[1] Tile_X0Y1_DSP_bot.Inst_DSP_bot_ConfigMem.Inst_frame1_bit16.Q
+ _0685_ VPWR VGND sg13g2_nor2b_1
XFILLER_33_59 VPWR VGND sg13g2_fill_1
X_5997_ Tile_X0Y1_FrameData[14] Tile_X0Y1_FrameStrobe[10] Tile_X0Y1_DSP_bot.Inst_DSP_bot_ConfigMem.Inst_frame10_bit14.Q
+ VPWR VGND sg13g2_dlhq_1
XFILLER_59_186 VPWR VGND sg13g2_fill_1
XFILLER_58_23 VPWR VGND sg13g2_fill_2
XFILLER_38_359 VPWR VGND sg13g2_fill_2
X_5920_ Tile_X0Y1_FrameData[27] Tile_X0Y1_FrameStrobe[8] Tile_X0Y1_DSP_bot.Inst_DSP_bot_ConfigMem.Inst_frame8_bit27.Q
+ VPWR VGND sg13g2_dlhq_1
X_2994_ _1371_ _1345_ _1346_ VPWR VGND sg13g2_xnor2_1
X_4733_ _0478_ _0480_ Tile_X0Y1_DSP_bot.Inst_DSP_bot_ConfigMem.Inst_frame4_bit30.Q
+ _0481_ VPWR VGND sg13g2_nand3_1
X_5851_ Tile_X0Y1_FrameData[0] Tile_X0Y1_FrameStrobe[5] Tile_X0Y1_DSP_bot.Inst_DSP_bot_ConfigMem.Inst_frame5_bit0.Q
+ VPWR VGND sg13g2_dlhq_1
X_4802_ _0545_ VPWR _0546_ VGND Tile_X0Y1_W2END[1] Tile_X0Y1_DSP_bot.Inst_DSP_bot_ConfigMem.Inst_frame4_bit0.Q
+ sg13g2_o21ai_1
X_5782_ Tile_X0Y1_FrameData[5] Tile_X0Y1_FrameStrobe[3] Tile_X0Y1_DSP_bot.Inst_DSP_bot_ConfigMem.Inst_frame3_bit5.Q
+ VPWR VGND sg13g2_dlhq_1
X_6265_ Tile_X0Y0_DSP_top.Inst_DSP_top_switch_matrix.N4BEG1 Tile_X0Y0_N4BEG[13] VPWR
+ VGND sg13g2_buf_1
X_4595_ Tile_X0Y0_DSP_top.Inst_DSP_top_ConfigMem.Inst_frame4_bit4.Q Tile_X0Y0_E6END[0]
+ _0349_ VPWR VGND sg13g2_nor2b_1
X_4664_ _0415_ VPWR _0416_ VGND Tile_X0Y0_DSP_top.Inst_DSP_top_ConfigMem.Inst_frame3_bit4.Q
+ _0190_ sg13g2_o21ai_1
X_3615_ _1957_ _1587_ _1933_ VPWR VGND sg13g2_xnor2_1
X_6403_ Tile_X0Y1_FrameData[22] Tile_X0Y1_FrameData_O[22] VPWR VGND sg13g2_buf_1
X_6334_ Tile_X0Y1_DSP_bot.Inst_DSP_bot_switch_matrix.E1BEG1 Tile_X0Y1_E1BEG[1] VPWR
+ VGND sg13g2_buf_1
X_3546_ Tile_X0Y1_DSP_bot.Inst_DSP_bot_ConfigMem.Inst_frame8_bit6.Q VPWR _1899_ VGND
+ Tile_X0Y1_DSP_bot.Inst_DSP_bot_ConfigMem.Inst_frame0_bit17.Q _1898_ sg13g2_o21ai_1
X_6196_ Tile_X0Y0_FrameData[16] Tile_X0Y0_FrameData_O[16] VPWR VGND sg13g2_buf_1
X_5078_ VGND VPWR _0037_ Tile_X0Y0_DSP_top.Inst_DSP_top_ConfigMem.Inst_frame7_bit14.Q
+ _0810_ Tile_X0Y0_DSP_top.Inst_DSP_top_ConfigMem.Inst_frame7_bit15.Q sg13g2_a21oi_1
X_5216_ Tile_X0Y0_FrameData[13] Tile_X0Y1_FrameStrobe[0] Tile_X0Y0_DSP_top.Inst_DSP_top_ConfigMem.Inst_frame0_bit13.Q
+ VPWR VGND sg13g2_dlhq_1
X_3477_ Tile_X0Y1_DSP_bot.Inst_DSP_bot_ConfigMem.Inst_frame12_bit2.Q Tile_X0Y1_DSP_bot.Inst_MULADD.C_reg\[4\]
+ _1833_ VPWR VGND sg13g2_and2_1
X_5147_ VPWR _0875_ _0874_ VGND sg13g2_inv_1
XFILLER_71_115 VPWR VGND sg13g2_fill_2
X_4029_ _2311_ _2312_ Tile_X0Y0_DSP_top.Inst_DSP_top_ConfigMem.Inst_frame9_bit17.Q
+ Tile_X0Y0_DSP_top.Inst_DSP_top_switch_matrix.WW4BEG3 VPWR VGND sg13g2_mux2_1
XFILLER_106_342 VPWR VGND sg13g2_fill_1
XFILLER_85_87 VPWR VGND sg13g2_fill_2
XFILLER_62_104 VPWR VGND sg13g2_fill_1
X_4380_ Tile_X0Y0_DSP_top.Inst_DSP_top_ConfigMem.Inst_frame2_bit4.Q Tile_X0Y1_NN4END[6]
+ Tile_X0Y0_E1END[0] Tile_X0Y0_EE4END[2] Tile_X0Y0_E6END[0] Tile_X0Y0_DSP_top.Inst_DSP_top_ConfigMem.Inst_frame2_bit5.Q
+ _0143_ VPWR VGND sg13g2_mux4_1
X_3331_ VGND VPWR Tile_X0Y1_DSP_bot.Inst_DSP_bot_ConfigMem.Inst_frame3_bit24.Q _0436_
+ _1695_ Tile_X0Y1_DSP_bot.Inst_DSP_bot_ConfigMem.Inst_frame3_bit25.Q sg13g2_a21oi_1
X_3400_ _1757_ _1759_ _1760_ VPWR VGND sg13g2_nor2_1
X_3193_ Tile_X0Y0_DSP_top.Inst_DSP_top_ConfigMem.Inst_frame8_bit11.Q VPWR _1565_ VGND
+ Tile_X0Y0_DSP_top.Inst_DSP_top_ConfigMem.Inst_frame8_bit10.Q _1564_ sg13g2_o21ai_1
X_6050_ Tile_X0Y1_FrameData[25] Tile_X0Y1_FrameStrobe[12] Tile_X0Y1_DSP_bot.Inst_DSP_bot_ConfigMem.Inst_frame12_bit25.Q
+ VPWR VGND sg13g2_dlhq_1
X_3262_ VPWR Tile_X0Y1_DSP_bot.Inst_DSP_bot_switch_matrix.JW2BEG5 _1629_ VGND sg13g2_inv_1
X_5001_ _0733_ Tile_X0Y1_DSP_bot.Inst_DSP_bot_ConfigMem.Inst_frame8_bit5.Q _0737_
+ VPWR VGND sg13g2_nor2b_1
XFILLER_93_273 VPWR VGND sg13g2_fill_1
X_5903_ Tile_X0Y1_FrameData[12] Tile_X0Y1_FrameStrobe[7] Tile_X0Y1_DSP_bot.Inst_DSP_bot_ConfigMem.Inst_frame7_bit12.Q
+ VPWR VGND sg13g2_dlhq_1
X_5834_ Tile_X0Y1_FrameData[17] Tile_X0Y1_FrameStrobe[5] Tile_X0Y1_DSP_bot.Inst_DSP_bot_ConfigMem.Inst_frame5_bit17.Q
+ VPWR VGND sg13g2_dlhq_1
X_4647_ _0398_ VPWR _0399_ VGND Tile_X0Y0_DSP_top.Inst_DSP_top_ConfigMem.Inst_frame1_bit16.Q
+ _0237_ sg13g2_o21ai_1
X_4716_ VPWR _0464_ Tile_X0Y0_DSP_top.Inst_DSP_top_switch_matrix.E2BEG3 VGND sg13g2_inv_1
X_5696_ Tile_X0Y1_FrameData[27] Tile_X0Y1_FrameStrobe[1] Tile_X0Y1_DSP_bot.Inst_DSP_bot_ConfigMem.Inst_frame1_bit27.Q
+ VPWR VGND sg13g2_dlhq_1
X_2977_ _1187_ _1327_ _0741_ _1354_ VPWR VGND sg13g2_nand3_1
X_5765_ Tile_X0Y1_FrameData[22] Tile_X0Y1_FrameStrobe[3] Tile_X0Y1_DSP_bot.Inst_DSP_bot_ConfigMem.Inst_frame3_bit22.Q
+ VPWR VGND sg13g2_dlhq_1
X_6248_ Tile_X0Y0_DSP_top.Inst_DSP_top_switch_matrix.N2BEGb4 Tile_X0Y0_N2BEGb[4] VPWR
+ VGND sg13g2_buf_1
X_4578_ Tile_X0Y0_DSP_top.Inst_DSP_top_ConfigMem.Inst_frame3_bit9.Q VPWR _0333_ VGND
+ Tile_X0Y0_DSP_top.Inst_DSP_top_ConfigMem.Inst_frame3_bit8.Q Tile_X0Y0_W2END[3] sg13g2_o21ai_1
X_6317_ Tile_X0Y0_WW4END[4] Tile_X0Y0_WW4BEG[0] VPWR VGND sg13g2_buf_1
X_3529_ VGND VPWR Tile_X0Y1_N2MID[2] _0106_ _1883_ Tile_X0Y1_DSP_bot.Inst_DSP_bot_ConfigMem.Inst_frame7_bit19.Q
+ sg13g2_a21oi_1
X_6179_ Tile_X0Y0_DSP_top.Inst_DSP_top_switch_matrix.EE4BEG3 Tile_X0Y0_EE4BEG[15]
+ VPWR VGND sg13g2_buf_1
XFILLER_76_218 VPWR VGND sg13g2_fill_2
XFILLER_4_244 VPWR VGND sg13g2_fill_1
XFILLER_96_75 VPWR VGND sg13g2_fill_2
XFILLER_4_288 VPWR VGND sg13g2_fill_2
XFILLER_90_287 VPWR VGND sg13g2_fill_2
XFILLER_90_254 VPWR VGND sg13g2_fill_1
X_2900_ _1278_ _1220_ _1276_ VPWR VGND sg13g2_xnor2_1
X_4501_ Tile_X0Y0_DSP_top.Inst_DSP_top_ConfigMem.Inst_frame4_bit27.Q VPWR _0259_ VGND
+ Tile_X0Y0_DSP_top.Inst_DSP_top_ConfigMem.Inst_frame4_bit26.Q _0257_ sg13g2_o21ai_1
X_5550_ Tile_X0Y0_FrameData[31] Tile_X0Y1_FrameStrobe[11] Tile_X0Y0_DSP_top.Inst_DSP_top_ConfigMem.Inst_frame11_bit31.Q
+ VPWR VGND sg13g2_dlhq_1
X_3880_ VGND VPWR Tile_X0Y0_DSP_top.Inst_DSP_top_ConfigMem.Inst_frame4_bit1.Q _2190_
+ _2193_ Tile_X0Y0_DSP_top.Inst_DSP_top_ConfigMem.Inst_frame4_bit2.Q sg13g2_a21oi_1
X_5481_ Tile_X0Y0_FrameData[4] Tile_X0Y1_FrameStrobe[8] Tile_X0Y0_DSP_top.Inst_DSP_top_ConfigMem.Inst_frame8_bit4.Q
+ VPWR VGND sg13g2_dlhq_1
X_2762_ _1144_ _0682_ _0817_ VPWR VGND sg13g2_nand2_1
X_2831_ _1211_ _1209_ _1210_ VPWR VGND sg13g2_nand2b_1
X_4432_ _0193_ Tile_X0Y0_DSP_top.Inst_DSP_top_ConfigMem.Inst_frame2_bit28.Q Tile_X0Y0_E2END[0]
+ VPWR VGND sg13g2_nand2_1
X_2693_ _1078_ _0817_ _1076_ VPWR VGND sg13g2_nand2_1
X_6102_ VPWR VGND _2500_ sg13g2_tiehi
X_4294_ VPWR _0057_ Tile_X0Y1_DSP_bot.Inst_DSP_bot_ConfigMem.Inst_frame4_bit19.Q VGND
+ sg13g2_inv_1
X_3314_ Tile_X0Y1_DSP_bot.Inst_DSP_bot_ConfigMem.Inst_frame2_bit21.Q Tile_X0Y1_N1END[2]
+ Tile_X0Y1_E1END[2] Tile_X0Y1_N2END[6] Tile_X0Y1_E2END[6] Tile_X0Y1_DSP_bot.Inst_DSP_bot_ConfigMem.Inst_frame2_bit20.Q
+ _1680_ VPWR VGND sg13g2_mux4_1
X_4363_ VPWR _0126_ Tile_X0Y1_DSP_bot.Inst_DSP_bot_switch_matrix.Q6 VGND sg13g2_inv_1
X_3176_ _1549_ Tile_X0Y0_E2MID[2] Tile_X0Y0_DSP_top.Inst_DSP_top_ConfigMem.Inst_frame7_bit18.Q
+ VPWR VGND sg13g2_nand2_1
XFILLER_58_218 VPWR VGND sg13g2_fill_2
X_3245_ Tile_X0Y1_W1END[2] Tile_X0Y1_DSP_bot.Inst_DSP_bot_ConfigMem.Inst_frame1_bit20.Q
+ _1613_ VPWR VGND sg13g2_nor2b_1
X_6033_ Tile_X0Y1_FrameData[10] Tile_X0Y1_FrameStrobe[11] Tile_X0Y1_DSP_bot.Inst_DSP_bot_ConfigMem.Inst_frame11_bit10.Q
+ VPWR VGND sg13g2_dlhq_1
XFILLER_81_232 VPWR VGND sg13g2_fill_2
XFILLER_34_192 VPWR VGND sg13g2_fill_2
X_5817_ Tile_X0Y1_FrameData[2] Tile_X0Y1_FrameStrobe[4] Tile_X0Y1_DSP_bot.Inst_DSP_bot_ConfigMem.Inst_frame4_bit2.Q
+ VPWR VGND sg13g2_dlhq_1
X_5748_ Tile_X0Y1_FrameData[7] Tile_X0Y1_FrameStrobe[2] Tile_X0Y1_DSP_bot.Inst_DSP_bot_ConfigMem.Inst_frame2_bit7.Q
+ VPWR VGND sg13g2_dlhq_1
X_5679_ Tile_X0Y1_FrameData[12] Tile_X0Y1_FrameStrobe[0] Tile_X0Y1_DSP_bot.Inst_DSP_bot_ConfigMem.Inst_frame0_bit12.Q
+ VPWR VGND sg13g2_dlhq_1
XFILLER_66_34 VPWR VGND sg13g2_fill_2
XFILLER_72_210 VPWR VGND sg13g2_fill_2
XFILLER_99_118 VPWR VGND sg13g2_fill_2
XFILLER_48_262 VPWR VGND sg13g2_fill_1
X_3030_ _1407_ _1395_ _1405_ VPWR VGND sg13g2_nand2_1
X_3932_ VGND VPWR Tile_X0Y0_DSP_top.Inst_DSP_top_ConfigMem.Inst_frame11_bit18.Q _2227_
+ _2228_ Tile_X0Y0_DSP_top.Inst_DSP_top_ConfigMem.Inst_frame11_bit19.Q sg13g2_a21oi_1
X_3863_ Tile_X0Y0_DSP_top.Inst_DSP_top_ConfigMem.Inst_frame12_bit20.Q Tile_X0Y1_N2MID[3]
+ Tile_X0Y1_N4END[6] Tile_X0Y0_E6END[0] Tile_X0Y0_DSP_top.Inst_DSP_top_switch_matrix.bot2top5
+ Tile_X0Y0_DSP_top.Inst_DSP_top_ConfigMem.Inst_frame12_bit21.Q Tile_X0Y0_DSP_top.Inst_DSP_top_switch_matrix.N4BEG1
+ VPWR VGND sg13g2_mux4_1
X_4981_ Tile_X0Y0_DSP_top.Inst_DSP_top_ConfigMem.Inst_frame2_bit0.Q Tile_X0Y0_S2END[1]
+ _0718_ VPWR VGND sg13g2_nor2b_1
XFILLER_16_170 VPWR VGND sg13g2_fill_1
X_3794_ VGND VPWR Tile_X0Y0_DSP_top.Inst_DSP_top_ConfigMem.Inst_frame3_bit31.Q _2115_
+ Tile_X0Y0_DSP_top.Inst_DSP_top_switch_matrix.E2BEG7 _2122_ sg13g2_a21oi_1
X_5464_ Tile_X0Y0_FrameData[21] Tile_X0Y1_FrameStrobe[8] Tile_X0Y0_DSP_top.Inst_DSP_top_ConfigMem.Inst_frame8_bit21.Q
+ VPWR VGND sg13g2_dlhq_1
X_5602_ Tile_X0Y0_FrameData[11] Tile_X0Y1_FrameStrobe[12] Tile_X0Y0_DSP_top.Inst_DSP_top_ConfigMem.Inst_frame12_bit11.Q
+ VPWR VGND sg13g2_dlhq_1
XFILLER_75_0 VPWR VGND sg13g2_fill_1
X_5533_ Tile_X0Y0_FrameData[16] Tile_X0Y1_FrameStrobe[10] Tile_X0Y0_DSP_top.Inst_DSP_top_ConfigMem.Inst_frame10_bit16.Q
+ VPWR VGND sg13g2_dlhq_1
X_2814_ _1081_ _1080_ _1194_ VPWR VGND sg13g2_xor2_1
X_2745_ _1126_ VPWR _1127_ VGND Tile_X0Y1_DSP_bot.Inst_DSP_bot_ConfigMem.Inst_frame12_bit1.Q
+ _1125_ sg13g2_o21ai_1
X_2676_ _1062_ Tile_X0Y1_DSP_bot.Inst_DSP_bot_ConfigMem.Inst_frame0_bit2.Q Tile_X0Y0_S4END[6]
+ VPWR VGND sg13g2_nand2b_1
X_4277_ VPWR _0040_ Tile_X0Y1_N2MID[5] VGND sg13g2_inv_1
X_5395_ Tile_X0Y0_FrameData[26] Tile_X0Y1_FrameStrobe[6] Tile_X0Y0_DSP_top.Inst_DSP_top_ConfigMem.Inst_frame6_bit26.Q
+ VPWR VGND sg13g2_dlhq_1
X_4346_ VPWR _0109_ Tile_X0Y1_DSP_bot.Inst_MULADD.C_reg\[14\] VGND sg13g2_inv_1
X_4415_ VGND VPWR Tile_X0Y1_DSP_bot.Inst_DSP_bot_ConfigMem.Inst_frame1_bit13.Q _0175_
+ _0176_ _0026_ sg13g2_a21oi_1
X_3159_ Tile_X0Y0_DSP_top.Inst_DSP_top_switch_matrix.E2BEG5 _1531_ _1532_ _1523_ Tile_X0Y0_DSP_top.Inst_DSP_top_ConfigMem.Inst_frame3_bit23.Q
+ VPWR VGND sg13g2_a22oi_1
X_3228_ Tile_X0Y1_DSP_bot.Inst_DSP_bot_ConfigMem.Inst_frame3_bit28.Q Tile_X0Y1_N1END[0]
+ Tile_X0Y1_N2END[0] Tile_X0Y1_E1END[0] Tile_X0Y1_E2END[0] Tile_X0Y1_DSP_bot.Inst_DSP_bot_ConfigMem.Inst_frame3_bit29.Q
+ _1597_ VPWR VGND sg13g2_mux4_1
X_6016_ Tile_X0Y1_FrameData[27] Tile_X0Y1_FrameStrobe[11] Tile_X0Y1_DSP_bot.Inst_DSP_bot_ConfigMem.Inst_frame11_bit27.Q
+ VPWR VGND sg13g2_dlhq_1
XFILLER_22_162 VPWR VGND sg13g2_fill_2
XFILLER_108_234 VPWR VGND sg13g2_fill_1
X_2530_ Tile_X0Y1_DSP_bot.Inst_DSP_bot_ConfigMem.Inst_frame4_bit9.Q VPWR _0923_ VGND
+ Tile_X0Y1_DSP_bot.Inst_DSP_bot_ConfigMem.Inst_frame4_bit8.Q Tile_X0Y1_DSP_bot.Inst_DSP_bot_switch_matrix.Q7
+ sg13g2_o21ai_1
X_5180_ VPWR _0906_ _0905_ VGND sg13g2_inv_1
X_4200_ VGND VPWR Tile_X0Y1_DSP_bot.Inst_DSP_bot_ConfigMem.Inst_frame9_bit12.Q _2437_
+ _2441_ _2440_ sg13g2_a21oi_1
X_4131_ VGND VPWR Tile_X0Y1_DSP_bot.Inst_DSP_bot_ConfigMem.Inst_frame11_bit14.Q _2380_
+ _2384_ _2383_ sg13g2_a21oi_1
X_3013_ _1388_ _1389_ _1390_ VPWR VGND sg13g2_nor2b_1
X_4062_ Tile_X0Y1_DSP_bot.Inst_DSP_bot_ConfigMem.Inst_frame3_bit0.Q Tile_X0Y1_DSP_bot.Inst_DSP_bot_switch_matrix.Q1
+ Tile_X0Y1_DSP_bot.Inst_DSP_bot_switch_matrix.Q2 Tile_X0Y1_DSP_bot.Inst_DSP_bot_switch_matrix.Q3
+ Tile_X0Y1_DSP_bot.Inst_DSP_bot_switch_matrix.Q4 Tile_X0Y1_DSP_bot.Inst_DSP_bot_ConfigMem.Inst_frame3_bit1.Q
+ _2333_ VPWR VGND sg13g2_mux4_1
X_3846_ Tile_X0Y0_DSP_top.Inst_DSP_top_switch_matrix.bot2top3 Tile_X0Y0_DSP_top.Inst_DSP_top_switch_matrix.bot2top4
+ Tile_X0Y0_DSP_top.Inst_DSP_top_ConfigMem.Inst_frame1_bit0.Q _2167_ VPWR VGND sg13g2_mux2_1
X_3915_ VGND VPWR Tile_X0Y0_DSP_top.Inst_DSP_top_ConfigMem.Inst_frame11_bit1.Q _2213_
+ _2214_ Tile_X0Y0_DSP_top.Inst_DSP_top_ConfigMem.Inst_frame11_bit2.Q sg13g2_a21oi_1
X_4895_ Tile_X0Y1_DSP_bot.Inst_DSP_bot_ConfigMem.Inst_frame4_bit16.Q Tile_X0Y1_DSP_bot.Inst_DSP_bot_switch_matrix.Q0
+ Tile_X0Y1_DSP_bot.Inst_DSP_bot_switch_matrix.Q1 Tile_X0Y1_DSP_bot.Inst_DSP_bot_switch_matrix.Q2
+ Tile_X0Y1_DSP_bot.Inst_DSP_bot_switch_matrix.Q3 Tile_X0Y1_DSP_bot.Inst_DSP_bot_ConfigMem.Inst_frame4_bit17.Q
+ _0635_ VPWR VGND sg13g2_mux4_1
X_4964_ _0700_ VPWR _0701_ VGND Tile_X0Y1_DSP_bot.Inst_DSP_bot_ConfigMem.Inst_frame1_bit17.Q
+ _0698_ sg13g2_o21ai_1
XFILLER_22_17 VPWR VGND sg13g2_fill_2
X_3777_ Tile_X0Y0_DSP_top.Inst_DSP_top_ConfigMem.Inst_frame4_bit30.Q _2106_ _2107_
+ VPWR VGND sg13g2_nor2_1
X_5516_ Tile_X0Y0_FrameData[1] Tile_X0Y1_FrameStrobe[9] Tile_X0Y0_DSP_top.Inst_DSP_top_ConfigMem.Inst_frame9_bit1.Q
+ VPWR VGND sg13g2_dlhq_1
X_5447_ Tile_X0Y0_FrameData[6] Tile_X0Y1_FrameStrobe[7] Tile_X0Y0_DSP_top.Inst_DSP_top_ConfigMem.Inst_frame7_bit6.Q
+ VPWR VGND sg13g2_dlhq_1
X_2728_ VGND VPWR _0051_ Tile_X0Y1_DSP_bot.Inst_DSP_bot_ConfigMem.Inst_frame2_bit16.Q
+ _1112_ Tile_X0Y1_DSP_bot.Inst_DSP_bot_ConfigMem.Inst_frame2_bit17.Q sg13g2_a21oi_1
X_2659_ _1046_ Tile_X0Y1_DSP_bot.Inst_DSP_bot_ConfigMem.Inst_frame3_bit5.Q _1045_
+ VPWR VGND sg13g2_nand2_1
X_6496_ Tile_X0Y1_DSP_bot.Inst_DSP_bot_switch_matrix.W6BEG1 Tile_X0Y1_W6BEG[11] VPWR
+ VGND sg13g2_buf_1
XFILLER_86_176 VPWR VGND sg13g2_fill_2
X_5378_ Tile_X0Y0_FrameData[11] Tile_X0Y1_FrameStrobe[5] Tile_X0Y0_DSP_top.Inst_DSP_top_ConfigMem.Inst_frame5_bit11.Q
+ VPWR VGND sg13g2_dlhq_1
XFILLER_59_335 VPWR VGND sg13g2_fill_2
X_4329_ VPWR _0092_ Tile_X0Y1_DSP_bot.Inst_DSP_bot_ConfigMem.Inst_frame2_bit23.Q VGND
+ sg13g2_inv_1
XFILLER_63_68 VPWR VGND sg13g2_fill_2
XFILLER_6_169 VPWR VGND sg13g2_fill_1
XFILLER_92_146 VPWR VGND sg13g2_fill_1
XFILLER_18_254 VPWR VGND sg13g2_fill_2
X_3700_ Tile_X0Y0_DSP_top.Inst_DSP_top_ConfigMem.Inst_frame1_bit27.Q VPWR _2034_ VGND
+ Tile_X0Y0_DSP_top.Inst_DSP_top_ConfigMem.Inst_frame1_bit26.Q _2032_ sg13g2_o21ai_1
X_4680_ VGND VPWR _0424_ _0428_ _0431_ _0430_ sg13g2_a21oi_1
XFILLER_33_224 VPWR VGND sg13g2_fill_1
X_6281_ Tile_X0Y0_DSP_top.Inst_DSP_top_switch_matrix.NN4BEG1 Tile_X0Y0_NN4BEG[13]
+ VPWR VGND sg13g2_buf_1
X_5301_ Tile_X0Y0_FrameData[24] Tile_X0Y1_FrameStrobe[3] Tile_X0Y0_DSP_top.Inst_DSP_top_ConfigMem.Inst_frame3_bit24.Q
+ VPWR VGND sg13g2_dlhq_1
X_3631_ VGND VPWR Tile_X0Y0_DSP_top.Inst_DSP_top_ConfigMem.Inst_frame3_bit26.Q _1968_
+ _1970_ _1969_ sg13g2_a21oi_1
X_6350_ Tile_X0Y1_E2MID[5] Tile_X0Y1_E2BEGb[5] VPWR VGND sg13g2_buf_1
X_3493_ Tile_X0Y1_DSP_bot.Inst_DSP_bot_ConfigMem.Inst_frame7_bit22.Q Tile_X0Y1_E2MID[0]
+ _1849_ VPWR VGND sg13g2_nor2b_1
X_3562_ _1914_ _1417_ _1913_ VPWR VGND sg13g2_nand2_1
XFILLER_110_251 VPWR VGND sg13g2_fill_1
X_5232_ Tile_X0Y0_FrameData[29] Tile_X0Y1_FrameStrobe[1] Tile_X0Y0_DSP_top.Inst_DSP_top_ConfigMem.Inst_frame1_bit29.Q
+ VPWR VGND sg13g2_dlhq_1
X_5094_ _0825_ Tile_X0Y0_DSP_top.Inst_DSP_top_ConfigMem.Inst_frame2_bit11.Q _0824_
+ VPWR VGND sg13g2_nand2b_1
XFILLER_56_338 VPWR VGND sg13g2_fill_1
X_5163_ _0890_ VPWR _0891_ VGND Tile_X0Y1_DSP_bot.Inst_DSP_bot_ConfigMem.Inst_frame2_bit6.Q
+ _0884_ sg13g2_o21ai_1
X_4114_ _2370_ _2369_ Tile_X0Y1_DSP_bot.Inst_DSP_bot_ConfigMem.Inst_frame12_bit27.Q
+ Tile_X0Y0_DSP_top.NN4BEG_outbuf_9.A VPWR VGND sg13g2_mux2_1
X_4045_ Tile_X0Y0_DSP_top.Inst_DSP_top_ConfigMem.Inst_frame9_bit25.Q VPWR _2327_ VGND
+ Tile_X0Y0_DSP_top.Inst_DSP_top_ConfigMem.Inst_frame9_bit24.Q _2326_ sg13g2_o21ai_1
X_5996_ Tile_X0Y1_FrameData[15] Tile_X0Y1_FrameStrobe[10] Tile_X0Y1_DSP_bot.Inst_DSP_bot_ConfigMem.Inst_frame10_bit15.Q
+ VPWR VGND sg13g2_dlhq_1
X_3829_ Tile_X0Y0_DSP_top.Inst_DSP_top_ConfigMem.Inst_frame2_bit22.Q VPWR _2151_ VGND
+ Tile_X0Y0_DSP_top.Inst_DSP_top_ConfigMem.Inst_frame2_bit21.Q _2148_ sg13g2_o21ai_1
X_4878_ _0619_ Tile_X0Y0_DSP_top.Inst_DSP_top_ConfigMem.Inst_frame2_bit12.Q Tile_X0Y0_DSP_top.Inst_DSP_top_switch_matrix.bot2top4
+ VPWR VGND sg13g2_nand2b_1
X_4947_ _0669_ _0435_ Tile_X0Y1_DSP_bot.Inst_DSP_bot_ConfigMem.Inst_frame1_bit16.Q
+ _0684_ VPWR VGND sg13g2_mux2_1
XFILLER_59_110 VPWR VGND sg13g2_fill_1
Xclkbuf_3_0_0_Tile_X0Y1_UserCLK_regs clknet_0_Tile_X0Y1_UserCLK_regs clknet_3_0_0_Tile_X0Y1_UserCLK_regs
+ VPWR VGND sg13g2_buf_8
X_6479_ Tile_X0Y1_W2MID[2] Tile_X0Y1_W2BEGb[2] VPWR VGND sg13g2_buf_1
XFILLER_101_295 VPWR VGND sg13g2_decap_8
XFILLER_99_64 VPWR VGND sg13g2_fill_1
XFILLER_65_113 VPWR VGND sg13g2_fill_2
XFILLER_80_127 VPWR VGND sg13g2_fill_1
XFILLER_65_179 VPWR VGND sg13g2_fill_1
XFILLER_46_360 VPWR VGND sg13g2_fill_1
X_5850_ Tile_X0Y1_FrameData[1] Tile_X0Y1_FrameStrobe[5] Tile_X0Y1_DSP_bot.Inst_DSP_bot_ConfigMem.Inst_frame5_bit1.Q
+ VPWR VGND sg13g2_dlhq_1
X_4663_ VGND VPWR Tile_X0Y1_N2MID[2] Tile_X0Y0_DSP_top.Inst_DSP_top_ConfigMem.Inst_frame3_bit4.Q
+ _0415_ Tile_X0Y0_DSP_top.Inst_DSP_top_ConfigMem.Inst_frame3_bit5.Q sg13g2_a21oi_1
X_6402_ Tile_X0Y1_FrameData[21] Tile_X0Y1_FrameData_O[21] VPWR VGND sg13g2_buf_1
X_2993_ _1370_ _1366_ _1369_ VPWR VGND sg13g2_nand2_1
X_4732_ _0131_ Tile_X0Y1_DSP_bot.Inst_DSP_bot_ConfigMem.Inst_frame4_bit28.Q _0479_
+ _0480_ VPWR VGND sg13g2_a21o_1
X_4801_ _0545_ _0028_ Tile_X0Y1_DSP_bot.Inst_DSP_bot_ConfigMem.Inst_frame4_bit0.Q
+ VPWR VGND sg13g2_nand2_1
X_5781_ Tile_X0Y1_FrameData[6] Tile_X0Y1_FrameStrobe[3] Tile_X0Y1_DSP_bot.Inst_DSP_bot_ConfigMem.Inst_frame3_bit6.Q
+ VPWR VGND sg13g2_dlhq_1
XFILLER_9_51 VPWR VGND sg13g2_decap_4
X_3614_ Tile_X0Y1_DSP_bot.Inst_DSP_bot_ConfigMem.Inst_frame12_bit11.Q Tile_X0Y1_DSP_bot.Inst_DSP_bot_switch_matrix.Q4
+ Tile_X0Y1_DSP_bot.Inst_DSP_bot_switch_matrix.JW2BEG1 _1793_ _1761_ Tile_X0Y1_DSP_bot.Inst_DSP_bot_ConfigMem.Inst_frame12_bit10.Q
+ Tile_X0Y0_DSP_top.Inst_DSP_top_switch_matrix.N1END2 VPWR VGND sg13g2_mux4_1
X_6264_ Tile_X0Y0_DSP_top.Inst_DSP_top_switch_matrix.N4BEG0 Tile_X0Y0_N4BEG[12] VPWR
+ VGND sg13g2_buf_1
X_4594_ _0348_ Tile_X0Y0_DSP_top.Inst_DSP_top_ConfigMem.Inst_frame4_bit7.Q _0341_
+ VPWR VGND sg13g2_nand2_1
X_5215_ Tile_X0Y0_FrameData[14] Tile_X0Y1_FrameStrobe[0] Tile_X0Y0_DSP_top.Inst_DSP_top_ConfigMem.Inst_frame0_bit14.Q
+ VPWR VGND sg13g2_dlhq_1
X_3476_ Tile_X0Y1_DSP_bot.C4 _1832_ _1823_ VPWR VGND sg13g2_nand2b_1
X_6333_ Tile_X0Y1_DSP_bot.Inst_DSP_bot_switch_matrix.E1BEG0 Tile_X0Y1_E1BEG[0] VPWR
+ VGND sg13g2_buf_1
X_3545_ VGND VPWR Tile_X0Y1_E2END[3] Tile_X0Y1_DSP_bot.Inst_DSP_bot_ConfigMem.Inst_frame0_bit16.Q
+ _1898_ _1897_ sg13g2_a21oi_1
X_6195_ Tile_X0Y0_FrameData[15] Tile_X0Y0_FrameData_O[15] VPWR VGND sg13g2_buf_1
X_5077_ VGND VPWR Tile_X0Y0_DSP_top.Inst_DSP_top_ConfigMem.Inst_frame7_bit14.Q _0405_
+ _0809_ _0808_ sg13g2_a21oi_1
X_4028_ Tile_X0Y0_DSP_top.Inst_DSP_top_ConfigMem.Inst_frame9_bit15.Q Tile_X0Y0_DSP_top.Inst_DSP_top_switch_matrix.bot2top9
+ _1510_ _2015_ _0616_ Tile_X0Y0_DSP_top.Inst_DSP_top_ConfigMem.Inst_frame9_bit16.Q
+ _2312_ VPWR VGND sg13g2_mux4_1
X_5146_ _0873_ VPWR _0874_ VGND Tile_X0Y1_DSP_bot.Inst_DSP_bot_ConfigMem.Inst_frame7_bit5.Q
+ _0871_ sg13g2_o21ai_1
X_5979_ Tile_X0Y1_FrameData[0] Tile_X0Y1_FrameStrobe[9] Tile_X0Y1_DSP_bot.Inst_DSP_bot_ConfigMem.Inst_frame9_bit0.Q
+ VPWR VGND sg13g2_dlhq_1
XFILLER_94_219 VPWR VGND sg13g2_fill_2
XFILLER_47_179 VPWR VGND sg13g2_fill_1
XFILLER_18_93 VPWR VGND sg13g2_fill_1
X_3330_ _1694_ _1690_ _1692_ VPWR VGND sg13g2_nand2_1
X_3192_ Tile_X0Y0_DSP_top.Inst_DSP_top_ConfigMem.Inst_frame5_bit16.Q Tile_X0Y1_N2MID[7]
+ Tile_X0Y0_EE4END[2] Tile_X0Y0_S2END[7] Tile_X0Y0_W2END[7] Tile_X0Y0_DSP_top.Inst_DSP_top_ConfigMem.Inst_frame5_bit17.Q
+ _1564_ VPWR VGND sg13g2_mux4_1
X_3261_ VGND VPWR _1625_ _1628_ _1629_ _1619_ sg13g2_a21oi_1
X_5000_ VPWR _0736_ _0735_ VGND sg13g2_inv_1
XFILLER_34_330 VPWR VGND sg13g2_fill_1
XFILLER_19_360 VPWR VGND sg13g2_fill_1
X_5833_ Tile_X0Y1_FrameData[18] Tile_X0Y1_FrameStrobe[5] Tile_X0Y1_DSP_bot.Inst_DSP_bot_ConfigMem.Inst_frame5_bit18.Q
+ VPWR VGND sg13g2_dlhq_1
X_5902_ Tile_X0Y1_FrameData[13] Tile_X0Y1_FrameStrobe[7] Tile_X0Y1_DSP_bot.Inst_DSP_bot_ConfigMem.Inst_frame7_bit13.Q
+ VPWR VGND sg13g2_dlhq_1
X_4646_ VGND VPWR _0040_ Tile_X0Y0_DSP_top.Inst_DSP_top_ConfigMem.Inst_frame1_bit16.Q
+ _0398_ Tile_X0Y0_DSP_top.Inst_DSP_top_ConfigMem.Inst_frame1_bit17.Q sg13g2_a21oi_1
X_4577_ _0331_ VPWR _0332_ VGND Tile_X0Y0_DSP_top.Inst_DSP_top_ConfigMem.Inst_frame3_bit8.Q
+ Tile_X0Y0_E6END[1] sg13g2_o21ai_1
X_4715_ Tile_X0Y0_DSP_top.Inst_DSP_top_switch_matrix.E2BEG3 _0461_ _0463_ _0459_ _0452_
+ VPWR VGND sg13g2_a22oi_1
X_2976_ _0533_ _1188_ _1353_ VPWR VGND sg13g2_nor2_1
X_5764_ Tile_X0Y1_FrameData[23] Tile_X0Y1_FrameStrobe[3] Tile_X0Y1_DSP_bot.Inst_DSP_bot_ConfigMem.Inst_frame3_bit23.Q
+ VPWR VGND sg13g2_dlhq_1
X_5695_ Tile_X0Y1_FrameData[28] Tile_X0Y1_FrameStrobe[1] Tile_X0Y1_DSP_bot.Inst_DSP_bot_ConfigMem.Inst_frame1_bit28.Q
+ VPWR VGND sg13g2_dlhq_1
X_6247_ Tile_X0Y0_DSP_top.Inst_DSP_top_switch_matrix.N2BEGb3 Tile_X0Y0_N2BEGb[3] VPWR
+ VGND sg13g2_buf_1
X_6178_ Tile_X0Y0_DSP_top.Inst_DSP_top_switch_matrix.EE4BEG2 Tile_X0Y0_EE4BEG[14]
+ VPWR VGND sg13g2_buf_1
X_6316_ Tile_X0Y0_DSP_top.Inst_DSP_top_switch_matrix.W6BEG1 Tile_X0Y0_W6BEG[11] VPWR
+ VGND sg13g2_buf_1
X_3459_ Tile_X0Y1_DSP_bot.Inst_DSP_bot_ConfigMem.Inst_frame8_bit14.Q _1812_ _1815_
+ _1816_ VPWR VGND sg13g2_nor3_1
X_3528_ _1882_ Tile_X0Y1_E2MID[2] Tile_X0Y1_DSP_bot.Inst_DSP_bot_ConfigMem.Inst_frame7_bit18.Q
+ VPWR VGND sg13g2_nand2_1
XFILLER_29_102 VPWR VGND sg13g2_fill_2
X_5129_ _0847_ _0858_ Tile_X0Y0_DSP_top.Inst_DSP_top_switch_matrix.JS2BEG4 VPWR VGND
+ sg13g2_nor2_1
XFILLER_84_230 VPWR VGND sg13g2_fill_2
XFILLER_40_311 VPWR VGND sg13g2_fill_2
XFILLER_105_0 VPWR VGND sg13g2_fill_2
XFILLER_20_72 VPWR VGND sg13g2_fill_2
X_2830_ _1140_ _1138_ _1210_ VPWR VGND sg13g2_xor2_1
X_4500_ Tile_X0Y0_DSP_top.Inst_DSP_top_ConfigMem.Inst_frame4_bit25.Q Tile_X0Y0_DSP_top.Inst_DSP_top_switch_matrix.bot2top4
+ Tile_X0Y0_DSP_top.Inst_DSP_top_switch_matrix.bot2top7 Tile_X0Y0_DSP_top.Inst_DSP_top_switch_matrix.bot2top5
+ Tile_X0Y0_DSP_top.Inst_DSP_top_switch_matrix.bot2top9 Tile_X0Y0_DSP_top.Inst_DSP_top_ConfigMem.Inst_frame4_bit24.Q
+ _0258_ VPWR VGND sg13g2_mux4_1
X_4431_ _0191_ VPWR _0192_ VGND Tile_X0Y0_DSP_top.Inst_DSP_top_ConfigMem.Inst_frame2_bit28.Q
+ _0189_ sg13g2_o21ai_1
X_5480_ Tile_X0Y0_FrameData[5] Tile_X0Y1_FrameStrobe[8] Tile_X0Y0_DSP_top.Inst_DSP_top_ConfigMem.Inst_frame8_bit5.Q
+ VPWR VGND sg13g2_dlhq_1
X_2761_ _1143_ _0939_ _0608_ VPWR VGND sg13g2_nand2b_1
XANTENNA_1 VPWR VGND Tile_X0Y0_E2MID[4] sg13g2_antennanp
X_2692_ VPWR VGND _1075_ _0868_ _1074_ _0074_ _1077_ _0867_ sg13g2_a221oi_1
XFILLER_100_316 VPWR VGND sg13g2_fill_2
X_4293_ VPWR _0056_ Tile_X0Y1_DSP_bot.Inst_DSP_bot_ConfigMem.Inst_frame4_bit27.Q VGND
+ sg13g2_inv_1
X_6101_ VPWR VGND _2499_ sg13g2_tiehi
X_3244_ _0467_ _0422_ Tile_X0Y1_DSP_bot.Inst_DSP_bot_ConfigMem.Inst_frame1_bit20.Q
+ _1612_ VPWR VGND sg13g2_mux2_1
X_3313_ _0092_ _1672_ _1679_ VPWR VGND sg13g2_nor2_1
X_6032_ Tile_X0Y1_FrameData[11] Tile_X0Y1_FrameStrobe[11] Tile_X0Y1_DSP_bot.Inst_DSP_bot_ConfigMem.Inst_frame11_bit11.Q
+ VPWR VGND sg13g2_dlhq_1
X_4362_ VPWR _0125_ Tile_X0Y1_DSP_bot.Inst_DSP_bot_switch_matrix.Q5 VGND sg13g2_inv_1
X_3175_ VGND VPWR Tile_X0Y0_DSP_top.Inst_DSP_top_ConfigMem.Inst_frame7_bit19.Q _1547_
+ _1548_ Tile_X0Y0_DSP_top.Inst_DSP_top_ConfigMem.Inst_frame8_bit13.Q sg13g2_a21oi_1
XFILLER_20_0 VPWR VGND sg13g2_fill_1
X_2959_ _1336_ _0682_ _1307_ VPWR VGND sg13g2_nand2_1
X_5816_ Tile_X0Y1_FrameData[3] Tile_X0Y1_FrameStrobe[4] Tile_X0Y1_DSP_bot.Inst_DSP_bot_ConfigMem.Inst_frame4_bit3.Q
+ VPWR VGND sg13g2_dlhq_1
X_5747_ Tile_X0Y1_FrameData[8] Tile_X0Y1_FrameStrobe[2] Tile_X0Y1_DSP_bot.Inst_DSP_bot_ConfigMem.Inst_frame2_bit8.Q
+ VPWR VGND sg13g2_dlhq_1
XFILLER_89_311 VPWR VGND sg13g2_fill_1
X_4629_ _0381_ VPWR _0382_ VGND Tile_X0Y1_E1END[2] Tile_X0Y1_DSP_bot.Inst_DSP_bot_ConfigMem.Inst_frame4_bit12.Q
+ sg13g2_o21ai_1
X_5678_ Tile_X0Y1_FrameData[13] Tile_X0Y1_FrameStrobe[0] Tile_X0Y1_DSP_bot.Inst_DSP_bot_ConfigMem.Inst_frame0_bit13.Q
+ VPWR VGND sg13g2_dlhq_1
XFILLER_40_152 VPWR VGND sg13g2_fill_2
XFILLER_15_94 VPWR VGND sg13g2_decap_4
X_3931_ Tile_X0Y0_S1END[3] Tile_X0Y0_DSP_top.Inst_DSP_top_switch_matrix.bot2top3 Tile_X0Y0_DSP_top.Inst_DSP_top_ConfigMem.Inst_frame11_bit17.Q
+ _2227_ VPWR VGND sg13g2_mux2_1
X_5601_ Tile_X0Y0_FrameData[12] Tile_X0Y1_FrameStrobe[12] Tile_X0Y0_DSP_top.Inst_DSP_top_ConfigMem.Inst_frame12_bit12.Q
+ VPWR VGND sg13g2_dlhq_1
X_3862_ Tile_X0Y0_DSP_top.Inst_DSP_top_ConfigMem.Inst_frame12_bit18.Q Tile_X0Y1_N2MID[2]
+ Tile_X0Y1_N4END[5] Tile_X0Y0_E6END[1] Tile_X0Y0_DSP_top.Inst_DSP_top_switch_matrix.bot2top4
+ Tile_X0Y0_DSP_top.Inst_DSP_top_ConfigMem.Inst_frame12_bit19.Q Tile_X0Y0_DSP_top.Inst_DSP_top_switch_matrix.N4BEG0
+ VPWR VGND sg13g2_mux4_1
XFILLER_82_2 VPWR VGND sg13g2_fill_1
X_4980_ Tile_X0Y0_W2END[1] Tile_X0Y0_W6END[1] Tile_X0Y0_DSP_top.Inst_DSP_top_ConfigMem.Inst_frame2_bit0.Q
+ _0717_ VPWR VGND sg13g2_mux2_1
XFILLER_63_277 VPWR VGND sg13g2_fill_2
X_2813_ _1190_ VPWR _1193_ VGND _1191_ _1192_ sg13g2_o21ai_1
XFILLER_23_108 VPWR VGND sg13g2_fill_2
X_3793_ VPWR VGND Tile_X0Y0_DSP_top.Inst_DSP_top_ConfigMem.Inst_frame3_bit30.Q Tile_X0Y0_DSP_top.Inst_DSP_top_ConfigMem.Inst_frame3_bit31.Q
+ _2121_ _2117_ _2122_ _2120_ sg13g2_a221oi_1
X_5394_ Tile_X0Y0_FrameData[27] Tile_X0Y1_FrameStrobe[6] Tile_X0Y0_DSP_top.Inst_DSP_top_ConfigMem.Inst_frame6_bit27.Q
+ VPWR VGND sg13g2_dlhq_1
XFILLER_68_0 VPWR VGND sg13g2_fill_1
X_5532_ Tile_X0Y0_FrameData[17] Tile_X0Y1_FrameStrobe[10] Tile_X0Y0_DSP_top.Inst_DSP_top_ConfigMem.Inst_frame10_bit17.Q
+ VPWR VGND sg13g2_dlhq_1
X_5463_ Tile_X0Y0_FrameData[22] Tile_X0Y1_FrameStrobe[8] Tile_X0Y0_DSP_top.Inst_DSP_top_ConfigMem.Inst_frame8_bit22.Q
+ VPWR VGND sg13g2_dlhq_1
X_2744_ _1126_ Tile_X0Y1_DSP_bot.Inst_DSP_bot_ConfigMem.Inst_frame12_bit1.Q Tile_X0Y1_DSP_bot.Inst_MULADD.B_reg\[2\]
+ VPWR VGND sg13g2_nand2_1
X_2675_ VGND VPWR Tile_X0Y1_DSP_bot.Inst_DSP_bot_ConfigMem.Inst_frame0_bit2.Q _1059_
+ _1061_ _1060_ sg13g2_a21oi_1
X_4414_ Tile_X0Y1_DSP_bot.Inst_DSP_bot_switch_matrix.Q7 Tile_X0Y1_DSP_bot.Inst_DSP_bot_switch_matrix.Q8
+ Tile_X0Y1_DSP_bot.Inst_DSP_bot_ConfigMem.Inst_frame1_bit12.Q _0175_ VPWR VGND sg13g2_mux2_1
XFILLER_86_358 VPWR VGND sg13g2_fill_2
X_4345_ VPWR _0108_ Tile_X0Y1_DSP_bot.Inst_MULADD.C_reg\[13\] VGND sg13g2_inv_1
X_4276_ VPWR _0039_ Tile_X0Y0_S2MID[7] VGND sg13g2_inv_1
X_3227_ VGND VPWR _0091_ _1592_ _1596_ _1595_ sg13g2_a21oi_1
X_6015_ Tile_X0Y1_FrameData[28] Tile_X0Y1_FrameStrobe[11] Tile_X0Y1_DSP_bot.Inst_DSP_bot_ConfigMem.Inst_frame11_bit28.Q
+ VPWR VGND sg13g2_dlhq_1
X_3089_ VGND VPWR Tile_X0Y0_DSP_top.Inst_DSP_top_ConfigMem.Inst_frame1_bit21.Q _1463_
+ _1466_ Tile_X0Y0_DSP_top.Inst_DSP_top_ConfigMem.Inst_frame1_bit22.Q sg13g2_a21oi_1
X_3158_ Tile_X0Y0_DSP_top.Inst_DSP_top_ConfigMem.Inst_frame3_bit23.Q _1529_ _1532_
+ VPWR VGND sg13g2_nor2_1
XFILLER_54_277 VPWR VGND sg13g2_fill_2
XFILLER_10_314 VPWR VGND sg13g2_decap_4
XFILLER_10_358 VPWR VGND sg13g2_fill_2
XFILLER_22_130 VPWR VGND sg13g2_decap_4
XFILLER_93_66 VPWR VGND sg13g2_fill_1
XFILLER_77_78 VPWR VGND sg13g2_fill_2
XFILLER_9_145 VPWR VGND sg13g2_fill_1
XFILLER_9_167 VPWR VGND sg13g2_fill_1
XFILLER_9_189 VPWR VGND sg13g2_decap_8
X_4061_ Tile_X0Y1_DSP_bot.Inst_DSP_bot_ConfigMem.Inst_frame11_bit30.Q Tile_X0Y1_DSP_bot.Inst_DSP_bot_switch_matrix.Q4
+ _0151_ Tile_X0Y1_DSP_bot.Inst_DSP_bot_switch_matrix.E2BEG3 _0171_ Tile_X0Y1_DSP_bot.Inst_DSP_bot_ConfigMem.Inst_frame11_bit31.Q
+ Tile_X0Y1_DSP_bot.Inst_DSP_bot_switch_matrix.S1BEG0 VPWR VGND sg13g2_mux4_1
X_4130_ Tile_X0Y1_DSP_bot.Inst_DSP_bot_ConfigMem.Inst_frame11_bit15.Q VPWR _2383_
+ VGND Tile_X0Y1_DSP_bot.Inst_DSP_bot_ConfigMem.Inst_frame11_bit14.Q _2382_ sg13g2_o21ai_1
XFILLER_91_350 VPWR VGND sg13g2_fill_2
X_3012_ _1389_ _1367_ _1368_ VPWR VGND sg13g2_xnor2_1
X_4963_ VGND VPWR Tile_X0Y1_DSP_bot.Inst_DSP_bot_ConfigMem.Inst_frame1_bit17.Q _0699_
+ _0700_ Tile_X0Y1_DSP_bot.Inst_DSP_bot_ConfigMem.Inst_frame1_bit18.Q sg13g2_a21oi_1
X_3776_ VGND VPWR Tile_X0Y0_EE4END[0] Tile_X0Y0_DSP_top.Inst_DSP_top_ConfigMem.Inst_frame4_bit28.Q
+ _2106_ _2105_ sg13g2_a21oi_1
X_3845_ _2166_ _2159_ _2165_ VPWR VGND sg13g2_nand2_1
X_3914_ Tile_X0Y0_W1END[0] Tile_X0Y0_DSP_top.Inst_DSP_top_switch_matrix.bot2top4 Tile_X0Y0_DSP_top.Inst_DSP_top_ConfigMem.Inst_frame11_bit0.Q
+ _2213_ VPWR VGND sg13g2_mux2_1
X_4894_ VPWR Tile_X0Y0_DSP_top.Inst_DSP_top_switch_matrix.JS2BEG3 _0634_ VGND sg13g2_inv_1
X_2589_ Tile_X0Y0_DSP_top.Inst_DSP_top_switch_matrix.N2BEGb3 Tile_X0Y0_E2MID[3] Tile_X0Y0_DSP_top.Inst_DSP_top_ConfigMem.Inst_frame6_bit2.Q
+ _0978_ VPWR VGND sg13g2_mux2_1
X_5377_ Tile_X0Y0_FrameData[12] Tile_X0Y1_FrameStrobe[5] Tile_X0Y0_DSP_top.Inst_DSP_top_ConfigMem.Inst_frame5_bit12.Q
+ VPWR VGND sg13g2_dlhq_1
X_5515_ Tile_X0Y0_FrameData[2] Tile_X0Y1_FrameStrobe[9] Tile_X0Y0_DSP_top.Inst_DSP_top_ConfigMem.Inst_frame9_bit2.Q
+ VPWR VGND sg13g2_dlhq_1
X_5446_ Tile_X0Y0_FrameData[7] Tile_X0Y1_FrameStrobe[7] Tile_X0Y0_DSP_top.Inst_DSP_top_ConfigMem.Inst_frame7_bit7.Q
+ VPWR VGND sg13g2_dlhq_1
X_2727_ _0084_ _1105_ _1111_ VPWR VGND sg13g2_nor2_1
X_2658_ Tile_X0Y1_DSP_bot.Inst_DSP_bot_switch_matrix.Q3 Tile_X0Y1_DSP_bot.Inst_DSP_bot_switch_matrix.Q4
+ Tile_X0Y1_DSP_bot.Inst_DSP_bot_ConfigMem.Inst_frame3_bit4.Q _1045_ VPWR VGND sg13g2_mux2_1
X_6495_ Tile_X0Y1_DSP_bot.Inst_DSP_bot_switch_matrix.W6BEG0 Tile_X0Y1_W6BEG[10] VPWR
+ VGND sg13g2_buf_1
X_4259_ VPWR _0022_ Tile_X0Y0_S4END[2] VGND sg13g2_inv_1
X_4328_ VPWR _0091_ Tile_X0Y1_DSP_bot.Inst_DSP_bot_ConfigMem.Inst_frame3_bit29.Q VGND
+ sg13g2_inv_1
XFILLER_6_126 VPWR VGND sg13g2_fill_2
XFILLER_88_88 VPWR VGND sg13g2_fill_2
XFILLER_88_55 VPWR VGND sg13g2_fill_2
XFILLER_18_200 VPWR VGND sg13g2_decap_4
X_3630_ Tile_X0Y0_DSP_top.Inst_DSP_top_ConfigMem.Inst_frame3_bit27.Q VPWR _1969_ VGND
+ Tile_X0Y0_DSP_top.Inst_DSP_top_ConfigMem.Inst_frame3_bit26.Q _1967_ sg13g2_o21ai_1
X_6280_ Tile_X0Y0_DSP_top.Inst_DSP_top_switch_matrix.NN4BEG0 Tile_X0Y0_NN4BEG[12]
+ VPWR VGND sg13g2_buf_1
X_5300_ Tile_X0Y0_FrameData[25] Tile_X0Y1_FrameStrobe[3] Tile_X0Y0_DSP_top.Inst_DSP_top_ConfigMem.Inst_frame3_bit25.Q
+ VPWR VGND sg13g2_dlhq_1
X_5231_ Tile_X0Y0_FrameData[30] Tile_X0Y1_FrameStrobe[1] Tile_X0Y0_DSP_top.Inst_DSP_top_ConfigMem.Inst_frame1_bit30.Q
+ VPWR VGND sg13g2_dlhq_1
X_3561_ _1895_ VPWR _1913_ VGND Tile_X0Y1_DSP_bot.Inst_DSP_bot_ConfigMem.Inst_frame12_bit3.Q
+ _1912_ sg13g2_o21ai_1
X_3492_ VGND VPWR Tile_X0Y1_DSP_bot.Inst_DSP_bot_ConfigMem.Inst_frame7_bit22.Q _1629_
+ _1848_ _1847_ sg13g2_a21oi_1
X_5093_ _0054_ _0821_ _0823_ _0824_ VPWR VGND sg13g2_nor3_1
XFILLER_83_136 VPWR VGND sg13g2_fill_1
X_4044_ Tile_X0Y0_DSP_top.Inst_DSP_top_ConfigMem.Inst_frame9_bit22.Q Tile_X0Y0_DSP_top.Inst_DSP_top_switch_matrix.bot2top6
+ Tile_X0Y0_DSP_top.Inst_DSP_top_switch_matrix.bot2top7 Tile_X0Y0_DSP_top.Inst_DSP_top_switch_matrix.bot2top8
+ Tile_X0Y0_DSP_top.Inst_DSP_top_switch_matrix.bot2top9 Tile_X0Y0_DSP_top.Inst_DSP_top_ConfigMem.Inst_frame9_bit23.Q
+ _2326_ VPWR VGND sg13g2_mux4_1
X_5162_ Tile_X0Y1_DSP_bot.Inst_DSP_bot_ConfigMem.Inst_frame2_bit7.Q _0889_ _0890_
+ VPWR VGND sg13g2_nor2_1
X_4113_ Tile_X0Y1_DSP_bot.Inst_DSP_bot_ConfigMem.Inst_frame12_bit25.Q Tile_X0Y1_N1END[3]
+ Tile_X0Y1_E1END[3] Tile_X0Y1_W1END[3] Tile_X0Y1_DSP_bot.Inst_DSP_bot_switch_matrix.Q3
+ Tile_X0Y1_DSP_bot.Inst_DSP_bot_ConfigMem.Inst_frame12_bit26.Q _2370_ VPWR VGND sg13g2_mux4_1
X_4946_ VPWR _0683_ _0682_ VGND sg13g2_inv_1
XFILLER_33_39 VPWR VGND sg13g2_fill_2
XFILLER_24_247 VPWR VGND sg13g2_decap_4
X_5995_ Tile_X0Y1_FrameData[16] Tile_X0Y1_FrameStrobe[10] Tile_X0Y1_DSP_bot.Inst_DSP_bot_ConfigMem.Inst_frame10_bit16.Q
+ VPWR VGND sg13g2_dlhq_1
X_3828_ _2149_ VPWR _2150_ VGND Tile_X0Y0_W1END[0] Tile_X0Y0_DSP_top.Inst_DSP_top_ConfigMem.Inst_frame2_bit20.Q
+ sg13g2_o21ai_1
X_3759_ _2088_ VPWR _2089_ VGND Tile_X0Y0_DSP_top.Inst_DSP_top_ConfigMem.Inst_frame1_bit29.Q
+ _2087_ sg13g2_o21ai_1
X_4877_ Tile_X0Y0_DSP_top.Inst_DSP_top_ConfigMem.Inst_frame9_bit31.Q VPWR _0618_ VGND
+ _0612_ _0615_ sg13g2_o21ai_1
XFILLER_109_7 VPWR VGND sg13g2_decap_8
X_5429_ Tile_X0Y0_FrameData[24] Tile_X0Y1_FrameStrobe[7] Tile_X0Y0_DSP_top.Inst_DSP_top_ConfigMem.Inst_frame7_bit24.Q
+ VPWR VGND sg13g2_dlhq_1
XFILLER_58_47 VPWR VGND sg13g2_fill_1
X_6478_ Tile_X0Y1_W2MID[1] Tile_X0Y1_W2BEGb[1] VPWR VGND sg13g2_buf_1
XFILLER_74_169 VPWR VGND sg13g2_decap_4
XFILLER_74_136 VPWR VGND sg13g2_decap_8
XFILLER_15_225 VPWR VGND sg13g2_decap_4
XFILLER_109_341 VPWR VGND sg13g2_fill_2
XFILLER_61_320 VPWR VGND sg13g2_fill_2
X_2992_ _1369_ _1368_ _1367_ VPWR VGND sg13g2_nand2b_1
X_4800_ _0544_ _0543_ Tile_X0Y1_DSP_bot.Inst_DSP_bot_ConfigMem.Inst_frame4_bit2.Q
+ VPWR VGND sg13g2_nand2b_1
X_5780_ Tile_X0Y1_FrameData[7] Tile_X0Y1_FrameStrobe[3] Tile_X0Y1_DSP_bot.Inst_DSP_bot_ConfigMem.Inst_frame3_bit7.Q
+ VPWR VGND sg13g2_dlhq_1
X_4593_ VGND VPWR Tile_X0Y0_DSP_top.Inst_DSP_top_ConfigMem.Inst_frame4_bit5.Q _0345_
+ _0347_ _0346_ sg13g2_a21oi_1
X_4662_ _0413_ Tile_X0Y0_DSP_top.Inst_DSP_top_ConfigMem.Inst_frame3_bit7.Q _0414_
+ VPWR VGND sg13g2_nor2b_1
X_6401_ Tile_X0Y1_FrameData[20] Tile_X0Y1_FrameData_O[20] VPWR VGND sg13g2_buf_1
X_4731_ Tile_X0Y1_DSP_bot.Inst_DSP_bot_ConfigMem.Inst_frame4_bit29.Q VPWR _0479_ VGND
+ Tile_X0Y1_DSP_bot.Inst_DSP_bot_ConfigMem.Inst_frame4_bit28.Q Tile_X0Y1_DSP_bot.Inst_DSP_bot_switch_matrix.Q6
+ sg13g2_o21ai_1
X_3613_ _1956_ Tile_X0Y1_DSP_bot.Inst_MULADD.ACC\[9\] Tile_X0Y1_DSP_bot.Inst_DSP_bot_ConfigMem.Inst_frame12_bit5.Q
+ Tile_X0Y1_DSP_bot.Inst_DSP_bot_switch_matrix.Q9 VPWR VGND sg13g2_mux2_1
X_6194_ Tile_X0Y0_FrameData[14] Tile_X0Y0_FrameData_O[14] VPWR VGND sg13g2_buf_1
XFILLER_88_239 VPWR VGND sg13g2_fill_2
X_5214_ Tile_X0Y0_FrameData[15] Tile_X0Y1_FrameStrobe[0] Tile_X0Y0_DSP_top.Inst_DSP_top_ConfigMem.Inst_frame0_bit15.Q
+ VPWR VGND sg13g2_dlhq_1
X_6332_ Tile_X0Y0_DSP_top.Inst_DSP_top_switch_matrix.WW4BEG3 Tile_X0Y0_WW4BEG[15]
+ VPWR VGND sg13g2_buf_1
XFILLER_50_0 VPWR VGND sg13g2_decap_8
X_3475_ VGND VPWR _1832_ _1831_ _1829_ sg13g2_or2_1
X_3544_ Tile_X0Y1_DSP_bot.Inst_DSP_bot_ConfigMem.Inst_frame0_bit16.Q Tile_X0Y1_N4END[3]
+ _1897_ VPWR VGND sg13g2_nor2b_1
X_6263_ Tile_X0Y0_DSP_top.N4BEG_outbuf_11.A Tile_X0Y0_N4BEG[11] VPWR VGND sg13g2_buf_1
X_4027_ Tile_X0Y0_DSP_top.Inst_DSP_top_ConfigMem.Inst_frame9_bit16.Q _0237_ Tile_X0Y0_W1END[1]
+ Tile_X0Y0_S1END[1] Tile_X0Y0_DSP_top.Inst_DSP_top_switch_matrix.bot2top5 Tile_X0Y0_DSP_top.Inst_DSP_top_ConfigMem.Inst_frame9_bit15.Q
+ _2311_ VPWR VGND sg13g2_mux4_1
X_5076_ Tile_X0Y0_DSP_top.Inst_DSP_top_ConfigMem.Inst_frame7_bit15.Q VPWR _0808_ VGND
+ Tile_X0Y0_DSP_top.Inst_DSP_top_ConfigMem.Inst_frame7_bit14.Q Tile_X0Y0_W2MID[0]
+ sg13g2_o21ai_1
XFILLER_71_117 VPWR VGND sg13g2_fill_1
X_5145_ Tile_X0Y1_DSP_bot.Inst_DSP_bot_switch_matrix.JS2BEG3 Tile_X0Y1_DSP_bot.Inst_DSP_bot_ConfigMem.Inst_frame7_bit4.Q
+ _0872_ _0873_ VPWR VGND sg13g2_a21o_1
XFILLER_100_22 VPWR VGND sg13g2_fill_2
X_4929_ Tile_X0Y0_DSP_top.Inst_DSP_top_ConfigMem.Inst_frame0_bit20.Q Tile_X0Y1_N4END[5]
+ Tile_X0Y0_SS4END[1] Tile_X0Y0_W2END[4] Tile_X0Y0_DSP_top.Inst_DSP_top_switch_matrix.JS2BEG3
+ Tile_X0Y0_DSP_top.Inst_DSP_top_ConfigMem.Inst_frame0_bit21.Q _0668_ VPWR VGND sg13g2_mux4_1
X_5978_ Tile_X0Y1_FrameData[1] Tile_X0Y1_FrameStrobe[9] Tile_X0Y1_DSP_bot.Inst_DSP_bot_ConfigMem.Inst_frame9_bit1.Q
+ VPWR VGND sg13g2_dlhq_1
XFILLER_109_97 VPWR VGND sg13g2_fill_1
XFILLER_79_217 VPWR VGND sg13g2_fill_1
X_3260_ _1627_ Tile_X0Y1_DSP_bot.Inst_DSP_bot_ConfigMem.Inst_frame1_bit23.Q _1628_
+ VPWR VGND sg13g2_nor2b_1
X_3191_ VGND VPWR Tile_X0Y0_DSP_top.Inst_DSP_top_ConfigMem.Inst_frame0_bit17.Q _1559_
+ _1563_ _1562_ sg13g2_a21oi_1
X_5901_ Tile_X0Y1_FrameData[14] Tile_X0Y1_FrameStrobe[7] Tile_X0Y1_DSP_bot.Inst_DSP_bot_ConfigMem.Inst_frame7_bit14.Q
+ VPWR VGND sg13g2_dlhq_1
XFILLER_98_0 VPWR VGND sg13g2_decap_4
X_4714_ VGND VPWR Tile_X0Y0_DSP_top.Inst_DSP_top_ConfigMem.Inst_frame3_bit14.Q _0462_
+ _0463_ Tile_X0Y0_DSP_top.Inst_DSP_top_ConfigMem.Inst_frame3_bit15.Q sg13g2_a21oi_1
X_5763_ Tile_X0Y1_FrameData[24] Tile_X0Y1_FrameStrobe[3] Tile_X0Y1_DSP_bot.Inst_DSP_bot_ConfigMem.Inst_frame3_bit24.Q
+ VPWR VGND sg13g2_dlhq_1
X_2975_ _0969_ _1260_ _1352_ VPWR VGND sg13g2_nor2_1
X_5832_ Tile_X0Y1_FrameData[19] Tile_X0Y1_FrameStrobe[5] Tile_X0Y1_DSP_bot.Inst_DSP_bot_ConfigMem.Inst_frame5_bit19.Q
+ VPWR VGND sg13g2_dlhq_1
X_4645_ _0390_ Tile_X0Y0_DSP_top.Inst_DSP_top_ConfigMem.Inst_frame1_bit19.Q _0397_
+ VPWR VGND sg13g2_nor2b_1
X_4576_ VGND VPWR Tile_X0Y0_DSP_top.Inst_DSP_top_ConfigMem.Inst_frame3_bit8.Q _0035_
+ _0331_ Tile_X0Y0_DSP_top.Inst_DSP_top_ConfigMem.Inst_frame3_bit9.Q sg13g2_a21oi_1
X_6315_ Tile_X0Y0_DSP_top.Inst_DSP_top_switch_matrix.W6BEG0 Tile_X0Y0_W6BEG[10] VPWR
+ VGND sg13g2_buf_1
X_5694_ Tile_X0Y1_FrameData[29] Tile_X0Y1_FrameStrobe[1] Tile_X0Y1_DSP_bot.Inst_DSP_bot_ConfigMem.Inst_frame1_bit29.Q
+ VPWR VGND sg13g2_dlhq_1
X_3527_ _1880_ VPWR _1881_ VGND _0106_ Tile_X0Y1_DSP_bot.Inst_DSP_bot_switch_matrix.E2BEG5
+ sg13g2_o21ai_1
X_6246_ Tile_X0Y0_DSP_top.Inst_DSP_top_switch_matrix.N2BEGb2 Tile_X0Y0_N2BEGb[2] VPWR
+ VGND sg13g2_buf_1
X_5128_ Tile_X0Y0_DSP_top.Inst_DSP_top_ConfigMem.Inst_frame2_bit19.Q _0852_ _0857_
+ _0858_ VPWR VGND sg13g2_nor3_1
XFILLER_103_347 VPWR VGND sg13g2_fill_1
X_6177_ Tile_X0Y0_DSP_top.Inst_DSP_top_switch_matrix.EE4BEG1 Tile_X0Y0_EE4BEG[13]
+ VPWR VGND sg13g2_buf_1
X_3458_ Tile_X0Y1_DSP_bot.Inst_DSP_bot_ConfigMem.Inst_frame7_bit25.Q _1813_ _1814_
+ _1815_ VPWR VGND sg13g2_nor3_1
X_3389_ Tile_X0Y1_DSP_bot.Inst_DSP_bot_ConfigMem.Inst_frame8_bit22.Q VPWR _1750_ VGND
+ Tile_X0Y1_DSP_bot.Inst_DSP_bot_ConfigMem.Inst_frame8_bit24.Q Tile_X0Y0_DSP_top.Inst_DSP_top_switch_matrix.N2BEGb6
+ sg13g2_o21ai_1
X_5059_ VGND VPWR Tile_X0Y0_DSP_top.Inst_DSP_top_ConfigMem.Inst_frame1_bit8.Q _0132_
+ _0792_ _0791_ sg13g2_a21oi_1
XFILLER_29_158 VPWR VGND sg13g2_decap_4
XFILLER_52_194 VPWR VGND sg13g2_fill_2
XFILLER_75_275 VPWR VGND sg13g2_fill_1
XFILLER_90_289 VPWR VGND sg13g2_fill_1
X_4430_ VGND VPWR _0031_ Tile_X0Y0_DSP_top.Inst_DSP_top_ConfigMem.Inst_frame2_bit28.Q
+ _0191_ Tile_X0Y0_DSP_top.Inst_DSP_top_ConfigMem.Inst_frame2_bit29.Q sg13g2_a21oi_1
X_2760_ _1141_ _1017_ _1142_ VPWR VGND sg13g2_nor2b_1
XANTENNA_2 VPWR VGND Tile_X0Y0_E2MID[4] sg13g2_antennanp
X_2691_ _1076_ _1074_ _1075_ VPWR VGND sg13g2_nand2_1
XFILLER_6_53 VPWR VGND sg13g2_decap_4
XFILLER_98_312 VPWR VGND sg13g2_fill_2
X_4292_ VPWR _0055_ Tile_X0Y1_W1END[3] VGND sg13g2_inv_1
X_6100_ VPWR VGND _2498_ sg13g2_tiehi
X_3312_ _1677_ VPWR _1678_ VGND Tile_X0Y1_DSP_bot.Inst_DSP_bot_ConfigMem.Inst_frame2_bit21.Q
+ _1674_ sg13g2_o21ai_1
X_6031_ Tile_X0Y1_FrameData[12] Tile_X0Y1_FrameStrobe[11] Tile_X0Y1_DSP_bot.Inst_DSP_bot_ConfigMem.Inst_frame11_bit12.Q
+ VPWR VGND sg13g2_dlhq_1
X_3243_ _1610_ VPWR _1611_ VGND Tile_X0Y1_DSP_bot.Inst_DSP_bot_ConfigMem.Inst_frame8_bit25.Q
+ Tile_X0Y1_DSP_bot.Inst_DSP_bot_switch_matrix.E2BEG5 sg13g2_o21ai_1
XFILLER_3_290 VPWR VGND sg13g2_fill_1
X_4361_ VPWR _0124_ Tile_X0Y1_DSP_bot.Inst_DSP_bot_ConfigMem.Inst_frame9_bit20.Q VGND
+ sg13g2_inv_1
X_3174_ VGND VPWR Tile_X0Y0_DSP_top.Inst_DSP_top_ConfigMem.Inst_frame7_bit18.Q Tile_X0Y0_DSP_top.Inst_DSP_top_switch_matrix.E2BEG5
+ _1547_ _1546_ sg13g2_a21oi_1
X_2958_ _1328_ VPWR _1335_ VGND _1325_ _1329_ sg13g2_o21ai_1
X_5815_ Tile_X0Y1_FrameData[4] Tile_X0Y1_FrameStrobe[4] Tile_X0Y1_DSP_bot.Inst_DSP_bot_ConfigMem.Inst_frame4_bit4.Q
+ VPWR VGND sg13g2_dlhq_1
X_5746_ Tile_X0Y1_FrameData[9] Tile_X0Y1_FrameStrobe[2] Tile_X0Y1_DSP_bot.Inst_DSP_bot_ConfigMem.Inst_frame2_bit9.Q
+ VPWR VGND sg13g2_dlhq_1
X_5677_ Tile_X0Y1_FrameData[14] Tile_X0Y1_FrameStrobe[0] Tile_X0Y1_DSP_bot.Inst_DSP_bot_ConfigMem.Inst_frame0_bit14.Q
+ VPWR VGND sg13g2_dlhq_1
X_2889_ _1208_ _1207_ _1267_ VPWR VGND sg13g2_xor2_1
X_4559_ _0314_ _0312_ _0313_ VPWR VGND sg13g2_nand2b_1
X_4628_ _0381_ Tile_X0Y1_DSP_bot.Inst_DSP_bot_ConfigMem.Inst_frame4_bit12.Q Tile_X0Y1_E2END[4]
+ VPWR VGND sg13g2_nand2b_1
X_6229_ Tile_X0Y1_FrameStrobe[17] Tile_X0Y0_FrameStrobe_O[17] VPWR VGND sg13g2_buf_1
XFILLER_57_253 VPWR VGND sg13g2_fill_2
XFILLER_57_242 VPWR VGND sg13g2_fill_1
XFILLER_17_117 VPWR VGND sg13g2_fill_1
X_3930_ _2225_ VPWR _2226_ VGND Tile_X0Y0_DSP_top.Inst_DSP_top_ConfigMem.Inst_frame11_bit17.Q
+ _0294_ sg13g2_o21ai_1
XFILLER_95_359 VPWR VGND sg13g2_fill_2
X_3792_ Tile_X0Y0_DSP_top.Inst_DSP_top_ConfigMem.Inst_frame3_bit28.Q Tile_X0Y0_S1END[0]
+ Tile_X0Y0_S1END[2] Tile_X0Y0_SS4END[0] Tile_X0Y0_WW4END[0] Tile_X0Y0_DSP_top.Inst_DSP_top_ConfigMem.Inst_frame3_bit29.Q
+ _2121_ VPWR VGND sg13g2_mux4_1
X_5600_ Tile_X0Y0_FrameData[13] Tile_X0Y1_FrameStrobe[12] Tile_X0Y0_DSP_top.Inst_DSP_top_ConfigMem.Inst_frame12_bit13.Q
+ VPWR VGND sg13g2_dlhq_1
X_5531_ Tile_X0Y0_FrameData[18] Tile_X0Y1_FrameStrobe[10] Tile_X0Y0_DSP_top.Inst_DSP_top_ConfigMem.Inst_frame10_bit18.Q
+ VPWR VGND sg13g2_dlhq_1
X_3861_ Tile_X0Y0_DSP_top.Inst_DSP_top_ConfigMem.Inst_frame12_bit16.Q Tile_X0Y0_DSP_top.Inst_DSP_top_switch_matrix.bot2top5
+ _0433_ Tile_X0Y0_DSP_top.Inst_DSP_top_switch_matrix.JW2BEG2 _0357_ Tile_X0Y0_DSP_top.Inst_DSP_top_ConfigMem.Inst_frame12_bit17.Q
+ Tile_X0Y0_DSP_top.Inst_DSP_top_switch_matrix.N1BEG3 VPWR VGND sg13g2_mux4_1
X_2812_ _1192_ _1077_ _1189_ VPWR VGND sg13g2_xnor2_1
X_2743_ VPWR Tile_X0Y1_DSP_bot.B2 _1125_ VGND sg13g2_inv_1
X_5462_ Tile_X0Y0_FrameData[23] Tile_X0Y1_FrameStrobe[8] Tile_X0Y0_DSP_top.Inst_DSP_top_ConfigMem.Inst_frame8_bit23.Q
+ VPWR VGND sg13g2_dlhq_1
X_5393_ Tile_X0Y0_FrameData[28] Tile_X0Y1_FrameStrobe[6] Tile_X0Y0_DSP_top.Inst_DSP_top_ConfigMem.Inst_frame6_bit28.Q
+ VPWR VGND sg13g2_dlhq_1
XFILLER_8_360 VPWR VGND sg13g2_fill_1
X_2674_ Tile_X0Y1_DSP_bot.Inst_DSP_bot_ConfigMem.Inst_frame0_bit3.Q VPWR _1060_ VGND
+ Tile_X0Y1_W2END[7] Tile_X0Y1_DSP_bot.Inst_DSP_bot_ConfigMem.Inst_frame0_bit2.Q sg13g2_o21ai_1
X_4413_ _0125_ _0126_ Tile_X0Y1_DSP_bot.Inst_DSP_bot_ConfigMem.Inst_frame1_bit12.Q
+ _0174_ VPWR VGND sg13g2_mux2_1
X_4344_ VPWR _0107_ Tile_X0Y1_DSP_bot.Inst_DSP_bot_ConfigMem.Inst_frame8_bit6.Q VGND
+ sg13g2_inv_1
X_3157_ _1531_ _1530_ Tile_X0Y0_DSP_top.Inst_DSP_top_ConfigMem.Inst_frame3_bit22.Q
+ VPWR VGND sg13g2_nand2b_1
X_4275_ VPWR _0038_ Tile_X0Y1_DSP_bot.Inst_DSP_bot_ConfigMem.Inst_frame4_bit31.Q VGND
+ sg13g2_inv_1
X_3226_ Tile_X0Y1_DSP_bot.Inst_DSP_bot_ConfigMem.Inst_frame3_bit30.Q VPWR _1595_ VGND
+ _1593_ _1594_ sg13g2_o21ai_1
X_6014_ Tile_X0Y1_FrameData[29] Tile_X0Y1_FrameStrobe[11] Tile_X0Y1_DSP_bot.Inst_DSP_bot_ConfigMem.Inst_frame11_bit29.Q
+ VPWR VGND sg13g2_dlhq_1
X_3088_ VGND VPWR Tile_X0Y0_DSP_top.Inst_DSP_top_ConfigMem.Inst_frame1_bit20.Q _0133_
+ _1465_ _1464_ sg13g2_a21oi_1
XFILLER_108_203 VPWR VGND sg13g2_decap_4
X_5729_ Tile_X0Y1_FrameData[26] Tile_X0Y1_FrameStrobe[2] Tile_X0Y1_DSP_bot.Inst_DSP_bot_ConfigMem.Inst_frame2_bit26.Q
+ VPWR VGND sg13g2_dlhq_1
XFILLER_22_153 VPWR VGND sg13g2_fill_2
XFILLER_89_131 VPWR VGND sg13g2_fill_2
XFILLER_77_359 VPWR VGND sg13g2_fill_2
XFILLER_45_278 VPWR VGND sg13g2_fill_2
XFILLER_60_215 VPWR VGND sg13g2_fill_2
XFILLER_13_197 VPWR VGND sg13g2_fill_2
XFILLER_54_7 VPWR VGND sg13g2_decap_4
XFILLER_68_359 VPWR VGND sg13g2_fill_2
X_3011_ VGND VPWR _1386_ _1387_ _1388_ _1385_ sg13g2_a21oi_1
X_4060_ Tile_X0Y1_DSP_bot.Inst_DSP_bot_ConfigMem.Inst_frame11_bit8.Q Tile_X0Y1_DSP_bot.Inst_DSP_bot_switch_matrix.Q6
+ _0288_ Tile_X0Y0_DSP_top.Inst_DSP_top_switch_matrix.N2BEGb2 _0274_ Tile_X0Y1_DSP_bot.Inst_DSP_bot_ConfigMem.Inst_frame11_bit9.Q
+ Tile_X0Y1_DSP_bot.Inst_DSP_bot_switch_matrix.E1BEG3 VPWR VGND sg13g2_mux4_1
X_3913_ _2211_ VPWR _2212_ VGND Tile_X0Y0_DSP_top.Inst_DSP_top_ConfigMem.Inst_frame11_bit0.Q
+ _0189_ sg13g2_o21ai_1
X_4893_ _0633_ VPWR _0634_ VGND _0623_ _0628_ sg13g2_o21ai_1
X_4962_ Tile_X0Y1_DSP_bot.Inst_DSP_bot_switch_matrix.Q2 Tile_X0Y1_DSP_bot.Inst_DSP_bot_switch_matrix.Q3
+ Tile_X0Y1_DSP_bot.Inst_DSP_bot_ConfigMem.Inst_frame1_bit16.Q _0699_ VPWR VGND sg13g2_mux2_1
X_3775_ Tile_X0Y0_DSP_top.Inst_DSP_top_ConfigMem.Inst_frame4_bit29.Q VPWR _2105_ VGND
+ _0021_ Tile_X0Y0_DSP_top.Inst_DSP_top_ConfigMem.Inst_frame4_bit28.Q sg13g2_o21ai_1
X_3844_ VGND VPWR _2161_ _2164_ _2165_ Tile_X0Y0_DSP_top.Inst_DSP_top_ConfigMem.Inst_frame1_bit3.Q
+ sg13g2_a21oi_1
X_5514_ Tile_X0Y0_FrameData[3] Tile_X0Y1_FrameStrobe[9] Tile_X0Y0_DSP_top.Inst_DSP_top_ConfigMem.Inst_frame9_bit3.Q
+ VPWR VGND sg13g2_dlhq_1
X_2726_ _1109_ VPWR _1110_ VGND Tile_X0Y1_DSP_bot.Inst_DSP_bot_ConfigMem.Inst_frame2_bit17.Q
+ _1106_ sg13g2_o21ai_1
X_6494_ Tile_X0Y1_W6END[11] Tile_X0Y1_W6BEG[9] VPWR VGND sg13g2_buf_1
XFILLER_22_19 VPWR VGND sg13g2_fill_1
X_5445_ Tile_X0Y0_FrameData[8] Tile_X0Y1_FrameStrobe[7] Tile_X0Y0_DSP_top.Inst_DSP_top_ConfigMem.Inst_frame7_bit8.Q
+ VPWR VGND sg13g2_dlhq_1
X_2588_ _0975_ _0976_ Tile_X0Y0_DSP_top.Inst_DSP_top_ConfigMem.Inst_frame6_bit3.Q
+ _0977_ VPWR VGND sg13g2_nand3_1
X_5376_ Tile_X0Y0_FrameData[13] Tile_X0Y1_FrameStrobe[5] Tile_X0Y0_DSP_top.Inst_DSP_top_ConfigMem.Inst_frame5_bit13.Q
+ VPWR VGND sg13g2_dlhq_1
X_4327_ VPWR _0090_ Tile_X0Y1_DSP_bot.Inst_MULADD.C_reg\[10\] VGND sg13g2_inv_1
XFILLER_59_337 VPWR VGND sg13g2_fill_1
XFILLER_59_326 VPWR VGND sg13g2_fill_1
XFILLER_59_315 VPWR VGND sg13g2_fill_1
X_2657_ Tile_X0Y1_DSP_bot.Inst_DSP_bot_switch_matrix.E2BEG3 _1038_ _1044_ _1032_ _1025_
+ VPWR VGND sg13g2_a22oi_1
X_3209_ _1579_ VPWR _1580_ VGND Tile_X0Y0_DSP_top.Inst_DSP_top_ConfigMem.Inst_frame8_bit10.Q
+ _1578_ sg13g2_o21ai_1
X_4258_ VPWR _0021_ Tile_X0Y0_E1END[0] VGND sg13g2_inv_1
X_4189_ Tile_X0Y1_DSP_bot.Inst_DSP_bot_ConfigMem.Inst_frame9_bit9.Q Tile_X0Y1_N1END[0]
+ Tile_X0Y1_W1END[0] _0467_ Tile_X0Y1_DSP_bot.Inst_DSP_bot_switch_matrix.Q4 Tile_X0Y1_DSP_bot.Inst_DSP_bot_ConfigMem.Inst_frame9_bit8.Q
+ _2431_ VPWR VGND sg13g2_mux4_1
XFILLER_2_322 VPWR VGND sg13g2_fill_1
XFILLER_12_96 VPWR VGND sg13g2_fill_2
XFILLER_77_101 VPWR VGND sg13g2_fill_2
X_3560_ VGND VPWR _0072_ Tile_X0Y1_DSP_bot.C0 _1912_ _1911_ sg13g2_a21oi_1
X_5230_ Tile_X0Y0_FrameData[31] Tile_X0Y1_FrameStrobe[1] Tile_X0Y0_DSP_top.Inst_DSP_top_ConfigMem.Inst_frame1_bit31.Q
+ VPWR VGND sg13g2_dlhq_1
X_5161_ VGND VPWR Tile_X0Y1_DSP_bot.Inst_DSP_bot_ConfigMem.Inst_frame2_bit5.Q _0887_
+ _0889_ _0888_ sg13g2_a21oi_1
X_3491_ Tile_X0Y1_DSP_bot.Inst_DSP_bot_ConfigMem.Inst_frame7_bit23.Q VPWR _1847_ VGND
+ Tile_X0Y1_W2MID[0] Tile_X0Y1_DSP_bot.Inst_DSP_bot_ConfigMem.Inst_frame7_bit22.Q
+ sg13g2_o21ai_1
XFILLER_110_286 VPWR VGND sg13g2_fill_1
XFILLER_110_231 VPWR VGND sg13g2_decap_4
X_5092_ VGND VPWR Tile_X0Y0_DSP_top.Inst_DSP_top_ConfigMem.Inst_frame2_bit8.Q Tile_X0Y0_DSP_top.Inst_DSP_top_switch_matrix.bot2top9
+ _0823_ _0822_ sg13g2_a21oi_1
X_4043_ VGND VPWR Tile_X0Y0_DSP_top.Inst_DSP_top_ConfigMem.Inst_frame9_bit23.Q _2323_
+ _2325_ _2324_ sg13g2_a21oi_1
X_4112_ Tile_X0Y1_DSP_bot.Inst_DSP_bot_ConfigMem.Inst_frame12_bit25.Q Tile_X0Y1_DSP_bot.Inst_DSP_bot_switch_matrix.Q7
+ _0875_ _1122_ _1877_ Tile_X0Y1_DSP_bot.Inst_DSP_bot_ConfigMem.Inst_frame12_bit26.Q
+ _2369_ VPWR VGND sg13g2_mux4_1
X_4876_ Tile_X0Y0_DSP_top.Inst_DSP_top_ConfigMem.Inst_frame9_bit30.Q _0616_ _0617_
+ VPWR VGND sg13g2_nor2_1
X_4945_ Tile_X0Y1_DSP_bot.Inst_MULADD.A_reg\[6\] Tile_X0Y0_DSP_top.Inst_DSP_top_switch_matrix.inst_cus_mux41_buf_top2bot2.X
+ _0073_ _0682_ VPWR VGND sg13g2_mux2_1
X_5994_ Tile_X0Y1_FrameData[17] Tile_X0Y1_FrameStrobe[10] Tile_X0Y1_DSP_bot.Inst_DSP_bot_ConfigMem.Inst_frame10_bit17.Q
+ VPWR VGND sg13g2_dlhq_1
X_3827_ _2149_ Tile_X0Y0_DSP_top.Inst_DSP_top_ConfigMem.Inst_frame2_bit20.Q Tile_X0Y0_W1END[2]
+ VPWR VGND sg13g2_nand2b_1
X_3758_ VGND VPWR Tile_X0Y0_DSP_top.Inst_DSP_top_ConfigMem.Inst_frame1_bit29.Q _2085_
+ _2088_ Tile_X0Y0_DSP_top.Inst_DSP_top_ConfigMem.Inst_frame1_bit30.Q sg13g2_a21oi_1
X_3689_ VGND VPWR _1459_ _1941_ _2024_ _1995_ sg13g2_a21oi_1
X_6477_ Tile_X0Y1_W2MID[0] Tile_X0Y1_W2BEGb[0] VPWR VGND sg13g2_buf_1
X_2709_ _1094_ Tile_X0Y1_DSP_bot.Inst_DSP_bot_ConfigMem.Inst_frame2_bit10.Q _1093_
+ VPWR VGND sg13g2_nand2_1
XFILLER_101_242 VPWR VGND sg13g2_fill_2
X_5428_ Tile_X0Y0_FrameData[25] Tile_X0Y1_FrameStrobe[7] Tile_X0Y0_DSP_top.Inst_DSP_top_ConfigMem.Inst_frame7_bit25.Q
+ VPWR VGND sg13g2_dlhq_1
X_5359_ Tile_X0Y0_FrameData[30] Tile_X0Y1_FrameStrobe[5] Tile_X0Y0_DSP_top.Inst_DSP_top_ConfigMem.Inst_frame5_bit30.Q
+ VPWR VGND sg13g2_dlhq_1
XFILLER_74_25 VPWR VGND sg13g2_fill_2
XFILLER_65_115 VPWR VGND sg13g2_fill_1
XFILLER_0_22 VPWR VGND sg13g2_decap_8
X_2991_ _1368_ _1364_ _1365_ VPWR VGND sg13g2_xnor2_1
X_4730_ _0477_ VPWR _0478_ VGND Tile_X0Y1_DSP_bot.Inst_DSP_bot_ConfigMem.Inst_frame4_bit28.Q
+ Tile_X0Y1_DSP_bot.Inst_DSP_bot_switch_matrix.Q4 sg13g2_o21ai_1
X_6331_ Tile_X0Y0_DSP_top.Inst_DSP_top_switch_matrix.WW4BEG2 Tile_X0Y0_WW4BEG[14]
+ VPWR VGND sg13g2_buf_1
X_4592_ Tile_X0Y0_DSP_top.Inst_DSP_top_ConfigMem.Inst_frame4_bit6.Q VPWR _0346_ VGND
+ Tile_X0Y0_DSP_top.Inst_DSP_top_ConfigMem.Inst_frame4_bit5.Q _0343_ sg13g2_o21ai_1
X_4661_ VGND VPWR Tile_X0Y0_DSP_top.Inst_DSP_top_ConfigMem.Inst_frame3_bit5.Q _0411_
+ _0413_ _0412_ sg13g2_a21oi_1
X_6400_ Tile_X0Y1_FrameData[19] Tile_X0Y1_FrameData_O[19] VPWR VGND sg13g2_buf_1
X_3612_ _1956_ _1932_ _1955_ VPWR VGND sg13g2_xnor2_1
X_3543_ Tile_X0Y1_W2END[3] Tile_X0Y0_DSP_top.Inst_DSP_top_switch_matrix.N2BEGb3 Tile_X0Y1_DSP_bot.Inst_DSP_bot_ConfigMem.Inst_frame0_bit16.Q
+ _1896_ VPWR VGND sg13g2_mux2_1
X_6193_ Tile_X0Y0_FrameData[13] Tile_X0Y0_FrameData_O[13] VPWR VGND sg13g2_buf_1
X_5213_ Tile_X0Y0_FrameData[16] Tile_X0Y1_FrameStrobe[0] Tile_X0Y0_DSP_top.Inst_DSP_top_ConfigMem.Inst_frame0_bit16.Q
+ VPWR VGND sg13g2_dlhq_1
XFILLER_56_104 VPWR VGND sg13g2_fill_1
XFILLER_43_0 VPWR VGND sg13g2_decap_8
X_3474_ Tile_X0Y1_DSP_bot.Inst_DSP_bot_ConfigMem.Inst_frame8_bit15.Q VPWR _1831_ VGND
+ Tile_X0Y1_DSP_bot.Inst_DSP_bot_ConfigMem.Inst_frame8_bit14.Q _1830_ sg13g2_o21ai_1
X_6262_ Tile_X0Y0_DSP_top.N4BEG_outbuf_10.A Tile_X0Y0_N4BEG[10] VPWR VGND sg13g2_buf_1
X_5144_ Tile_X0Y1_DSP_bot.Inst_DSP_bot_ConfigMem.Inst_frame7_bit5.Q VPWR _0872_ VGND
+ Tile_X0Y1_DSP_bot.Inst_DSP_bot_ConfigMem.Inst_frame7_bit4.Q _0076_ sg13g2_o21ai_1
X_4026_ VGND VPWR _2302_ _2304_ Tile_X0Y0_DSP_top.Inst_DSP_top_switch_matrix.WW4BEG2
+ _2310_ sg13g2_a21oi_1
X_5075_ Tile_X0Y0_DSP_top.Inst_DSP_top_ConfigMem.Inst_frame8_bit9.Q VPWR _0807_ VGND
+ Tile_X0Y0_DSP_top.Inst_DSP_top_ConfigMem.Inst_frame8_bit8.Q _0806_ sg13g2_o21ai_1
XFILLER_100_34 VPWR VGND sg13g2_decap_4
X_4928_ _0667_ VPWR Tile_X0Y0_DSP_top.Inst_DSP_top_switch_matrix.E2BEG0 VGND _0647_
+ _0654_ sg13g2_o21ai_1
X_4859_ Tile_X0Y0_DSP_top.Inst_DSP_top_ConfigMem.Inst_frame8_bit0.Q VPWR _0601_ VGND
+ Tile_X0Y0_DSP_top.Inst_DSP_top_ConfigMem.Inst_frame0_bit7.Q _0600_ sg13g2_o21ai_1
XFILLER_20_240 VPWR VGND sg13g2_decap_8
X_5977_ Tile_X0Y1_FrameData[2] Tile_X0Y1_FrameStrobe[9] Tile_X0Y1_DSP_bot.Inst_DSP_bot_ConfigMem.Inst_frame9_bit2.Q
+ VPWR VGND sg13g2_dlhq_1
X_3190_ Tile_X0Y0_DSP_top.Inst_DSP_top_ConfigMem.Inst_frame8_bit10.Q VPWR _1562_ VGND
+ Tile_X0Y0_DSP_top.Inst_DSP_top_ConfigMem.Inst_frame0_bit17.Q _1561_ sg13g2_o21ai_1
X_5900_ Tile_X0Y1_FrameData[15] Tile_X0Y1_FrameStrobe[7] Tile_X0Y1_DSP_bot.Inst_DSP_bot_ConfigMem.Inst_frame7_bit15.Q
+ VPWR VGND sg13g2_dlhq_1
X_4713_ Tile_X0Y0_DSP_top.Inst_DSP_top_ConfigMem.Inst_frame3_bit12.Q Tile_X0Y0_E6END[0]
+ Tile_X0Y0_S2END[4] Tile_X0Y0_W2END[4] Tile_X0Y0_W6END[0] Tile_X0Y0_DSP_top.Inst_DSP_top_ConfigMem.Inst_frame3_bit13.Q
+ _0462_ VPWR VGND sg13g2_mux4_1
XFILLER_61_184 VPWR VGND sg13g2_fill_1
X_2974_ _1351_ _1215_ _1330_ VPWR VGND sg13g2_xnor2_1
X_5762_ Tile_X0Y1_FrameData[25] Tile_X0Y1_FrameStrobe[3] Tile_X0Y1_DSP_bot.Inst_DSP_bot_ConfigMem.Inst_frame3_bit25.Q
+ VPWR VGND sg13g2_dlhq_1
X_5693_ Tile_X0Y1_FrameData[30] Tile_X0Y1_FrameStrobe[1] Tile_X0Y1_DSP_bot.Inst_DSP_bot_ConfigMem.Inst_frame1_bit30.Q
+ VPWR VGND sg13g2_dlhq_1
X_5831_ Tile_X0Y1_FrameData[20] Tile_X0Y1_FrameStrobe[5] Tile_X0Y1_DSP_bot.Inst_DSP_bot_ConfigMem.Inst_frame5_bit20.Q
+ VPWR VGND sg13g2_dlhq_1
X_6245_ Tile_X0Y0_DSP_top.Inst_DSP_top_switch_matrix.N2BEGb1 Tile_X0Y0_N2BEGb[1] VPWR
+ VGND sg13g2_buf_1
X_4644_ VGND VPWR _0396_ _0395_ _0394_ sg13g2_or2_1
X_4575_ VGND VPWR Tile_X0Y0_DSP_top.Inst_DSP_top_ConfigMem.Inst_frame3_bit9.Q _0329_
+ _0330_ Tile_X0Y0_DSP_top.Inst_DSP_top_ConfigMem.Inst_frame3_bit10.Q sg13g2_a21oi_1
X_6314_ Tile_X0Y0_W6END[11] Tile_X0Y0_W6BEG[9] VPWR VGND sg13g2_buf_1
X_3526_ VGND VPWR _1880_ Tile_X0Y0_DSP_top.Inst_DSP_top_switch_matrix.JS2BEG2 Tile_X0Y1_DSP_bot.Inst_DSP_bot_ConfigMem.Inst_frame7_bit18.Q
+ sg13g2_or2_1
X_5058_ Tile_X0Y0_DSP_top.Inst_DSP_top_ConfigMem.Inst_frame1_bit9.Q VPWR _0791_ VGND
+ Tile_X0Y0_DSP_top.Inst_DSP_top_ConfigMem.Inst_frame1_bit8.Q Tile_X0Y0_DSP_top.Inst_DSP_top_switch_matrix.bot2top7
+ sg13g2_o21ai_1
XFILLER_103_359 VPWR VGND sg13g2_fill_2
XFILLER_103_337 VPWR VGND sg13g2_fill_2
X_5127_ VPWR VGND Tile_X0Y0_DSP_top.Inst_DSP_top_ConfigMem.Inst_frame2_bit17.Q _0063_
+ _0856_ _0853_ _0857_ _0854_ sg13g2_a221oi_1
X_6176_ Tile_X0Y0_DSP_top.Inst_DSP_top_switch_matrix.EE4BEG0 Tile_X0Y0_EE4BEG[12]
+ VPWR VGND sg13g2_buf_1
X_3457_ Tile_X0Y1_N2MID[6] Tile_X0Y1_DSP_bot.Inst_DSP_bot_ConfigMem.Inst_frame7_bit24.Q
+ _1814_ VPWR VGND sg13g2_nor2_1
X_3388_ VPWR Tile_X0Y1_DSP_bot.Inst_DSP_bot_switch_matrix.JS2BEG6 _1749_ VGND sg13g2_inv_1
XFILLER_29_104 VPWR VGND sg13g2_fill_1
X_4009_ Tile_X0Y0_DSP_top.Inst_DSP_top_ConfigMem.Inst_frame9_bit10.Q VPWR _2295_ VGND
+ _0123_ _1512_ sg13g2_o21ai_1
XFILLER_52_162 VPWR VGND sg13g2_fill_1
XFILLER_20_74 VPWR VGND sg13g2_fill_1
XFILLER_90_268 VPWR VGND sg13g2_fill_2
XFILLER_45_93 VPWR VGND sg13g2_fill_2
X_4360_ VPWR _0123_ Tile_X0Y0_DSP_top.Inst_DSP_top_ConfigMem.Inst_frame9_bit9.Q VGND
+ sg13g2_inv_1
XANTENNA_3 VPWR VGND Tile_X0Y0_E2MID[4] sg13g2_antennanp
X_2690_ _1075_ _0073_ Tile_X0Y1_DSP_bot.A1 VPWR VGND sg13g2_nand2_1
X_3311_ _1676_ Tile_X0Y1_DSP_bot.Inst_DSP_bot_ConfigMem.Inst_frame2_bit22.Q _1677_
+ VPWR VGND sg13g2_nor2b_1
XFILLER_98_324 VPWR VGND sg13g2_fill_2
X_4291_ VPWR _0054_ Tile_X0Y0_DSP_top.Inst_DSP_top_ConfigMem.Inst_frame2_bit10.Q VGND
+ sg13g2_inv_1
X_3173_ Tile_X0Y0_DSP_top.Inst_DSP_top_ConfigMem.Inst_frame7_bit18.Q Tile_X0Y0_S2MID[2]
+ _1546_ VPWR VGND sg13g2_nor2b_1
X_3242_ VGND VPWR Tile_X0Y1_DSP_bot.Inst_DSP_bot_ConfigMem.Inst_frame8_bit25.Q _1609_
+ _1610_ Tile_X0Y1_DSP_bot.Inst_DSP_bot_ConfigMem.Inst_frame8_bit27.Q sg13g2_a21oi_1
X_6030_ Tile_X0Y1_FrameData[13] Tile_X0Y1_FrameStrobe[11] Tile_X0Y1_DSP_bot.Inst_DSP_bot_ConfigMem.Inst_frame11_bit13.Q
+ VPWR VGND sg13g2_dlhq_1
X_5814_ Tile_X0Y1_FrameData[5] Tile_X0Y1_FrameStrobe[4] Tile_X0Y1_DSP_bot.Inst_DSP_bot_ConfigMem.Inst_frame4_bit5.Q
+ VPWR VGND sg13g2_dlhq_1
X_2888_ _1266_ _1265_ _1229_ VPWR VGND sg13g2_nand2b_1
X_2957_ VPWR _1334_ _1333_ VGND sg13g2_inv_1
X_5745_ Tile_X0Y1_FrameData[10] Tile_X0Y1_FrameStrobe[2] Tile_X0Y1_DSP_bot.Inst_DSP_bot_ConfigMem.Inst_frame2_bit10.Q
+ VPWR VGND sg13g2_dlhq_1
X_4627_ _0379_ VPWR _0380_ VGND Tile_X0Y1_DSP_bot.Inst_DSP_bot_ConfigMem.Inst_frame4_bit13.Q
+ _0376_ sg13g2_o21ai_1
X_5676_ Tile_X0Y1_FrameData[15] Tile_X0Y1_FrameStrobe[0] Tile_X0Y1_DSP_bot.Inst_DSP_bot_ConfigMem.Inst_frame0_bit15.Q
+ VPWR VGND sg13g2_dlhq_1
X_6228_ Tile_X0Y1_FrameStrobe[16] Tile_X0Y0_FrameStrobe_O[16] VPWR VGND sg13g2_buf_1
X_4489_ Tile_X0Y0_DSP_top.Inst_DSP_top_ConfigMem.Inst_frame4_bit19.Q _0242_ _0247_
+ _0248_ VPWR VGND sg13g2_nor3_1
X_4558_ Tile_X0Y1_DSP_bot.Inst_DSP_bot_ConfigMem.Inst_frame4_bit27.Q VPWR _0313_ VGND
+ Tile_X0Y1_DSP_bot.Inst_DSP_bot_ConfigMem.Inst_frame4_bit26.Q _0306_ sg13g2_o21ai_1
X_3509_ _1864_ _1862_ _1863_ VPWR VGND sg13g2_nand2b_1
XFILLER_1_228 VPWR VGND sg13g2_fill_2
X_6159_ Tile_X0Y0_E6END[9] Tile_X0Y0_E6BEG[7] VPWR VGND sg13g2_buf_1
XFILLER_57_210 VPWR VGND sg13g2_fill_1
XFILLER_13_324 VPWR VGND sg13g2_decap_8
XFILLER_13_335 VPWR VGND sg13g2_fill_1
XFILLER_15_85 VPWR VGND sg13g2_fill_1
XFILLER_110_0 VPWR VGND sg13g2_decap_8
XFILLER_48_221 VPWR VGND sg13g2_fill_2
XFILLER_16_184 VPWR VGND sg13g2_fill_2
X_3791_ Tile_X0Y0_DSP_top.Inst_DSP_top_ConfigMem.Inst_frame3_bit30.Q _2119_ _2120_
+ VPWR VGND sg13g2_nor2_1
X_5530_ Tile_X0Y0_FrameData[19] Tile_X0Y1_FrameStrobe[10] Tile_X0Y0_DSP_top.Inst_DSP_top_ConfigMem.Inst_frame10_bit19.Q
+ VPWR VGND sg13g2_dlhq_1
X_5461_ Tile_X0Y0_FrameData[24] Tile_X0Y1_FrameStrobe[8] Tile_X0Y0_DSP_top.Inst_DSP_top_ConfigMem.Inst_frame8_bit24.Q
+ VPWR VGND sg13g2_dlhq_1
X_3860_ Tile_X0Y0_DSP_top.Inst_DSP_top_ConfigMem.Inst_frame12_bit14.Q Tile_X0Y0_DSP_top.Inst_DSP_top_switch_matrix.bot2top4
+ _0387_ Tile_X0Y0_DSP_top.Inst_DSP_top_switch_matrix.JW2BEG1 _0407_ Tile_X0Y0_DSP_top.Inst_DSP_top_ConfigMem.Inst_frame12_bit15.Q
+ Tile_X0Y0_DSP_top.Inst_DSP_top_switch_matrix.N1BEG2 VPWR VGND sg13g2_mux4_1
X_2811_ _1191_ _0899_ _0939_ VPWR VGND sg13g2_nand2_1
X_2742_ Tile_X0Y1_DSP_bot.Inst_DSP_bot_ConfigMem.Inst_frame8_bit2.Q _1121_ _1124_
+ _1103_ _1101_ Tile_X0Y1_DSP_bot.Inst_DSP_bot_ConfigMem.Inst_frame8_bit3.Q _1125_
+ VPWR VGND sg13g2_mux4_1
X_5392_ Tile_X0Y0_FrameData[29] Tile_X0Y1_FrameStrobe[6] Tile_X0Y0_DSP_top.Inst_DSP_top_ConfigMem.Inst_frame6_bit29.Q
+ VPWR VGND sg13g2_dlhq_1
X_4274_ VPWR _0037_ Tile_X0Y0_S2MID[0] VGND sg13g2_inv_1
X_2673_ VPWR Tile_X0Y1_DSP_bot.Inst_DSP_bot_switch_matrix.E2BEG1 _1059_ VGND sg13g2_inv_1
X_4412_ _0173_ _0026_ _0172_ VPWR VGND sg13g2_nand2b_1
X_4343_ VPWR _0106_ Tile_X0Y1_DSP_bot.Inst_DSP_bot_ConfigMem.Inst_frame7_bit18.Q VGND
+ sg13g2_inv_1
X_3087_ Tile_X0Y0_DSP_top.Inst_DSP_top_ConfigMem.Inst_frame1_bit20.Q Tile_X0Y0_DSP_top.Inst_DSP_top_switch_matrix.bot2top0
+ _1464_ VPWR VGND sg13g2_nor2_1
X_3156_ Tile_X0Y0_DSP_top.Inst_DSP_top_ConfigMem.Inst_frame3_bit21.Q Tile_X0Y0_DSP_top.Inst_DSP_top_switch_matrix.N1END2
+ Tile_X0Y0_E1END[2] Tile_X0Y1_N2MID[6] Tile_X0Y0_E2END[6] Tile_X0Y0_DSP_top.Inst_DSP_top_ConfigMem.Inst_frame3_bit20.Q
+ _1530_ VPWR VGND sg13g2_mux4_1
XFILLER_94_360 VPWR VGND sg13g2_fill_1
XFILLER_39_243 VPWR VGND sg13g2_fill_2
X_6013_ Tile_X0Y1_FrameData[30] Tile_X0Y1_FrameStrobe[11] Tile_X0Y1_DSP_bot.Inst_DSP_bot_ConfigMem.Inst_frame11_bit30.Q
+ VPWR VGND sg13g2_dlhq_1
X_3225_ Tile_X0Y1_DSP_bot.Inst_DSP_bot_ConfigMem.Inst_frame3_bit29.Q VPWR _1594_ VGND
+ Tile_X0Y0_SS4END[4] Tile_X0Y1_DSP_bot.Inst_DSP_bot_ConfigMem.Inst_frame3_bit28.Q
+ sg13g2_o21ai_1
XFILLER_54_246 VPWR VGND sg13g2_decap_4
X_5659_ _2492_ VGND VPWR Tile_X0Y0_DSP_top.Inst_DSP_top_switch_matrix.inst_cus_mux81_buf_top2bot17.X
+ Tile_X0Y1_DSP_bot.Inst_MULADD.C_reg\[19\] clknet_3_6_0_Tile_X0Y1_UserCLK_regs sg13g2_dfrbpq_1
X_3989_ VGND VPWR Tile_X0Y0_DSP_top.Inst_DSP_top_ConfigMem.Inst_frame10_bit24.Q _1537_
+ _2278_ _2277_ sg13g2_a21oi_1
X_5728_ Tile_X0Y1_FrameData[27] Tile_X0Y1_FrameStrobe[2] Tile_X0Y1_DSP_bot.Inst_DSP_bot_ConfigMem.Inst_frame2_bit27.Q
+ VPWR VGND sg13g2_dlhq_1
XFILLER_77_69 VPWR VGND sg13g2_decap_4
XFILLER_26_62 VPWR VGND sg13g2_fill_1
XFILLER_42_83 VPWR VGND sg13g2_fill_2
XFILLER_95_179 VPWR VGND sg13g2_fill_2
X_3010_ _1384_ _1374_ _1387_ VPWR VGND sg13g2_xor2_1
X_3843_ _2163_ Tile_X0Y0_DSP_top.Inst_DSP_top_ConfigMem.Inst_frame1_bit2.Q _2164_
+ VPWR VGND sg13g2_nor2b_1
XFILLER_91_352 VPWR VGND sg13g2_fill_1
X_3912_ VGND VPWR _0021_ Tile_X0Y0_DSP_top.Inst_DSP_top_ConfigMem.Inst_frame11_bit0.Q
+ _2211_ Tile_X0Y0_DSP_top.Inst_DSP_top_ConfigMem.Inst_frame11_bit1.Q sg13g2_a21oi_1
Xclkbuf_0_Tile_X0Y1_UserCLK Tile_X0Y1_UserCLK clknet_0_Tile_X0Y1_UserCLK VPWR VGND
+ sg13g2_buf_8
X_4892_ _0633_ _0630_ _0632_ VPWR VGND sg13g2_nand2_1
XFILLER_51_238 VPWR VGND sg13g2_fill_1
X_4961_ _0697_ VPWR _0698_ VGND Tile_X0Y1_DSP_bot.Inst_DSP_bot_ConfigMem.Inst_frame1_bit16.Q
+ Tile_X0Y1_DSP_bot.Inst_DSP_bot_switch_matrix.Q0 sg13g2_o21ai_1
X_3774_ _2103_ VPWR _2104_ VGND Tile_X0Y0_DSP_top.Inst_DSP_top_ConfigMem.Inst_frame4_bit28.Q
+ _0190_ sg13g2_o21ai_1
X_5444_ Tile_X0Y0_FrameData[9] Tile_X0Y1_FrameStrobe[7] Tile_X0Y0_DSP_top.Inst_DSP_top_ConfigMem.Inst_frame7_bit9.Q
+ VPWR VGND sg13g2_dlhq_1
X_5513_ Tile_X0Y0_FrameData[4] Tile_X0Y1_FrameStrobe[9] Tile_X0Y0_DSP_top.Inst_DSP_top_ConfigMem.Inst_frame9_bit4.Q
+ VPWR VGND sg13g2_dlhq_1
X_2725_ _1108_ Tile_X0Y1_DSP_bot.Inst_DSP_bot_ConfigMem.Inst_frame2_bit18.Q _1109_
+ VPWR VGND sg13g2_nor2b_1
X_2656_ Tile_X0Y1_DSP_bot.Inst_DSP_bot_ConfigMem.Inst_frame3_bit15.Q _1043_ _1044_
+ VPWR VGND sg13g2_nor2_1
X_6493_ Tile_X0Y1_W6END[10] Tile_X0Y1_W6BEG[8] VPWR VGND sg13g2_buf_1
X_2587_ _0976_ Tile_X0Y0_W2MID[3] Tile_X0Y0_DSP_top.Inst_DSP_top_ConfigMem.Inst_frame6_bit2.Q
+ VPWR VGND sg13g2_nand2_1
X_5375_ Tile_X0Y0_FrameData[14] Tile_X0Y1_FrameStrobe[5] Tile_X0Y0_DSP_top.Inst_DSP_top_ConfigMem.Inst_frame5_bit14.Q
+ VPWR VGND sg13g2_dlhq_1
X_4326_ VPWR _0089_ Tile_X0Y1_DSP_bot.Inst_DSP_bot_ConfigMem.Inst_frame7_bit9.Q VGND
+ sg13g2_inv_1
X_4257_ VPWR _0020_ Tile_X0Y1_N2MID[4] VGND sg13g2_inv_1
X_3208_ VGND VPWR Tile_X0Y0_DSP_top.Inst_DSP_top_ConfigMem.Inst_frame8_bit10.Q _0645_
+ _1579_ Tile_X0Y0_DSP_top.Inst_DSP_top_ConfigMem.Inst_frame8_bit11.Q sg13g2_a21oi_1
X_3139_ Tile_X0Y1_DSP_bot.Inst_MULADD.C_reg\[12\] Tile_X0Y1_DSP_bot.Inst_DSP_bot_ConfigMem.Inst_frame12_bit2.Q
+ _1513_ VPWR VGND sg13g2_and2_1
XFILLER_67_360 VPWR VGND sg13g2_fill_1
X_4188_ _2428_ _2430_ Tile_X0Y1_DSP_bot.Inst_DSP_bot_switch_matrix.WW4BEG1 VPWR VGND
+ sg13g2_nor2_1
XFILLER_27_224 VPWR VGND sg13g2_fill_2
XFILLER_58_360 VPWR VGND sg13g2_fill_1
X_3490_ Tile_X0Y1_DSP_bot.Inst_DSP_bot_ConfigMem.Inst_frame8_bit13.Q VPWR _1846_ VGND
+ _1840_ _1843_ sg13g2_o21ai_1
X_5091_ Tile_X0Y0_DSP_top.Inst_DSP_top_ConfigMem.Inst_frame2_bit9.Q VPWR _0822_ VGND
+ Tile_X0Y0_DSP_top.Inst_DSP_top_ConfigMem.Inst_frame2_bit8.Q _0129_ sg13g2_o21ai_1
X_4111_ _2368_ _2367_ Tile_X0Y1_DSP_bot.Inst_DSP_bot_ConfigMem.Inst_frame12_bit24.Q
+ Tile_X0Y0_DSP_top.NN4BEG_outbuf_8.A VPWR VGND sg13g2_mux2_1
X_5160_ Tile_X0Y1_DSP_bot.Inst_DSP_bot_ConfigMem.Inst_frame2_bit6.Q VPWR _0888_ VGND
+ Tile_X0Y1_DSP_bot.Inst_DSP_bot_ConfigMem.Inst_frame2_bit5.Q _0886_ sg13g2_o21ai_1
X_4042_ _2324_ Tile_X0Y0_DSP_top.Inst_DSP_top_ConfigMem.Inst_frame9_bit24.Q _2322_
+ VPWR VGND sg13g2_nand2_1
XFILLER_56_319 VPWR VGND sg13g2_fill_1
X_5993_ Tile_X0Y1_FrameData[18] Tile_X0Y1_FrameStrobe[10] Tile_X0Y1_DSP_bot.Inst_DSP_bot_ConfigMem.Inst_frame10_bit18.Q
+ VPWR VGND sg13g2_dlhq_1
X_3826_ Tile_X0Y0_S1END[2] Tile_X0Y0_S2END[6] Tile_X0Y0_DSP_top.Inst_DSP_top_ConfigMem.Inst_frame2_bit20.Q
+ _2148_ VPWR VGND sg13g2_mux2_1
X_4875_ Tile_X0Y0_DSP_top.Inst_DSP_top_ConfigMem.Inst_frame5_bit5.Q Tile_X0Y1_N2MID[4]
+ Tile_X0Y0_S2END[4] Tile_X0Y0_EE4END[0] Tile_X0Y0_W2END[4] Tile_X0Y0_DSP_top.Inst_DSP_top_ConfigMem.Inst_frame5_bit4.Q
+ _0616_ VPWR VGND sg13g2_mux4_1
X_4944_ _0681_ VPWR Tile_X0Y0_DSP_top.Inst_DSP_top_switch_matrix.inst_cus_mux41_buf_top2bot2.X
+ VGND _0617_ _0618_ sg13g2_o21ai_1
X_3757_ VGND VPWR Tile_X0Y0_DSP_top.Inst_DSP_top_ConfigMem.Inst_frame1_bit28.Q _0133_
+ _2087_ _2086_ sg13g2_a21oi_1
X_5427_ Tile_X0Y0_FrameData[26] Tile_X0Y1_FrameStrobe[7] Tile_X0Y0_DSP_top.Inst_DSP_top_ConfigMem.Inst_frame7_bit26.Q
+ VPWR VGND sg13g2_dlhq_1
X_3688_ _2021_ _2000_ _2023_ VPWR VGND sg13g2_xor2_1
X_6476_ Tile_X0Y1_W2END[7] Tile_X0Y1_W2BEG[7] VPWR VGND sg13g2_buf_1
X_2639_ VGND VPWR Tile_X0Y1_DSP_bot.Inst_DSP_bot_ConfigMem.Inst_frame3_bit12.Q _0126_
+ _1027_ _1026_ sg13g2_a21oi_1
X_2708_ _1092_ VPWR _1093_ VGND Tile_X0Y1_DSP_bot.Inst_DSP_bot_ConfigMem.Inst_frame2_bit8.Q
+ Tile_X0Y1_DSP_bot.Inst_DSP_bot_switch_matrix.Q5 sg13g2_o21ai_1
XFILLER_99_260 VPWR VGND sg13g2_fill_1
X_4309_ VPWR _0072_ Tile_X0Y1_DSP_bot.Inst_DSP_bot_ConfigMem.Inst_frame12_bit2.Q VGND
+ sg13g2_inv_1
X_5289_ Tile_X0Y0_FrameData[4] Tile_X0Y1_FrameStrobe[2] Tile_X0Y0_DSP_top.Inst_DSP_top_ConfigMem.Inst_frame2_bit4.Q
+ VPWR VGND sg13g2_dlhq_1
X_5358_ Tile_X0Y0_FrameData[31] Tile_X0Y1_FrameStrobe[5] Tile_X0Y0_DSP_top.Inst_DSP_top_ConfigMem.Inst_frame5_bit31.Q
+ VPWR VGND sg13g2_dlhq_1
XFILLER_73_182 VPWR VGND sg13g2_decap_8
X_4660_ Tile_X0Y0_DSP_top.Inst_DSP_top_ConfigMem.Inst_frame3_bit6.Q VPWR _0412_ VGND
+ Tile_X0Y0_DSP_top.Inst_DSP_top_ConfigMem.Inst_frame3_bit5.Q _0410_ sg13g2_o21ai_1
XFILLER_61_322 VPWR VGND sg13g2_fill_1
X_2990_ VGND VPWR _1358_ _1360_ _1367_ _1362_ sg13g2_a21oi_1
X_4591_ _0344_ VPWR _0345_ VGND Tile_X0Y0_DSP_top.Inst_DSP_top_ConfigMem.Inst_frame4_bit4.Q
+ _0129_ sg13g2_o21ai_1
X_6330_ Tile_X0Y0_DSP_top.Inst_DSP_top_switch_matrix.WW4BEG1 Tile_X0Y0_WW4BEG[13]
+ VPWR VGND sg13g2_buf_1
X_3611_ _1955_ _1689_ _1692_ VPWR VGND sg13g2_xnor2_1
X_3473_ Tile_X0Y1_DSP_bot.Inst_DSP_bot_ConfigMem.Inst_frame5_bit24.Q Tile_X0Y1_N2END[7]
+ Tile_X0Y1_E2END[7] Tile_X0Y0_S2MID[7] Tile_X0Y1_WW4END[0] Tile_X0Y1_DSP_bot.Inst_DSP_bot_ConfigMem.Inst_frame5_bit25.Q
+ _1830_ VPWR VGND sg13g2_mux4_1
X_3542_ _1895_ Tile_X0Y1_DSP_bot.Inst_DSP_bot_ConfigMem.Inst_frame12_bit3.Q Tile_X0Y1_DSP_bot.Inst_MULADD.ACC\[0\]
+ VPWR VGND sg13g2_nand2_1
X_6261_ Tile_X0Y0_DSP_top.N4BEG_outbuf_9.A Tile_X0Y0_N4BEG[9] VPWR VGND sg13g2_buf_1
X_6192_ Tile_X0Y0_FrameData[12] Tile_X0Y0_FrameData_O[12] VPWR VGND sg13g2_buf_1
X_5212_ Tile_X0Y0_FrameData[17] Tile_X0Y1_FrameStrobe[0] Tile_X0Y0_DSP_top.Inst_DSP_top_ConfigMem.Inst_frame0_bit17.Q
+ VPWR VGND sg13g2_dlhq_1
X_5074_ Tile_X0Y0_DSP_top.Inst_DSP_top_ConfigMem.Inst_frame5_bit15.Q Tile_X0Y1_N2MID[0]
+ Tile_X0Y0_S2END[0] Tile_X0Y0_EE4END[1] Tile_X0Y0_W2END[0] Tile_X0Y0_DSP_top.Inst_DSP_top_ConfigMem.Inst_frame5_bit14.Q
+ _0806_ VPWR VGND sg13g2_mux4_1
XFILLER_56_127 VPWR VGND sg13g2_fill_1
X_5143_ _0870_ VPWR _0871_ VGND _0020_ Tile_X0Y1_DSP_bot.Inst_DSP_bot_ConfigMem.Inst_frame7_bit4.Q
+ sg13g2_o21ai_1
X_4025_ VGND VPWR Tile_X0Y0_DSP_top.Inst_DSP_top_ConfigMem.Inst_frame9_bit13.Q _2306_
+ _2310_ _2309_ sg13g2_a21oi_1
X_5976_ Tile_X0Y1_FrameData[3] Tile_X0Y1_FrameStrobe[9] Tile_X0Y1_DSP_bot.Inst_DSP_bot_ConfigMem.Inst_frame9_bit3.Q
+ VPWR VGND sg13g2_dlhq_1
X_4927_ _0667_ _0659_ _0666_ VPWR VGND sg13g2_nand2_1
X_3809_ _2134_ VPWR Tile_X0Y0_DSP_top.Inst_DSP_top_switch_matrix.bot2top3 VGND Tile_X0Y1_DSP_bot.Inst_DSP_bot_ConfigMem.Inst_frame12_bit5.Q
+ _2133_ sg13g2_o21ai_1
X_4789_ _0532_ VPWR _0533_ VGND Tile_X0Y1_DSP_bot.Inst_DSP_bot_ConfigMem.Inst_frame12_bit1.Q
+ Tile_X0Y0_DSP_top.Inst_DSP_top_switch_matrix.inst_cus_mux41_buf_top2bot4.X sg13g2_o21ai_1
X_4858_ VGND VPWR Tile_X0Y0_E6END[0] Tile_X0Y0_DSP_top.Inst_DSP_top_ConfigMem.Inst_frame0_bit6.Q
+ _0600_ _0599_ sg13g2_a21oi_1
XFILLER_106_335 VPWR VGND sg13g2_decap_8
X_6459_ Tile_X0Y0_DSP_top.Inst_DSP_top_switch_matrix.SS4BEG2 Tile_X0Y1_SS4BEG[10]
+ VPWR VGND sg13g2_buf_1
XFILLER_47_105 VPWR VGND sg13g2_fill_2
XFILLER_34_322 VPWR VGND sg13g2_fill_1
X_5830_ Tile_X0Y1_FrameData[21] Tile_X0Y1_FrameStrobe[5] Tile_X0Y1_DSP_bot.Inst_DSP_bot_ConfigMem.Inst_frame5_bit21.Q
+ VPWR VGND sg13g2_dlhq_1
X_4643_ Tile_X0Y0_DSP_top.Inst_DSP_top_ConfigMem.Inst_frame1_bit18.Q VPWR _0395_ VGND
+ Tile_X0Y0_DSP_top.Inst_DSP_top_ConfigMem.Inst_frame1_bit17.Q _0392_ sg13g2_o21ai_1
X_4712_ _0461_ _0460_ Tile_X0Y0_DSP_top.Inst_DSP_top_ConfigMem.Inst_frame3_bit14.Q
+ VPWR VGND sg13g2_nand2b_1
X_5761_ Tile_X0Y1_FrameData[26] Tile_X0Y1_FrameStrobe[3] Tile_X0Y1_DSP_bot.Inst_DSP_bot_ConfigMem.Inst_frame3_bit26.Q
+ VPWR VGND sg13g2_dlhq_1
X_2973_ _1350_ _1347_ _1348_ VPWR VGND sg13g2_xnor2_1
X_5692_ Tile_X0Y1_FrameData[31] Tile_X0Y1_FrameStrobe[1] Tile_X0Y1_DSP_bot.Inst_DSP_bot_ConfigMem.Inst_frame1_bit31.Q
+ VPWR VGND sg13g2_dlhq_1
X_6244_ Tile_X0Y0_DSP_top.Inst_DSP_top_switch_matrix.N2BEGb0 Tile_X0Y0_N2BEGb[0] VPWR
+ VGND sg13g2_buf_1
X_4574_ Tile_X0Y1_N4END[7] Tile_X0Y0_E2END[3] Tile_X0Y0_DSP_top.Inst_DSP_top_ConfigMem.Inst_frame3_bit8.Q
+ _0329_ VPWR VGND sg13g2_mux2_1
X_6313_ Tile_X0Y0_W6END[10] Tile_X0Y0_W6BEG[8] VPWR VGND sg13g2_buf_1
X_3456_ Tile_X0Y1_E2MID[6] Tile_X0Y1_DSP_bot.Inst_DSP_bot_ConfigMem.Inst_frame7_bit24.Q
+ _1813_ VPWR VGND sg13g2_nor2b_1
X_3525_ VGND VPWR Tile_X0Y1_DSP_bot.Inst_DSP_bot_ConfigMem.Inst_frame8_bit8.Q _1876_
+ _1879_ _1878_ sg13g2_a21oi_1
X_5126_ _0855_ VPWR _0856_ VGND Tile_X0Y0_W1END[1] Tile_X0Y0_DSP_top.Inst_DSP_top_ConfigMem.Inst_frame2_bit16.Q
+ sg13g2_o21ai_1
X_5057_ _0789_ VPWR _0790_ VGND Tile_X0Y0_DSP_top.Inst_DSP_top_ConfigMem.Inst_frame1_bit8.Q
+ Tile_X0Y0_DSP_top.Inst_DSP_top_switch_matrix.bot2top5 sg13g2_o21ai_1
X_6175_ Tile_X0Y0_EE4END[15] Tile_X0Y0_EE4BEG[11] VPWR VGND sg13g2_buf_1
XFILLER_84_277 VPWR VGND sg13g2_fill_2
XFILLER_84_222 VPWR VGND sg13g2_fill_2
X_4008_ _2293_ VPWR _2294_ VGND Tile_X0Y0_DSP_top.Inst_DSP_top_ConfigMem.Inst_frame9_bit10.Q
+ _2291_ sg13g2_o21ai_1
X_3387_ _1749_ _1748_ _0098_ _1745_ _1743_ VPWR VGND sg13g2_a22oi_1
X_5959_ Tile_X0Y1_FrameData[20] Tile_X0Y1_FrameStrobe[9] Tile_X0Y1_DSP_bot.Inst_DSP_bot_ConfigMem.Inst_frame9_bit20.Q
+ VPWR VGND sg13g2_dlhq_1
XFILLER_90_214 VPWR VGND sg13g2_fill_2
XFILLER_16_333 VPWR VGND sg13g2_fill_2
X_4290_ VPWR _0053_ Tile_X0Y1_NN4END[5] VGND sg13g2_inv_1
XANTENNA_4 VPWR VGND Tile_X0Y0_E2MID[4] sg13g2_antennanp
X_3310_ VGND VPWR Tile_X0Y1_DSP_bot.Inst_DSP_bot_ConfigMem.Inst_frame2_bit20.Q _0131_
+ _1676_ _1675_ sg13g2_a21oi_1
X_3172_ _1543_ VPWR _1545_ VGND _1539_ _1544_ sg13g2_o21ai_1
X_3241_ VPWR Tile_X0Y1_DSP_bot.Inst_DSP_bot_switch_matrix.E2BEG7 _1609_ VGND sg13g2_inv_1
XFILLER_34_163 VPWR VGND sg13g2_fill_2
X_5813_ Tile_X0Y1_FrameData[6] Tile_X0Y1_FrameStrobe[4] Tile_X0Y1_DSP_bot.Inst_DSP_bot_ConfigMem.Inst_frame4_bit6.Q
+ VPWR VGND sg13g2_dlhq_1
X_2887_ _1265_ _1264_ _1263_ VPWR VGND sg13g2_nand2b_1
X_2956_ _0992_ _1260_ _1333_ VPWR VGND sg13g2_nor2_1
X_5744_ Tile_X0Y1_FrameData[11] Tile_X0Y1_FrameStrobe[2] Tile_X0Y1_DSP_bot.Inst_DSP_bot_ConfigMem.Inst_frame2_bit11.Q
+ VPWR VGND sg13g2_dlhq_1
X_4626_ VGND VPWR Tile_X0Y1_DSP_bot.Inst_DSP_bot_ConfigMem.Inst_frame4_bit13.Q _0378_
+ _0379_ _0045_ sg13g2_a21oi_1
X_5675_ Tile_X0Y1_FrameData[16] Tile_X0Y1_FrameStrobe[0] Tile_X0Y1_DSP_bot.Inst_DSP_bot_ConfigMem.Inst_frame0_bit16.Q
+ VPWR VGND sg13g2_dlhq_1
X_6227_ Tile_X0Y1_FrameStrobe[15] Tile_X0Y0_FrameStrobe_O[15] VPWR VGND sg13g2_buf_1
X_4488_ VPWR VGND Tile_X0Y0_DSP_top.Inst_DSP_top_ConfigMem.Inst_frame4_bit17.Q _0059_
+ _0246_ _0243_ _0247_ _0244_ sg13g2_a221oi_1
X_6158_ Tile_X0Y0_E6END[8] Tile_X0Y0_E6BEG[6] VPWR VGND sg13g2_buf_1
XFILLER_103_124 VPWR VGND sg13g2_fill_2
X_4557_ _0311_ VPWR _0312_ VGND Tile_X0Y1_DSP_bot.Inst_DSP_bot_ConfigMem.Inst_frame4_bit25.Q
+ _0308_ sg13g2_o21ai_1
X_3508_ _1863_ _1415_ _1419_ VPWR VGND sg13g2_xnor2_1
X_3439_ Tile_X0Y1_DSP_bot.Inst_DSP_bot_ConfigMem.Inst_frame0_bit27.Q VPWR _1797_ VGND
+ Tile_X0Y1_W2END[2] Tile_X0Y1_DSP_bot.Inst_DSP_bot_ConfigMem.Inst_frame0_bit26.Q
+ sg13g2_o21ai_1
X_5109_ _0838_ VPWR _0839_ VGND _0053_ Tile_X0Y0_DSP_top.Inst_DSP_top_ConfigMem.Inst_frame0_bit12.Q
+ sg13g2_o21ai_1
X_6089_ VPWR VGND _2487_ sg13g2_tiehi
XFILLER_40_188 VPWR VGND sg13g2_fill_2
XFILLER_103_0 VPWR VGND sg13g2_fill_2
XFILLER_31_63 VPWR VGND sg13g2_fill_1
XFILLER_95_328 VPWR VGND sg13g2_fill_2
XFILLER_48_255 VPWR VGND sg13g2_decap_8
XFILLER_31_111 VPWR VGND sg13g2_fill_2
X_3790_ VGND VPWR Tile_X0Y0_E2END[0] Tile_X0Y0_DSP_top.Inst_DSP_top_ConfigMem.Inst_frame3_bit28.Q
+ _2119_ _2118_ sg13g2_a21oi_1
X_5460_ Tile_X0Y0_FrameData[25] Tile_X0Y1_FrameStrobe[8] Tile_X0Y0_DSP_top.Inst_DSP_top_ConfigMem.Inst_frame8_bit25.Q
+ VPWR VGND sg13g2_dlhq_1
X_2810_ _1190_ _1077_ _1189_ VPWR VGND sg13g2_nand2_1
X_2672_ _1059_ _1058_ _0083_ _1055_ _1049_ VPWR VGND sg13g2_a22oi_1
X_2741_ VPWR _1124_ _1123_ VGND sg13g2_inv_1
X_4411_ Tile_X0Y1_DSP_bot.Inst_DSP_bot_ConfigMem.Inst_frame1_bit12.Q Tile_X0Y1_DSP_bot.Inst_DSP_bot_switch_matrix.Q0
+ Tile_X0Y1_DSP_bot.Inst_DSP_bot_switch_matrix.Q1 Tile_X0Y1_DSP_bot.Inst_DSP_bot_switch_matrix.Q2
+ Tile_X0Y1_DSP_bot.Inst_DSP_bot_switch_matrix.Q4 Tile_X0Y1_DSP_bot.Inst_DSP_bot_ConfigMem.Inst_frame1_bit13.Q
+ _0172_ VPWR VGND sg13g2_mux4_1
X_4273_ VPWR _0036_ Tile_X0Y0_W6END[1] VGND sg13g2_inv_1
X_5391_ Tile_X0Y0_FrameData[30] Tile_X0Y1_FrameStrobe[6] Tile_X0Y0_DSP_top.Inst_DSP_top_ConfigMem.Inst_frame6_bit30.Q
+ VPWR VGND sg13g2_dlhq_1
X_3224_ Tile_X0Y1_WW4END[0] Tile_X0Y1_DSP_bot.Inst_DSP_bot_ConfigMem.Inst_frame3_bit28.Q
+ _1593_ VPWR VGND sg13g2_nor2b_1
X_6012_ Tile_X0Y1_FrameData[31] Tile_X0Y1_FrameStrobe[11] Tile_X0Y1_DSP_bot.Inst_DSP_bot_ConfigMem.Inst_frame11_bit31.Q
+ VPWR VGND sg13g2_dlhq_1
X_4342_ VPWR _0105_ Tile_X0Y1_DSP_bot.Inst_MULADD.ACC\[1\] VGND sg13g2_inv_1
.ends
