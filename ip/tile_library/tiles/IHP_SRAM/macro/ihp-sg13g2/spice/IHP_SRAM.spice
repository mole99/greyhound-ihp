* NGSPICE file created from IHP_SRAM.ext - technology: ihp-sg13g2

* Black-box entry subcircuit for sg13g2_mux4_1 abstract view
.subckt sg13g2_mux4_1 S0 A0 A1 A2 A3 S1 X VDD VSS
.ends

* Black-box entry subcircuit for sg13g2_inv_1 abstract view
.subckt sg13g2_inv_1 VDD Y A VSS
.ends

* Black-box entry subcircuit for sg13g2_fill_1 abstract view
.subckt sg13g2_fill_1 VDD VSS
.ends

* Black-box entry subcircuit for sg13g2_decap_8 abstract view
.subckt sg13g2_decap_8 VDD VSS
.ends

* Black-box entry subcircuit for sg13g2_fill_2 abstract view
.subckt sg13g2_fill_2 VDD VSS
.ends

* Black-box entry subcircuit for sg13g2_dlhq_1 abstract view
.subckt sg13g2_dlhq_1 D GATE Q VDD VSS
.ends

* Black-box entry subcircuit for sg13g2_buf_1 abstract view
.subckt sg13g2_buf_1 A X VDD VSS
.ends

* Black-box entry subcircuit for sg13g2_decap_4 abstract view
.subckt sg13g2_decap_4 VDD VSS
.ends

* Black-box entry subcircuit for sg13g2_a21oi_1 abstract view
.subckt sg13g2_a21oi_1 VSS VDD A1 A2 Y B1
.ends

* Black-box entry subcircuit for sg13g2_nand2b_1 abstract view
.subckt sg13g2_nand2b_1 Y B A_N VDD VSS
.ends

* Black-box entry subcircuit for sg13g2_o21ai_1 abstract view
.subckt sg13g2_o21ai_1 B1 VDD Y VSS A1 A2
.ends

* Black-box entry subcircuit for sg13g2_mux2_1 abstract view
.subckt sg13g2_mux2_1 A0 A1 S X VDD VSS
.ends

* Black-box entry subcircuit for sg13g2_antennanp abstract view
.subckt sg13g2_antennanp VDD VSS A
.ends

* Black-box entry subcircuit for sg13g2_nor2b_1 abstract view
.subckt sg13g2_nor2b_1 A B_N Y VDD VSS
.ends

* Black-box entry subcircuit for sg13g2_nor2_1 abstract view
.subckt sg13g2_nor2_1 A B Y VDD VSS
.ends

* Black-box entry subcircuit for sg13g2_nor3_1 abstract view
.subckt sg13g2_nor3_1 A B C Y VDD VSS
.ends

* Black-box entry subcircuit for sg13g2_nand2_1 abstract view
.subckt sg13g2_nand2_1 Y A B VDD VSS
.ends

* Black-box entry subcircuit for sg13g2_a221oi_1 abstract view
.subckt sg13g2_a221oi_1 VDD VSS B2 C1 B1 A1 Y A2
.ends

* Black-box entry subcircuit for sg13g2_nand3_1 abstract view
.subckt sg13g2_nand3_1 B C A Y VDD VSS
.ends

* Black-box entry subcircuit for sg13g2_nand3b_1 abstract view
.subckt sg13g2_nand3b_1 B C Y VDD VSS A_N
.ends

* Black-box entry subcircuit for sg13g2_a22oi_1 abstract view
.subckt sg13g2_a22oi_1 Y B1 B2 A2 A1 VDD VSS
.ends

* Black-box entry subcircuit for sg13g2_buf_8 abstract view
.subckt sg13g2_buf_8 A X VDD VSS
.ends

* Black-box entry subcircuit for sg13g2_nand4_1 abstract view
.subckt sg13g2_nand4_1 B C A Y VDD VSS D
.ends

* Black-box entry subcircuit for sg13g2_or2_1 abstract view
.subckt sg13g2_or2_1 VSS VDD X B A
.ends

* Black-box entry subcircuit for sg13g2_or3_1 abstract view
.subckt sg13g2_or3_1 A B C X VDD VSS
.ends

* Black-box entry subcircuit for sg13g2_and2_1 abstract view
.subckt sg13g2_and2_1 A B X VDD VSS
.ends

* Black-box entry subcircuit for sg13g2_tielo abstract view
.subckt sg13g2_tielo VDD VSS L_LO
.ends

* Black-box entry subcircuit for sg13g2_tiehi abstract view
.subckt sg13g2_tiehi VDD VSS L_HI
.ends

.subckt IHP_SRAM A_ADDR_SRAM0 A_ADDR_SRAM1 A_ADDR_SRAM2 A_ADDR_SRAM3 A_ADDR_SRAM4
+ A_ADDR_SRAM5 A_ADDR_SRAM6 A_ADDR_SRAM7 A_ADDR_SRAM8 A_ADDR_SRAM9 A_BM_SRAM0 A_BM_SRAM1
+ A_BM_SRAM10 A_BM_SRAM11 A_BM_SRAM12 A_BM_SRAM13 A_BM_SRAM14 A_BM_SRAM15 A_BM_SRAM16
+ A_BM_SRAM17 A_BM_SRAM18 A_BM_SRAM19 A_BM_SRAM2 A_BM_SRAM20 A_BM_SRAM21 A_BM_SRAM22
+ A_BM_SRAM23 A_BM_SRAM24 A_BM_SRAM25 A_BM_SRAM26 A_BM_SRAM27 A_BM_SRAM28 A_BM_SRAM29
+ A_BM_SRAM3 A_BM_SRAM30 A_BM_SRAM31 A_BM_SRAM4 A_BM_SRAM5 A_BM_SRAM6 A_BM_SRAM7 A_BM_SRAM8
+ A_BM_SRAM9 A_CLK_SRAM A_DIN_SRAM0 A_DIN_SRAM1 A_DIN_SRAM10 A_DIN_SRAM11 A_DIN_SRAM12
+ A_DIN_SRAM13 A_DIN_SRAM14 A_DIN_SRAM15 A_DIN_SRAM16 A_DIN_SRAM17 A_DIN_SRAM18 A_DIN_SRAM19
+ A_DIN_SRAM2 A_DIN_SRAM20 A_DIN_SRAM21 A_DIN_SRAM22 A_DIN_SRAM23 A_DIN_SRAM24 A_DIN_SRAM25
+ A_DIN_SRAM26 A_DIN_SRAM27 A_DIN_SRAM28 A_DIN_SRAM29 A_DIN_SRAM3 A_DIN_SRAM30 A_DIN_SRAM31
+ A_DIN_SRAM4 A_DIN_SRAM5 A_DIN_SRAM6 A_DIN_SRAM7 A_DIN_SRAM8 A_DIN_SRAM9 A_DOUT_SRAM0
+ A_DOUT_SRAM1 A_DOUT_SRAM10 A_DOUT_SRAM11 A_DOUT_SRAM12 A_DOUT_SRAM13 A_DOUT_SRAM14
+ A_DOUT_SRAM15 A_DOUT_SRAM16 A_DOUT_SRAM17 A_DOUT_SRAM18 A_DOUT_SRAM19 A_DOUT_SRAM2
+ A_DOUT_SRAM20 A_DOUT_SRAM21 A_DOUT_SRAM22 A_DOUT_SRAM23 A_DOUT_SRAM24 A_DOUT_SRAM25
+ A_DOUT_SRAM26 A_DOUT_SRAM27 A_DOUT_SRAM28 A_DOUT_SRAM29 A_DOUT_SRAM3 A_DOUT_SRAM30
+ A_DOUT_SRAM31 A_DOUT_SRAM4 A_DOUT_SRAM5 A_DOUT_SRAM6 A_DOUT_SRAM7 A_DOUT_SRAM8 A_DOUT_SRAM9
+ A_MEN_SRAM A_REN_SRAM A_TIE_HIGH_SRAM A_TIE_LOW_SRAM A_WEN_SRAM CONFIGURED_top Tile_X0Y0_E1END[0]
+ Tile_X0Y0_E1END[1] Tile_X0Y0_E1END[2] Tile_X0Y0_E1END[3] Tile_X0Y0_E2END[0] Tile_X0Y0_E2END[1]
+ Tile_X0Y0_E2END[2] Tile_X0Y0_E2END[3] Tile_X0Y0_E2END[4] Tile_X0Y0_E2END[5] Tile_X0Y0_E2END[6]
+ Tile_X0Y0_E2END[7] Tile_X0Y0_E2MID[0] Tile_X0Y0_E2MID[1] Tile_X0Y0_E2MID[2] Tile_X0Y0_E2MID[3]
+ Tile_X0Y0_E2MID[4] Tile_X0Y0_E2MID[5] Tile_X0Y0_E2MID[6] Tile_X0Y0_E2MID[7] Tile_X0Y0_E6END[0]
+ Tile_X0Y0_E6END[10] Tile_X0Y0_E6END[11] Tile_X0Y0_E6END[1] Tile_X0Y0_E6END[2] Tile_X0Y0_E6END[3]
+ Tile_X0Y0_E6END[4] Tile_X0Y0_E6END[5] Tile_X0Y0_E6END[6] Tile_X0Y0_E6END[7] Tile_X0Y0_E6END[8]
+ Tile_X0Y0_E6END[9] Tile_X0Y0_EE4END[0] Tile_X0Y0_EE4END[10] Tile_X0Y0_EE4END[11]
+ Tile_X0Y0_EE4END[12] Tile_X0Y0_EE4END[13] Tile_X0Y0_EE4END[14] Tile_X0Y0_EE4END[15]
+ Tile_X0Y0_EE4END[1] Tile_X0Y0_EE4END[2] Tile_X0Y0_EE4END[3] Tile_X0Y0_EE4END[4]
+ Tile_X0Y0_EE4END[5] Tile_X0Y0_EE4END[6] Tile_X0Y0_EE4END[7] Tile_X0Y0_EE4END[8]
+ Tile_X0Y0_EE4END[9] Tile_X0Y0_FrameData[0] Tile_X0Y0_FrameData[10] Tile_X0Y0_FrameData[11]
+ Tile_X0Y0_FrameData[12] Tile_X0Y0_FrameData[13] Tile_X0Y0_FrameData[14] Tile_X0Y0_FrameData[15]
+ Tile_X0Y0_FrameData[16] Tile_X0Y0_FrameData[17] Tile_X0Y0_FrameData[18] Tile_X0Y0_FrameData[19]
+ Tile_X0Y0_FrameData[1] Tile_X0Y0_FrameData[20] Tile_X0Y0_FrameData[21] Tile_X0Y0_FrameData[22]
+ Tile_X0Y0_FrameData[23] Tile_X0Y0_FrameData[24] Tile_X0Y0_FrameData[25] Tile_X0Y0_FrameData[26]
+ Tile_X0Y0_FrameData[27] Tile_X0Y0_FrameData[28] Tile_X0Y0_FrameData[29] Tile_X0Y0_FrameData[2]
+ Tile_X0Y0_FrameData[30] Tile_X0Y0_FrameData[31] Tile_X0Y0_FrameData[3] Tile_X0Y0_FrameData[4]
+ Tile_X0Y0_FrameData[5] Tile_X0Y0_FrameData[6] Tile_X0Y0_FrameData[7] Tile_X0Y0_FrameData[8]
+ Tile_X0Y0_FrameData[9] Tile_X0Y0_FrameData_O[0] Tile_X0Y0_FrameData_O[10] Tile_X0Y0_FrameData_O[11]
+ Tile_X0Y0_FrameData_O[12] Tile_X0Y0_FrameData_O[13] Tile_X0Y0_FrameData_O[14] Tile_X0Y0_FrameData_O[15]
+ Tile_X0Y0_FrameData_O[16] Tile_X0Y0_FrameData_O[17] Tile_X0Y0_FrameData_O[18] Tile_X0Y0_FrameData_O[19]
+ Tile_X0Y0_FrameData_O[1] Tile_X0Y0_FrameData_O[20] Tile_X0Y0_FrameData_O[21] Tile_X0Y0_FrameData_O[22]
+ Tile_X0Y0_FrameData_O[23] Tile_X0Y0_FrameData_O[24] Tile_X0Y0_FrameData_O[25] Tile_X0Y0_FrameData_O[26]
+ Tile_X0Y0_FrameData_O[27] Tile_X0Y0_FrameData_O[28] Tile_X0Y0_FrameData_O[29] Tile_X0Y0_FrameData_O[2]
+ Tile_X0Y0_FrameData_O[30] Tile_X0Y0_FrameData_O[31] Tile_X0Y0_FrameData_O[3] Tile_X0Y0_FrameData_O[4]
+ Tile_X0Y0_FrameData_O[5] Tile_X0Y0_FrameData_O[6] Tile_X0Y0_FrameData_O[7] Tile_X0Y0_FrameData_O[8]
+ Tile_X0Y0_FrameData_O[9] Tile_X0Y0_FrameStrobe_O[0] Tile_X0Y0_FrameStrobe_O[10]
+ Tile_X0Y0_FrameStrobe_O[11] Tile_X0Y0_FrameStrobe_O[12] Tile_X0Y0_FrameStrobe_O[13]
+ Tile_X0Y0_FrameStrobe_O[14] Tile_X0Y0_FrameStrobe_O[15] Tile_X0Y0_FrameStrobe_O[16]
+ Tile_X0Y0_FrameStrobe_O[17] Tile_X0Y0_FrameStrobe_O[18] Tile_X0Y0_FrameStrobe_O[19]
+ Tile_X0Y0_FrameStrobe_O[1] Tile_X0Y0_FrameStrobe_O[2] Tile_X0Y0_FrameStrobe_O[3]
+ Tile_X0Y0_FrameStrobe_O[4] Tile_X0Y0_FrameStrobe_O[5] Tile_X0Y0_FrameStrobe_O[6]
+ Tile_X0Y0_FrameStrobe_O[7] Tile_X0Y0_FrameStrobe_O[8] Tile_X0Y0_FrameStrobe_O[9]
+ Tile_X0Y0_N1BEG[0] Tile_X0Y0_N1BEG[1] Tile_X0Y0_N1BEG[2] Tile_X0Y0_N1BEG[3] Tile_X0Y0_N2BEG[0]
+ Tile_X0Y0_N2BEG[1] Tile_X0Y0_N2BEG[2] Tile_X0Y0_N2BEG[3] Tile_X0Y0_N2BEG[4] Tile_X0Y0_N2BEG[5]
+ Tile_X0Y0_N2BEG[6] Tile_X0Y0_N2BEG[7] Tile_X0Y0_N2BEGb[0] Tile_X0Y0_N2BEGb[1] Tile_X0Y0_N2BEGb[2]
+ Tile_X0Y0_N2BEGb[3] Tile_X0Y0_N2BEGb[4] Tile_X0Y0_N2BEGb[5] Tile_X0Y0_N2BEGb[6]
+ Tile_X0Y0_N2BEGb[7] Tile_X0Y0_N4BEG[0] Tile_X0Y0_N4BEG[10] Tile_X0Y0_N4BEG[11] Tile_X0Y0_N4BEG[12]
+ Tile_X0Y0_N4BEG[13] Tile_X0Y0_N4BEG[14] Tile_X0Y0_N4BEG[15] Tile_X0Y0_N4BEG[1] Tile_X0Y0_N4BEG[2]
+ Tile_X0Y0_N4BEG[3] Tile_X0Y0_N4BEG[4] Tile_X0Y0_N4BEG[5] Tile_X0Y0_N4BEG[6] Tile_X0Y0_N4BEG[7]
+ Tile_X0Y0_N4BEG[8] Tile_X0Y0_N4BEG[9] Tile_X0Y0_S1END[0] Tile_X0Y0_S1END[1] Tile_X0Y0_S1END[2]
+ Tile_X0Y0_S1END[3] Tile_X0Y0_S2END[0] Tile_X0Y0_S2END[1] Tile_X0Y0_S2END[2] Tile_X0Y0_S2END[3]
+ Tile_X0Y0_S2END[4] Tile_X0Y0_S2END[5] Tile_X0Y0_S2END[6] Tile_X0Y0_S2END[7] Tile_X0Y0_S2MID[0]
+ Tile_X0Y0_S2MID[1] Tile_X0Y0_S2MID[2] Tile_X0Y0_S2MID[3] Tile_X0Y0_S2MID[4] Tile_X0Y0_S2MID[5]
+ Tile_X0Y0_S2MID[6] Tile_X0Y0_S2MID[7] Tile_X0Y0_S4END[0] Tile_X0Y0_S4END[10] Tile_X0Y0_S4END[11]
+ Tile_X0Y0_S4END[12] Tile_X0Y0_S4END[13] Tile_X0Y0_S4END[14] Tile_X0Y0_S4END[15]
+ Tile_X0Y0_S4END[1] Tile_X0Y0_S4END[2] Tile_X0Y0_S4END[3] Tile_X0Y0_S4END[4] Tile_X0Y0_S4END[5]
+ Tile_X0Y0_S4END[6] Tile_X0Y0_S4END[7] Tile_X0Y0_S4END[8] Tile_X0Y0_S4END[9] Tile_X0Y0_UserCLKo
+ Tile_X0Y0_W1BEG[0] Tile_X0Y0_W1BEG[1] Tile_X0Y0_W1BEG[2] Tile_X0Y0_W1BEG[3] Tile_X0Y0_W2BEG[0]
+ Tile_X0Y0_W2BEG[1] Tile_X0Y0_W2BEG[2] Tile_X0Y0_W2BEG[3] Tile_X0Y0_W2BEG[4] Tile_X0Y0_W2BEG[5]
+ Tile_X0Y0_W2BEG[6] Tile_X0Y0_W2BEG[7] Tile_X0Y0_W2BEGb[0] Tile_X0Y0_W2BEGb[1] Tile_X0Y0_W2BEGb[2]
+ Tile_X0Y0_W2BEGb[3] Tile_X0Y0_W2BEGb[4] Tile_X0Y0_W2BEGb[5] Tile_X0Y0_W2BEGb[6]
+ Tile_X0Y0_W2BEGb[7] Tile_X0Y0_W6BEG[0] Tile_X0Y0_W6BEG[10] Tile_X0Y0_W6BEG[11] Tile_X0Y0_W6BEG[1]
+ Tile_X0Y0_W6BEG[2] Tile_X0Y0_W6BEG[3] Tile_X0Y0_W6BEG[4] Tile_X0Y0_W6BEG[5] Tile_X0Y0_W6BEG[6]
+ Tile_X0Y0_W6BEG[7] Tile_X0Y0_W6BEG[8] Tile_X0Y0_W6BEG[9] Tile_X0Y0_WW4BEG[0] Tile_X0Y0_WW4BEG[10]
+ Tile_X0Y0_WW4BEG[11] Tile_X0Y0_WW4BEG[12] Tile_X0Y0_WW4BEG[13] Tile_X0Y0_WW4BEG[14]
+ Tile_X0Y0_WW4BEG[15] Tile_X0Y0_WW4BEG[1] Tile_X0Y0_WW4BEG[2] Tile_X0Y0_WW4BEG[3]
+ Tile_X0Y0_WW4BEG[4] Tile_X0Y0_WW4BEG[5] Tile_X0Y0_WW4BEG[6] Tile_X0Y0_WW4BEG[7]
+ Tile_X0Y0_WW4BEG[8] Tile_X0Y0_WW4BEG[9] Tile_X0Y1_E1END[0] Tile_X0Y1_E1END[1] Tile_X0Y1_E1END[2]
+ Tile_X0Y1_E1END[3] Tile_X0Y1_E2END[0] Tile_X0Y1_E2END[1] Tile_X0Y1_E2END[2] Tile_X0Y1_E2END[3]
+ Tile_X0Y1_E2END[4] Tile_X0Y1_E2END[5] Tile_X0Y1_E2END[6] Tile_X0Y1_E2END[7] Tile_X0Y1_E2MID[0]
+ Tile_X0Y1_E2MID[1] Tile_X0Y1_E2MID[2] Tile_X0Y1_E2MID[3] Tile_X0Y1_E2MID[4] Tile_X0Y1_E2MID[5]
+ Tile_X0Y1_E2MID[6] Tile_X0Y1_E2MID[7] Tile_X0Y1_E6END[0] Tile_X0Y1_E6END[10] Tile_X0Y1_E6END[11]
+ Tile_X0Y1_E6END[1] Tile_X0Y1_E6END[2] Tile_X0Y1_E6END[3] Tile_X0Y1_E6END[4] Tile_X0Y1_E6END[5]
+ Tile_X0Y1_E6END[6] Tile_X0Y1_E6END[7] Tile_X0Y1_E6END[8] Tile_X0Y1_E6END[9] Tile_X0Y1_EE4END[0]
+ Tile_X0Y1_EE4END[10] Tile_X0Y1_EE4END[11] Tile_X0Y1_EE4END[12] Tile_X0Y1_EE4END[13]
+ Tile_X0Y1_EE4END[14] Tile_X0Y1_EE4END[15] Tile_X0Y1_EE4END[1] Tile_X0Y1_EE4END[2]
+ Tile_X0Y1_EE4END[3] Tile_X0Y1_EE4END[4] Tile_X0Y1_EE4END[5] Tile_X0Y1_EE4END[6]
+ Tile_X0Y1_EE4END[7] Tile_X0Y1_EE4END[8] Tile_X0Y1_EE4END[9] Tile_X0Y1_FrameData[0]
+ Tile_X0Y1_FrameData[10] Tile_X0Y1_FrameData[11] Tile_X0Y1_FrameData[12] Tile_X0Y1_FrameData[13]
+ Tile_X0Y1_FrameData[14] Tile_X0Y1_FrameData[15] Tile_X0Y1_FrameData[16] Tile_X0Y1_FrameData[17]
+ Tile_X0Y1_FrameData[18] Tile_X0Y1_FrameData[19] Tile_X0Y1_FrameData[1] Tile_X0Y1_FrameData[20]
+ Tile_X0Y1_FrameData[21] Tile_X0Y1_FrameData[22] Tile_X0Y1_FrameData[23] Tile_X0Y1_FrameData[24]
+ Tile_X0Y1_FrameData[25] Tile_X0Y1_FrameData[26] Tile_X0Y1_FrameData[27] Tile_X0Y1_FrameData[28]
+ Tile_X0Y1_FrameData[29] Tile_X0Y1_FrameData[2] Tile_X0Y1_FrameData[30] Tile_X0Y1_FrameData[31]
+ Tile_X0Y1_FrameData[3] Tile_X0Y1_FrameData[4] Tile_X0Y1_FrameData[5] Tile_X0Y1_FrameData[6]
+ Tile_X0Y1_FrameData[7] Tile_X0Y1_FrameData[8] Tile_X0Y1_FrameData[9] Tile_X0Y1_FrameData_O[0]
+ Tile_X0Y1_FrameData_O[10] Tile_X0Y1_FrameData_O[11] Tile_X0Y1_FrameData_O[12] Tile_X0Y1_FrameData_O[13]
+ Tile_X0Y1_FrameData_O[14] Tile_X0Y1_FrameData_O[15] Tile_X0Y1_FrameData_O[16] Tile_X0Y1_FrameData_O[17]
+ Tile_X0Y1_FrameData_O[18] Tile_X0Y1_FrameData_O[19] Tile_X0Y1_FrameData_O[1] Tile_X0Y1_FrameData_O[20]
+ Tile_X0Y1_FrameData_O[21] Tile_X0Y1_FrameData_O[22] Tile_X0Y1_FrameData_O[23] Tile_X0Y1_FrameData_O[24]
+ Tile_X0Y1_FrameData_O[25] Tile_X0Y1_FrameData_O[26] Tile_X0Y1_FrameData_O[27] Tile_X0Y1_FrameData_O[28]
+ Tile_X0Y1_FrameData_O[29] Tile_X0Y1_FrameData_O[2] Tile_X0Y1_FrameData_O[30] Tile_X0Y1_FrameData_O[31]
+ Tile_X0Y1_FrameData_O[3] Tile_X0Y1_FrameData_O[4] Tile_X0Y1_FrameData_O[5] Tile_X0Y1_FrameData_O[6]
+ Tile_X0Y1_FrameData_O[7] Tile_X0Y1_FrameData_O[8] Tile_X0Y1_FrameData_O[9] Tile_X0Y1_FrameStrobe[0]
+ Tile_X0Y1_FrameStrobe[10] Tile_X0Y1_FrameStrobe[11] Tile_X0Y1_FrameStrobe[12] Tile_X0Y1_FrameStrobe[13]
+ Tile_X0Y1_FrameStrobe[14] Tile_X0Y1_FrameStrobe[15] Tile_X0Y1_FrameStrobe[16] Tile_X0Y1_FrameStrobe[17]
+ Tile_X0Y1_FrameStrobe[18] Tile_X0Y1_FrameStrobe[19] Tile_X0Y1_FrameStrobe[1] Tile_X0Y1_FrameStrobe[2]
+ Tile_X0Y1_FrameStrobe[3] Tile_X0Y1_FrameStrobe[4] Tile_X0Y1_FrameStrobe[5] Tile_X0Y1_FrameStrobe[6]
+ Tile_X0Y1_FrameStrobe[7] Tile_X0Y1_FrameStrobe[8] Tile_X0Y1_FrameStrobe[9] Tile_X0Y1_N1END[0]
+ Tile_X0Y1_N1END[1] Tile_X0Y1_N1END[2] Tile_X0Y1_N1END[3] Tile_X0Y1_N2END[0] Tile_X0Y1_N2END[1]
+ Tile_X0Y1_N2END[2] Tile_X0Y1_N2END[3] Tile_X0Y1_N2END[4] Tile_X0Y1_N2END[5] Tile_X0Y1_N2END[6]
+ Tile_X0Y1_N2END[7] Tile_X0Y1_N2MID[0] Tile_X0Y1_N2MID[1] Tile_X0Y1_N2MID[2] Tile_X0Y1_N2MID[3]
+ Tile_X0Y1_N2MID[4] Tile_X0Y1_N2MID[5] Tile_X0Y1_N2MID[6] Tile_X0Y1_N2MID[7] Tile_X0Y1_N4END[0]
+ Tile_X0Y1_N4END[10] Tile_X0Y1_N4END[11] Tile_X0Y1_N4END[12] Tile_X0Y1_N4END[13]
+ Tile_X0Y1_N4END[14] Tile_X0Y1_N4END[15] Tile_X0Y1_N4END[1] Tile_X0Y1_N4END[2] Tile_X0Y1_N4END[3]
+ Tile_X0Y1_N4END[4] Tile_X0Y1_N4END[5] Tile_X0Y1_N4END[6] Tile_X0Y1_N4END[7] Tile_X0Y1_N4END[8]
+ Tile_X0Y1_N4END[9] Tile_X0Y1_S1BEG[0] Tile_X0Y1_S1BEG[1] Tile_X0Y1_S1BEG[2] Tile_X0Y1_S1BEG[3]
+ Tile_X0Y1_S2BEG[0] Tile_X0Y1_S2BEG[1] Tile_X0Y1_S2BEG[2] Tile_X0Y1_S2BEG[3] Tile_X0Y1_S2BEG[4]
+ Tile_X0Y1_S2BEG[5] Tile_X0Y1_S2BEG[6] Tile_X0Y1_S2BEG[7] Tile_X0Y1_S2BEGb[0] Tile_X0Y1_S2BEGb[1]
+ Tile_X0Y1_S2BEGb[2] Tile_X0Y1_S2BEGb[3] Tile_X0Y1_S2BEGb[4] Tile_X0Y1_S2BEGb[5]
+ Tile_X0Y1_S2BEGb[6] Tile_X0Y1_S2BEGb[7] Tile_X0Y1_S4BEG[0] Tile_X0Y1_S4BEG[10] Tile_X0Y1_S4BEG[11]
+ Tile_X0Y1_S4BEG[12] Tile_X0Y1_S4BEG[13] Tile_X0Y1_S4BEG[14] Tile_X0Y1_S4BEG[15]
+ Tile_X0Y1_S4BEG[1] Tile_X0Y1_S4BEG[2] Tile_X0Y1_S4BEG[3] Tile_X0Y1_S4BEG[4] Tile_X0Y1_S4BEG[5]
+ Tile_X0Y1_S4BEG[6] Tile_X0Y1_S4BEG[7] Tile_X0Y1_S4BEG[8] Tile_X0Y1_S4BEG[9] Tile_X0Y1_UserCLK
+ Tile_X0Y1_W1BEG[0] Tile_X0Y1_W1BEG[1] Tile_X0Y1_W1BEG[2] Tile_X0Y1_W1BEG[3] Tile_X0Y1_W2BEG[0]
+ Tile_X0Y1_W2BEG[1] Tile_X0Y1_W2BEG[2] Tile_X0Y1_W2BEG[3] Tile_X0Y1_W2BEG[4] Tile_X0Y1_W2BEG[5]
+ Tile_X0Y1_W2BEG[6] Tile_X0Y1_W2BEG[7] Tile_X0Y1_W2BEGb[0] Tile_X0Y1_W2BEGb[1] Tile_X0Y1_W2BEGb[2]
+ Tile_X0Y1_W2BEGb[3] Tile_X0Y1_W2BEGb[4] Tile_X0Y1_W2BEGb[5] Tile_X0Y1_W2BEGb[6]
+ Tile_X0Y1_W2BEGb[7] Tile_X0Y1_W6BEG[0] Tile_X0Y1_W6BEG[10] Tile_X0Y1_W6BEG[11] Tile_X0Y1_W6BEG[1]
+ Tile_X0Y1_W6BEG[2] Tile_X0Y1_W6BEG[3] Tile_X0Y1_W6BEG[4] Tile_X0Y1_W6BEG[5] Tile_X0Y1_W6BEG[6]
+ Tile_X0Y1_W6BEG[7] Tile_X0Y1_W6BEG[8] Tile_X0Y1_W6BEG[9] Tile_X0Y1_WW4BEG[0] Tile_X0Y1_WW4BEG[10]
+ Tile_X0Y1_WW4BEG[11] Tile_X0Y1_WW4BEG[12] Tile_X0Y1_WW4BEG[13] Tile_X0Y1_WW4BEG[14]
+ Tile_X0Y1_WW4BEG[15] Tile_X0Y1_WW4BEG[1] Tile_X0Y1_WW4BEG[2] Tile_X0Y1_WW4BEG[3]
+ Tile_X0Y1_WW4BEG[4] Tile_X0Y1_WW4BEG[5] Tile_X0Y1_WW4BEG[6] Tile_X0Y1_WW4BEG[7]
+ Tile_X0Y1_WW4BEG[8] Tile_X0Y1_WW4BEG[9] VGND VPWR
X_0367_ Tile_X0Y0_IHP_SRAM_top.Inst_IHP_SRAM_top_ConfigMem.Inst_frame9_bit24.Q Tile_X0Y0_E1END[1]
+ Tile_X0Y0_E6END[5] Tile_X0Y0_IHP_SRAM_top.Inst_IHP_SRAM_top_switch_matrix.J_NS4_BEG13
+ _0059_ Tile_X0Y0_IHP_SRAM_top.Inst_IHP_SRAM_top_ConfigMem.Inst_frame9_bit25.Q Tile_X0Y0_IHP_SRAM_top.Inst_IHP_SRAM_top_switch_matrix.N1BEG1
+ VPWR VGND sg13g2_mux4_1
X_0298_ VPWR _0001_ Tile_X0Y1_E2END[5] VGND sg13g2_inv_1
XFILLER_52_18 VPWR VGND sg13g2_fill_1
XFILLER_26_52 VPWR VGND sg13g2_decap_8
XFILLER_3_23 VPWR VGND sg13g2_fill_2
XFILLER_67_92 VPWR VGND sg13g2_fill_2
X_1270_ Tile_X0Y1_FrameData[18] Tile_X0Y1_FrameStrobe[3] Tile_X0Y1_IHP_SRAM_bot.Inst_IHP_SRAM_bot_ConfigMem.Inst_frame3_bit18.Q
+ VPWR VGND sg13g2_dlhq_1
X_0985_ Tile_X0Y0_FrameData[5] Tile_X0Y1_FrameStrobe[3] Tile_X0Y0_IHP_SRAM_top.Inst_IHP_SRAM_top_ConfigMem.Inst_frame3_bit5.Q
+ VPWR VGND sg13g2_dlhq_1
X_1606_ Tile_X0Y0_IHP_SRAM_top.Inst_IHP_SRAM_top_switch_matrix.WW4BEG11 net202 VPWR
+ VGND sg13g2_buf_1
X_1537_ Tile_X0Y0_IHP_SRAM_top.Inst_IHP_SRAM_top_switch_matrix.N2BEG7 net142 VPWR
+ VGND sg13g2_buf_1
X_0419_ Tile_X0Y0_IHP_SRAM_top.Inst_IHP_SRAM_top_ConfigMem.Inst_frame7_bit16.Q Tile_X0Y0_E1END[3]
+ Tile_X0Y0_E2MID[0] Tile_X0Y0_E2END[0] Tile_X0Y0_IHP_SRAM_top.Inst_IHP_SRAM_top_switch_matrix.J_NS2_BEG7
+ Tile_X0Y0_IHP_SRAM_top.Inst_IHP_SRAM_top_ConfigMem.Inst_frame7_bit17.Q Tile_X0Y0_IHP_SRAM_top.Inst_IHP_SRAM_top_switch_matrix.S2BEG7
+ VPWR VGND sg13g2_mux4_1
X_1399_ Tile_X0Y1_FrameData[17] Tile_X0Y1_FrameStrobe[7] Tile_X0Y1_IHP_SRAM_bot.Inst_IHP_SRAM_bot_ConfigMem.Inst_frame7_bit17.Q
+ VPWR VGND sg13g2_dlhq_1
X_1468_ Tile_X0Y1_FrameData[12] Tile_X0Y1_FrameStrobe[9] Tile_X0Y1_IHP_SRAM_bot.Inst_IHP_SRAM_bot_ConfigMem.Inst_frame9_bit12.Q
+ VPWR VGND sg13g2_dlhq_1
XFILLER_63_28 VPWR VGND sg13g2_fill_1
XFILLER_5_4 VPWR VGND sg13g2_fill_2
XFILLER_53_72 VPWR VGND sg13g2_decap_4
X_0770_ VGND VPWR _0026_ _0210_ _0211_ Tile_X0Y1_IHP_SRAM_bot.Inst_IHP_SRAM_bot_ConfigMem.Inst_frame8_bit13.Q
+ sg13g2_a21oi_1
X_1322_ Tile_X0Y1_FrameData[30] Tile_X0Y1_FrameStrobe[5] Tile_X0Y1_IHP_SRAM_bot.Inst_IHP_SRAM_bot_ConfigMem.Inst_frame5_bit30.Q
+ VPWR VGND sg13g2_dlhq_1
X_1253_ Tile_X0Y1_FrameData[3] Tile_X0Y1_FrameStrobe[2] Tile_X0Y1_IHP_SRAM_bot.Inst_IHP_SRAM_bot_ConfigMem.Inst_frame2_bit3.Q
+ VPWR VGND sg13g2_dlhq_1
X_1184_ Tile_X0Y1_FrameData[8] Tile_X0Y1_FrameStrobe[0] Tile_X0Y1_IHP_SRAM_bot.Inst_IHP_SRAM_bot_ConfigMem.Inst_frame0_bit8.Q
+ VPWR VGND sg13g2_dlhq_1
X_0968_ Tile_X0Y0_FrameData[22] Tile_X0Y1_FrameStrobe[3] Tile_X0Y0_IHP_SRAM_top.Inst_IHP_SRAM_top_ConfigMem.Inst_frame3_bit22.Q
+ VPWR VGND sg13g2_dlhq_1
Xoutput231 net231 Tile_X0Y1_FrameData_O[23] VPWR VGND sg13g2_buf_1
X_0899_ Tile_X0Y0_FrameData[27] Tile_X0Y1_FrameStrobe[1] Tile_X0Y0_IHP_SRAM_top.Inst_IHP_SRAM_top_ConfigMem.Inst_frame1_bit27.Q
+ VPWR VGND sg13g2_dlhq_1
Xoutput264 net264 Tile_X0Y1_S2BEGb[4] VPWR VGND sg13g2_buf_1
Xoutput253 net253 Tile_X0Y1_S2BEG[1] VPWR VGND sg13g2_buf_1
Xoutput275 net275 Tile_X0Y1_S4BEG[1] VPWR VGND sg13g2_buf_1
Xoutput286 net286 Tile_X0Y1_W1BEG[2] VPWR VGND sg13g2_buf_1
Xoutput242 net242 Tile_X0Y1_FrameData_O[4] VPWR VGND sg13g2_buf_1
Xoutput220 net220 Tile_X0Y1_FrameData_O[13] VPWR VGND sg13g2_buf_1
XFILLER_67_180 VPWR VGND sg13g2_decap_8
XFILLER_59_158 VPWR VGND sg13g2_fill_1
Xoutput297 net297 Tile_X0Y1_W2BEGb[1] VPWR VGND sg13g2_buf_1
XFILLER_23_42 VPWR VGND sg13g2_decap_8
XFILLER_80_92 VPWR VGND sg13g2_fill_1
X_0822_ _0258_ Tile_X0Y1_IHP_SRAM_bot.Inst_IHP_SRAM_bot_ConfigMem.Inst_frame2_bit30.Q
+ Tile_X0Y1_IHP_SRAM_bot.Inst_IHP_SRAM_bot_ConfigMem.Inst_frame2_bit29.Q VPWR VGND
+ sg13g2_nand2b_1
X_0684_ _0162_ VPWR net1 VGND Tile_X0Y1_IHP_SRAM_bot.Inst_IHP_SRAM_bot_ConfigMem.Inst_frame4_bit19.Q
+ _0164_ sg13g2_o21ai_1
X_0753_ VGND VPWR _0022_ _0194_ _0196_ _0195_ sg13g2_a21oi_1
X_1305_ Tile_X0Y1_FrameData[15] Tile_X0Y1_FrameStrobe[4] Tile_X0Y1_IHP_SRAM_bot.Inst_IHP_SRAM_bot_ConfigMem.Inst_frame4_bit15.Q
+ VPWR VGND sg13g2_dlhq_1
X_1236_ Tile_X0Y1_FrameData[20] Tile_X0Y1_FrameStrobe[2] Tile_X0Y1_IHP_SRAM_bot.Inst_IHP_SRAM_bot_ConfigMem.Inst_frame2_bit20.Q
+ VPWR VGND sg13g2_dlhq_1
XFILLER_29_0 VPWR VGND sg13g2_decap_8
XFILLER_100_36 VPWR VGND sg13g2_fill_2
XFILLER_100_25 VPWR VGND sg13g2_decap_8
X_1098_ Tile_X0Y0_FrameData[20] Tile_X0Y1_FrameStrobe[7] Tile_X0Y0_IHP_SRAM_top.Inst_IHP_SRAM_top_ConfigMem.Inst_frame7_bit20.Q
+ VPWR VGND sg13g2_dlhq_1
X_1167_ Tile_X0Y1_FrameData[25] Tile_X0Y1_FrameStrobe[0] Tile_X0Y1_IHP_SRAM_bot.Inst_IHP_SRAM_bot_ConfigMem.Inst_frame0_bit25.Q
+ VPWR VGND sg13g2_dlhq_1
XFILLER_100_69 VPWR VGND sg13g2_decap_8
XFILLER_18_53 VPWR VGND sg13g2_fill_1
XFILLER_34_96 VPWR VGND sg13g2_fill_1
X_1021_ Tile_X0Y0_FrameData[1] Tile_X0Y1_FrameStrobe[4] Tile_X0Y0_IHP_SRAM_top.Inst_IHP_SRAM_top_ConfigMem.Inst_frame4_bit1.Q
+ VPWR VGND sg13g2_dlhq_1
X_0805_ Tile_X0Y1_IHP_SRAM_bot.Inst_IHP_SRAM_bot_ConfigMem.Inst_frame7_bit13.Q VPWR
+ _0243_ VGND Tile_X0Y1_IHP_SRAM_bot.Inst_IHP_SRAM_bot_ConfigMem.Inst_frame7_bit12.Q
+ Tile_X0Y1_IHP_SRAM_bot.Inst_IHP_SRAM_bot_switch_matrix.J_NS4_BEG14 sg13g2_o21ai_1
X_0598_ Tile_X0Y0_IHP_SRAM_top.Inst_IHP_SRAM_top_ConfigMem.Inst_frame7_bit28.Q VPWR
+ _0153_ VGND Tile_X0Y0_IHP_SRAM_top.Inst_IHP_SRAM_top_ConfigMem.Inst_frame7_bit27.Q
+ Tile_X0Y0_IHP_SRAM_top.Inst_IHP_SRAM_top_switch_matrix.J_NS4_BEG15 sg13g2_o21ai_1
X_0667_ Tile_X0Y1_IHP_SRAM_bot.Inst_IHP_SRAM_bot_ConfigMem.Inst_frame1_bit8.Q Tile_X0Y1_N1END[0]
+ Tile_X0Y1_N4END[0] _0088_ Tile_X0Y0_S4END[4] Tile_X0Y1_IHP_SRAM_bot.Inst_IHP_SRAM_bot_ConfigMem.Inst_frame1_bit9.Q
+ _0161_ VPWR VGND sg13g2_mux4_1
X_0736_ Tile_X0Y1_E1END[0] Tile_X0Y1_EE4END[0] Tile_X0Y1_IHP_SRAM_bot.Inst_IHP_SRAM_bot_ConfigMem.Inst_frame8_bit2.Q
+ _0180_ VPWR VGND sg13g2_mux2_1
X_1219_ Tile_X0Y1_FrameData[5] Tile_X0Y1_FrameStrobe[1] Tile_X0Y1_IHP_SRAM_bot.Inst_IHP_SRAM_bot_ConfigMem.Inst_frame1_bit5.Q
+ VPWR VGND sg13g2_dlhq_1
XFILLER_106_144 VPWR VGND sg13g2_decap_8
XFILLER_96_25 VPWR VGND sg13g2_decap_8
X_0452_ Tile_X0Y0_IHP_SRAM_top.Inst_IHP_SRAM_top_ConfigMem.Inst_frame5_bit6.Q A_DOUT_SRAM16
+ A_DOUT_SRAM28 Tile_X0Y0_IHP_SRAM_top.Inst_IHP_SRAM_top_switch_matrix.J_NS4_BEG15
+ Tile_X0Y0_IHP_SRAM_top.Inst_IHP_SRAM_top_switch_matrix.J_NS2_BEG7 Tile_X0Y0_IHP_SRAM_top.Inst_IHP_SRAM_top_ConfigMem.Inst_frame5_bit7.Q
+ Tile_X0Y0_IHP_SRAM_top.Inst_IHP_SRAM_top_switch_matrix.WW4BEG0 VPWR VGND sg13g2_mux4_1
X_0521_ Tile_X0Y0_IHP_SRAM_top.Inst_IHP_SRAM_top_ConfigMem.Inst_frame2_bit22.Q Tile_X0Y0_E1END[0]
+ Tile_X0Y0_EE4END[4] Tile_X0Y0_EE4END[12] Tile_X0Y0_IHP_SRAM_top.Inst_IHP_SRAM_top_switch_matrix.J_NS4_BEG12
+ Tile_X0Y0_IHP_SRAM_top.Inst_IHP_SRAM_top_ConfigMem.Inst_frame2_bit23.Q net32 VPWR
+ VGND sg13g2_mux4_1
XANTENNA_5 VPWR VGND A_DOUT_SRAM18 sg13g2_antennanp
X_1570_ Tile_X0Y0_IHP_SRAM_top.Inst_IHP_SRAM_top_switch_matrix.W2BEG3 net175 VPWR
+ VGND sg13g2_buf_1
X_0383_ _0076_ _0074_ Tile_X0Y1_IHP_SRAM_bot.Inst_IHP_SRAM_bot_ConfigMem.Inst_frame0_bit30.Q
+ VPWR VGND sg13g2_nand2b_1
XFILLER_96_0 VPWR VGND sg13g2_fill_1
X_1004_ Tile_X0Y0_FrameData[18] Tile_X0Y1_FrameStrobe[4] Tile_X0Y0_IHP_SRAM_top.Inst_IHP_SRAM_top_ConfigMem.Inst_frame4_bit18.Q
+ VPWR VGND sg13g2_dlhq_1
XFILLER_106_46 VPWR VGND sg13g2_decap_8
XFILLER_103_147 VPWR VGND sg13g2_decap_8
X_1699_ Tile_X0Y1_IHP_SRAM_bot.Inst_IHP_SRAM_bot_switch_matrix.W6BEG0 net304 VPWR
+ VGND sg13g2_buf_1
X_0719_ Tile_X0Y1_IHP_SRAM_bot.Inst_IHP_SRAM_bot_ConfigMem.Inst_frame2_bit0.Q Tile_X0Y1_EE4END[2]
+ Tile_X0Y1_EE4END[10] Tile_X0Y1_E6END[2] _0159_ Tile_X0Y1_IHP_SRAM_bot.Inst_IHP_SRAM_bot_ConfigMem.Inst_frame2_bit1.Q
+ net23 VPWR VGND sg13g2_mux4_1
XFILLER_72_215 VPWR VGND sg13g2_fill_1
XFILLER_25_142 VPWR VGND sg13g2_fill_2
XFILLER_15_98 VPWR VGND sg13g2_fill_1
XFILLER_31_20 VPWR VGND sg13g2_fill_1
XFILLER_40_134 VPWR VGND sg13g2_fill_1
Xoutput64 net64 A_DIN_SRAM27 VPWR VGND sg13g2_buf_1
Xoutput75 net75 A_DIN_SRAM9 VPWR VGND sg13g2_buf_1
Xoutput53 net53 A_DIN_SRAM17 VPWR VGND sg13g2_buf_1
Xoutput7 net7 A_ADDR_SRAM6 VPWR VGND sg13g2_buf_1
Xoutput42 net42 A_BM_SRAM9 VPWR VGND sg13g2_buf_1
Xoutput20 net20 A_BM_SRAM17 VPWR VGND sg13g2_buf_1
Xoutput31 net31 A_BM_SRAM27 VPWR VGND sg13g2_buf_1
Xoutput97 net97 Tile_X0Y0_FrameData_O[26] VPWR VGND sg13g2_buf_1
Xoutput86 net86 Tile_X0Y0_FrameData_O[16] VPWR VGND sg13g2_buf_1
XFILLER_82_6 VPWR VGND sg13g2_fill_1
X_1622_ Tile_X0Y1_FrameData[11] net218 VPWR VGND sg13g2_buf_1
X_0504_ Tile_X0Y0_IHP_SRAM_top.Inst_IHP_SRAM_top_ConfigMem.Inst_frame3_bit20.Q Tile_X0Y0_EE4END[3]
+ Tile_X0Y0_EE4END[11] Tile_X0Y0_E6END[11] Tile_X0Y0_IHP_SRAM_top.Inst_IHP_SRAM_top_switch_matrix.J_NS4_BEG11
+ Tile_X0Y0_IHP_SRAM_top.Inst_IHP_SRAM_top_ConfigMem.Inst_frame3_bit21.Q net64 VPWR
+ VGND sg13g2_mux4_1
X_1484_ Tile_X0Y0_FrameData[10] net80 VPWR VGND sg13g2_buf_1
X_0435_ Tile_X0Y0_IHP_SRAM_top.Inst_IHP_SRAM_top_ConfigMem.Inst_frame6_bit5.Q Tile_X0Y0_IHP_SRAM_top.Inst_IHP_SRAM_top_switch_matrix.N1END3
+ A_DOUT_SRAM17 Tile_X0Y0_S1END[3] A_DOUT_SRAM20 Tile_X0Y0_IHP_SRAM_top.Inst_IHP_SRAM_top_ConfigMem.Inst_frame6_bit4.Q
+ Tile_X0Y0_IHP_SRAM_top.Inst_IHP_SRAM_top_switch_matrix.W1BEG3 VPWR VGND sg13g2_mux4_1
X_1553_ Tile_X0Y1_N4END[15] net164 VPWR VGND sg13g2_buf_1
X_0366_ Tile_X0Y0_IHP_SRAM_top.Inst_IHP_SRAM_top_ConfigMem.Inst_frame0_bit2.Q Tile_X0Y0_IHP_SRAM_top.Inst_IHP_SRAM_top_switch_matrix.N1END1
+ Tile_X0Y1_N4END[5] Tile_X0Y0_S1END[1] Tile_X0Y0_S4END[1] Tile_X0Y0_IHP_SRAM_top.Inst_IHP_SRAM_top_ConfigMem.Inst_frame0_bit3.Q
+ Tile_X0Y0_IHP_SRAM_top.Inst_IHP_SRAM_top_switch_matrix.J_NS4_BEG13 VPWR VGND sg13g2_mux4_1
XFILLER_11_0 VPWR VGND sg13g2_fill_1
X_0297_ VPWR _0000_ Tile_X0Y1_E2MID[3] VGND sg13g2_inv_1
XFILLER_45_215 VPWR VGND sg13g2_fill_1
XFILLER_42_85 VPWR VGND sg13g2_decap_8
XFILLER_95_137 VPWR VGND sg13g2_decap_4
XFILLER_36_215 VPWR VGND sg13g2_fill_1
X_0984_ Tile_X0Y0_FrameData[6] Tile_X0Y1_FrameStrobe[3] Tile_X0Y0_IHP_SRAM_top.Inst_IHP_SRAM_top_ConfigMem.Inst_frame3_bit6.Q
+ VPWR VGND sg13g2_dlhq_1
X_1536_ Tile_X0Y0_IHP_SRAM_top.Inst_IHP_SRAM_top_switch_matrix.N2BEG6 net141 VPWR
+ VGND sg13g2_buf_1
X_1605_ Tile_X0Y0_IHP_SRAM_top.Inst_IHP_SRAM_top_switch_matrix.WW4BEG10 net201 VPWR
+ VGND sg13g2_buf_1
XFILLER_103_14 VPWR VGND sg13g2_fill_1
X_0418_ Tile_X0Y0_IHP_SRAM_top.Inst_IHP_SRAM_top_ConfigMem.Inst_frame8_bit10.Q Tile_X0Y0_E2MID[1]
+ Tile_X0Y0_E2END[1] Tile_X0Y0_E6END[1] Tile_X0Y0_IHP_SRAM_top.Inst_IHP_SRAM_top_switch_matrix.J_NS2_BEG6
+ Tile_X0Y0_IHP_SRAM_top.Inst_IHP_SRAM_top_ConfigMem.Inst_frame8_bit11.Q Tile_X0Y0_IHP_SRAM_top.Inst_IHP_SRAM_top_switch_matrix.N2BEG6
+ VPWR VGND sg13g2_mux4_1
X_1398_ Tile_X0Y1_FrameData[18] Tile_X0Y1_FrameStrobe[7] Tile_X0Y1_IHP_SRAM_bot.Inst_IHP_SRAM_bot_ConfigMem.Inst_frame7_bit18.Q
+ VPWR VGND sg13g2_dlhq_1
X_0349_ _0048_ VPWR _0049_ VGND Tile_X0Y1_IHP_SRAM_bot.Inst_IHP_SRAM_bot_ConfigMem.Inst_frame1_bit2.Q
+ Tile_X0Y1_E2END[3] sg13g2_o21ai_1
X_1467_ Tile_X0Y1_FrameData[13] Tile_X0Y1_FrameStrobe[9] Tile_X0Y1_IHP_SRAM_bot.Inst_IHP_SRAM_bot_ConfigMem.Inst_frame9_bit13.Q
+ VPWR VGND sg13g2_dlhq_1
XFILLER_12_44 VPWR VGND sg13g2_fill_1
XFILLER_12_99 VPWR VGND sg13g2_fill_2
XFILLER_37_85 VPWR VGND sg13g2_decap_8
XFILLER_37_96 VPWR VGND sg13g2_fill_1
XFILLER_83_129 VPWR VGND sg13g2_fill_2
X_1252_ Tile_X0Y1_FrameData[4] Tile_X0Y1_FrameStrobe[2] Tile_X0Y1_IHP_SRAM_bot.Inst_IHP_SRAM_bot_ConfigMem.Inst_frame2_bit4.Q
+ VPWR VGND sg13g2_dlhq_1
X_1321_ Tile_X0Y1_FrameData[31] Tile_X0Y1_FrameStrobe[5] Tile_X0Y1_IHP_SRAM_bot.Inst_IHP_SRAM_bot_ConfigMem.Inst_frame5_bit31.Q
+ VPWR VGND sg13g2_dlhq_1
X_1183_ Tile_X0Y1_FrameData[9] Tile_X0Y1_FrameStrobe[0] Tile_X0Y1_IHP_SRAM_bot.Inst_IHP_SRAM_bot_ConfigMem.Inst_frame0_bit9.Q
+ VPWR VGND sg13g2_dlhq_1
X_0967_ Tile_X0Y0_FrameData[23] Tile_X0Y1_FrameStrobe[3] Tile_X0Y0_IHP_SRAM_top.Inst_IHP_SRAM_top_ConfigMem.Inst_frame3_bit23.Q
+ VPWR VGND sg13g2_dlhq_1
X_1519_ Tile_X0Y1_FrameStrobe[13] net115 VPWR VGND sg13g2_buf_1
X_0898_ Tile_X0Y0_FrameData[28] Tile_X0Y1_FrameStrobe[1] Tile_X0Y0_IHP_SRAM_top.Inst_IHP_SRAM_top_ConfigMem.Inst_frame1_bit28.Q
+ VPWR VGND sg13g2_dlhq_1
Xoutput210 net210 Tile_X0Y0_WW4BEG[4] VPWR VGND sg13g2_buf_1
Xoutput232 net232 Tile_X0Y1_FrameData_O[24] VPWR VGND sg13g2_buf_1
Xoutput298 net298 Tile_X0Y1_W2BEGb[2] VPWR VGND sg13g2_buf_1
Xoutput265 net265 Tile_X0Y1_S2BEGb[5] VPWR VGND sg13g2_buf_1
Xoutput254 net254 Tile_X0Y1_S2BEG[2] VPWR VGND sg13g2_buf_1
Xoutput276 net276 Tile_X0Y1_S4BEG[2] VPWR VGND sg13g2_buf_1
Xoutput287 net287 Tile_X0Y1_W1BEG[3] VPWR VGND sg13g2_buf_1
Xoutput243 net243 Tile_X0Y1_FrameData_O[5] VPWR VGND sg13g2_buf_1
Xoutput221 net221 Tile_X0Y1_FrameData_O[14] VPWR VGND sg13g2_buf_1
XFILLER_2_188 VPWR VGND sg13g2_decap_8
XFILLER_48_40 VPWR VGND sg13g2_fill_2
XFILLER_9_56 VPWR VGND sg13g2_fill_2
X_0821_ Tile_X0Y1_IHP_SRAM_bot.Inst_IHP_SRAM_bot_ConfigMem.Inst_frame2_bit30.Q Tile_X0Y1_IHP_SRAM_bot.Inst_IHP_SRAM_bot_ConfigMem.Inst_frame2_bit29.Q
+ _0257_ VPWR VGND sg13g2_nor2b_1
X_0752_ Tile_X0Y1_IHP_SRAM_bot.Inst_IHP_SRAM_bot_ConfigMem.Inst_frame8_bit7.Q VPWR
+ _0195_ VGND _0192_ _0193_ sg13g2_o21ai_1
X_0683_ VGND VPWR Tile_X0Y1_E2END[0] Tile_X0Y1_IHP_SRAM_bot.Inst_IHP_SRAM_bot_ConfigMem.Inst_frame4_bit18.Q
+ _0164_ _0163_ sg13g2_a21oi_1
X_1304_ Tile_X0Y1_FrameData[16] Tile_X0Y1_FrameStrobe[4] Tile_X0Y1_IHP_SRAM_bot.Inst_IHP_SRAM_bot_ConfigMem.Inst_frame4_bit16.Q
+ VPWR VGND sg13g2_dlhq_1
X_1235_ Tile_X0Y1_FrameData[21] Tile_X0Y1_FrameStrobe[2] Tile_X0Y1_IHP_SRAM_bot.Inst_IHP_SRAM_bot_ConfigMem.Inst_frame2_bit21.Q
+ VPWR VGND sg13g2_dlhq_1
X_1166_ Tile_X0Y1_FrameData[26] Tile_X0Y1_FrameStrobe[0] Tile_X0Y1_IHP_SRAM_bot.Inst_IHP_SRAM_bot_ConfigMem.Inst_frame0_bit26.Q
+ VPWR VGND sg13g2_dlhq_1
X_1097_ Tile_X0Y0_FrameData[21] Tile_X0Y1_FrameStrobe[7] Tile_X0Y0_IHP_SRAM_top.Inst_IHP_SRAM_top_ConfigMem.Inst_frame7_bit21.Q
+ VPWR VGND sg13g2_dlhq_1
XFILLER_85_27 VPWR VGND sg13g2_fill_1
XFILLER_70_154 VPWR VGND sg13g2_fill_1
XFILLER_109_186 VPWR VGND sg13g2_fill_1
XFILLER_50_85 VPWR VGND sg13g2_fill_1
X_1020_ Tile_X0Y0_FrameData[2] Tile_X0Y1_FrameStrobe[4] Tile_X0Y0_IHP_SRAM_top.Inst_IHP_SRAM_top_ConfigMem.Inst_frame4_bit2.Q
+ VPWR VGND sg13g2_dlhq_1
XFILLER_38_118 VPWR VGND sg13g2_decap_8
XFILLER_98_4 VPWR VGND sg13g2_fill_2
X_0735_ _0178_ VPWR _0179_ VGND _0019_ _0161_ sg13g2_o21ai_1
X_0804_ _0031_ _0083_ _0242_ VPWR VGND sg13g2_nor2_1
X_0597_ Tile_X0Y0_IHP_SRAM_top.Inst_IHP_SRAM_top_switch_matrix.J_NS2_BEG7 Tile_X0Y0_IHP_SRAM_top.Inst_IHP_SRAM_top_ConfigMem.Inst_frame7_bit27.Q
+ _0152_ VPWR VGND sg13g2_nor2b_1
XFILLER_69_210 VPWR VGND sg13g2_fill_2
X_0666_ Tile_X0Y1_IHP_SRAM_bot.Inst_IHP_SRAM_bot_ConfigMem.Inst_frame5_bit22.Q A_DOUT_SRAM2
+ A_DOUT_SRAM14 _0160_ _0078_ Tile_X0Y1_IHP_SRAM_bot.Inst_IHP_SRAM_bot_ConfigMem.Inst_frame5_bit23.Q
+ Tile_X0Y1_IHP_SRAM_bot.Inst_IHP_SRAM_bot_switch_matrix.WW4BEG14 VPWR VGND sg13g2_mux4_1
XFILLER_41_0 VPWR VGND sg13g2_fill_2
X_1149_ Tile_X0Y0_FrameData[1] Tile_X0Y1_FrameStrobe[8] Tile_X0Y0_IHP_SRAM_top.Inst_IHP_SRAM_top_ConfigMem.Inst_frame8_bit1.Q
+ VPWR VGND sg13g2_dlhq_1
X_1218_ Tile_X0Y1_FrameData[6] Tile_X0Y1_FrameStrobe[1] Tile_X0Y1_IHP_SRAM_bot.Inst_IHP_SRAM_bot_ConfigMem.Inst_frame1_bit6.Q
+ VPWR VGND sg13g2_dlhq_1
XFILLER_71_18 VPWR VGND sg13g2_fill_2
XFILLER_52_176 VPWR VGND sg13g2_fill_2
XFILLER_106_123 VPWR VGND sg13g2_decap_8
XFILLER_20_77 VPWR VGND sg13g2_fill_2
XFILLER_43_187 VPWR VGND sg13g2_fill_1
XFILLER_45_41 VPWR VGND sg13g2_decap_8
XANTENNA_6 VPWR VGND A_DOUT_SRAM18 sg13g2_antennanp
X_0520_ Tile_X0Y0_IHP_SRAM_top.Inst_IHP_SRAM_top_ConfigMem.Inst_frame2_bit20.Q Tile_X0Y0_EE4END[3]
+ Tile_X0Y0_EE4END[11] Tile_X0Y0_E6END[11] Tile_X0Y0_IHP_SRAM_top.Inst_IHP_SRAM_top_switch_matrix.J_NS4_BEG11
+ Tile_X0Y0_IHP_SRAM_top.Inst_IHP_SRAM_top_ConfigMem.Inst_frame2_bit21.Q net31 VPWR
+ VGND sg13g2_mux4_1
X_0451_ Tile_X0Y0_IHP_SRAM_top.Inst_IHP_SRAM_top_ConfigMem.Inst_frame5_bit4.Q A_DOUT_SRAM23
+ A_DOUT_SRAM31 Tile_X0Y0_IHP_SRAM_top.Inst_IHP_SRAM_top_switch_matrix.J_NS2_BEG0
+ Tile_X0Y0_IHP_SRAM_top.Inst_IHP_SRAM_top_switch_matrix.J_NS2_BEG7 Tile_X0Y0_IHP_SRAM_top.Inst_IHP_SRAM_top_ConfigMem.Inst_frame5_bit5.Q
+ Tile_X0Y0_IHP_SRAM_top.Inst_IHP_SRAM_top_switch_matrix.W2BEGb7 VPWR VGND sg13g2_mux4_1
X_0382_ Tile_X0Y1_N1END[3] Tile_X0Y1_IHP_SRAM_bot.Inst_IHP_SRAM_bot_ConfigMem.Inst_frame0_bit30.Q
+ Tile_X0Y1_IHP_SRAM_bot.Inst_IHP_SRAM_bot_ConfigMem.Inst_frame0_bit31.Q _0075_ VPWR
+ VGND sg13g2_nor3_1
X_1003_ Tile_X0Y0_FrameData[19] Tile_X0Y1_FrameStrobe[4] Tile_X0Y0_IHP_SRAM_top.Inst_IHP_SRAM_top_ConfigMem.Inst_frame4_bit19.Q
+ VPWR VGND sg13g2_dlhq_1
XFILLER_89_0 VPWR VGND sg13g2_fill_1
X_1698_ Tile_X0Y1_IHP_SRAM_bot.Inst_IHP_SRAM_bot_switch_matrix.W2BEGb7 net303 VPWR
+ VGND sg13g2_buf_1
X_0718_ Tile_X0Y1_IHP_SRAM_bot.Inst_IHP_SRAM_bot_ConfigMem.Inst_frame3_bit30.Q Tile_X0Y1_EE4END[1]
+ Tile_X0Y1_EE4END[9] Tile_X0Y1_E6END[1] _0160_ Tile_X0Y1_IHP_SRAM_bot.Inst_IHP_SRAM_bot_ConfigMem.Inst_frame3_bit31.Q
+ net12 VPWR VGND sg13g2_mux4_1
XFILLER_103_126 VPWR VGND sg13g2_decap_8
XFILLER_57_213 VPWR VGND sg13g2_fill_2
X_0649_ Tile_X0Y1_IHP_SRAM_bot.Inst_IHP_SRAM_bot_ConfigMem.Inst_frame1_bit26.Q Tile_X0Y1_N1END[1]
+ Tile_X0Y1_N4END[1] _0060_ Tile_X0Y0_S4END[5] Tile_X0Y1_IHP_SRAM_bot.Inst_IHP_SRAM_bot_ConfigMem.Inst_frame1_bit27.Q
+ Tile_X0Y1_IHP_SRAM_bot.Inst_IHP_SRAM_bot_switch_matrix.J_NS4_BEG9 VPWR VGND sg13g2_mux4_1
XFILLER_82_28 VPWR VGND sg13g2_fill_1
XFILLER_40_179 VPWR VGND sg13g2_fill_1
Xoutput98 net98 Tile_X0Y0_FrameData_O[27] VPWR VGND sg13g2_buf_1
Xoutput87 net87 Tile_X0Y0_FrameData_O[17] VPWR VGND sg13g2_buf_1
Xoutput10 net10 A_ADDR_SRAM9 VPWR VGND sg13g2_buf_1
Xoutput8 net8 A_ADDR_SRAM7 VPWR VGND sg13g2_buf_1
Xoutput65 net65 A_DIN_SRAM28 VPWR VGND sg13g2_buf_1
Xoutput54 net54 A_DIN_SRAM18 VPWR VGND sg13g2_buf_1
Xoutput21 net21 A_BM_SRAM18 VPWR VGND sg13g2_buf_1
Xoutput32 net32 A_BM_SRAM28 VPWR VGND sg13g2_buf_1
Xoutput43 net43 A_CLK_SRAM VPWR VGND sg13g2_buf_1
Xoutput76 net76 A_MEN_SRAM VPWR VGND sg13g2_buf_1
XFILLER_31_146 VPWR VGND sg13g2_fill_2
XFILLER_31_168 VPWR VGND sg13g2_fill_1
X_1552_ Tile_X0Y1_N4END[14] net163 VPWR VGND sg13g2_buf_1
X_1621_ Tile_X0Y1_FrameData[10] net217 VPWR VGND sg13g2_buf_1
X_1483_ Tile_X0Y0_FrameData[9] net110 VPWR VGND sg13g2_buf_1
X_0503_ Tile_X0Y0_IHP_SRAM_top.Inst_IHP_SRAM_top_ConfigMem.Inst_frame3_bit18.Q Tile_X0Y0_EE4END[2]
+ Tile_X0Y0_EE4END[10] Tile_X0Y0_E6END[10] Tile_X0Y0_IHP_SRAM_top.Inst_IHP_SRAM_top_switch_matrix.J_NS4_BEG10
+ Tile_X0Y0_IHP_SRAM_top.Inst_IHP_SRAM_top_ConfigMem.Inst_frame3_bit19.Q net63 VPWR
+ VGND sg13g2_mux4_1
X_0434_ Tile_X0Y0_IHP_SRAM_top.Inst_IHP_SRAM_top_ConfigMem.Inst_frame6_bit3.Q Tile_X0Y0_IHP_SRAM_top.Inst_IHP_SRAM_top_switch_matrix.N1END2
+ A_DOUT_SRAM16 Tile_X0Y0_S1END[2] A_DOUT_SRAM21 Tile_X0Y0_IHP_SRAM_top.Inst_IHP_SRAM_top_ConfigMem.Inst_frame6_bit2.Q
+ Tile_X0Y0_IHP_SRAM_top.Inst_IHP_SRAM_top_switch_matrix.W1BEG2 VPWR VGND sg13g2_mux4_1
X_0365_ Tile_X0Y1_IHP_SRAM_bot.Inst_IHP_SRAM_bot_ConfigMem.Inst_frame9_bit13.Q Tile_X0Y1_E1END[1]
+ Tile_X0Y1_IHP_SRAM_bot.Inst_IHP_SRAM_bot_switch_matrix.J_NS4_BEG13 Tile_X0Y1_E6END[5]
+ _0063_ Tile_X0Y1_IHP_SRAM_bot.Inst_IHP_SRAM_bot_ConfigMem.Inst_frame9_bit12.Q Tile_X0Y0_IHP_SRAM_top.Inst_IHP_SRAM_top_switch_matrix.N1END1
+ VPWR VGND sg13g2_mux4_1
XFILLER_97_190 VPWR VGND sg13g2_fill_2
XFILLER_67_94 VPWR VGND sg13g2_fill_1
X_0983_ Tile_X0Y0_FrameData[7] Tile_X0Y1_FrameStrobe[3] Tile_X0Y0_IHP_SRAM_top.Inst_IHP_SRAM_top_ConfigMem.Inst_frame3_bit7.Q
+ VPWR VGND sg13g2_dlhq_1
X_1535_ Tile_X0Y0_IHP_SRAM_top.Inst_IHP_SRAM_top_switch_matrix.N2BEG5 net140 VPWR
+ VGND sg13g2_buf_1
X_1604_ Tile_X0Y0_IHP_SRAM_top.Inst_IHP_SRAM_top_switch_matrix.WW4BEG9 net215 VPWR
+ VGND sg13g2_buf_1
X_0417_ Tile_X0Y0_IHP_SRAM_top.Inst_IHP_SRAM_top_ConfigMem.Inst_frame0_bit21.Q Tile_X0Y0_IHP_SRAM_top.Inst_IHP_SRAM_top_switch_matrix.N2BEGb6
+ Tile_X0Y0_S2MID[6] Tile_X0Y1_N2MID[6] Tile_X0Y0_S2END[6] Tile_X0Y0_IHP_SRAM_top.Inst_IHP_SRAM_top_ConfigMem.Inst_frame0_bit20.Q
+ Tile_X0Y0_IHP_SRAM_top.Inst_IHP_SRAM_top_switch_matrix.J_NS2_BEG6 VPWR VGND sg13g2_mux4_1
X_1397_ Tile_X0Y1_FrameData[19] Tile_X0Y1_FrameStrobe[7] Tile_X0Y1_IHP_SRAM_bot.Inst_IHP_SRAM_bot_ConfigMem.Inst_frame7_bit19.Q
+ VPWR VGND sg13g2_dlhq_1
X_1466_ Tile_X0Y1_FrameData[14] Tile_X0Y1_FrameStrobe[9] Tile_X0Y1_IHP_SRAM_bot.Inst_IHP_SRAM_bot_ConfigMem.Inst_frame9_bit14.Q
+ VPWR VGND sg13g2_dlhq_1
X_0348_ _0048_ Tile_X0Y1_IHP_SRAM_bot.Inst_IHP_SRAM_bot_ConfigMem.Inst_frame1_bit2.Q
+ _0002_ VPWR VGND sg13g2_nand2_1
XFILLER_77_149 VPWR VGND sg13g2_decap_4
XFILLER_5_6 VPWR VGND sg13g2_fill_1
XFILLER_5_197 VPWR VGND sg13g2_decap_8
X_1320_ Tile_X0Y1_FrameData[0] Tile_X0Y1_FrameStrobe[4] Tile_X0Y1_IHP_SRAM_bot.Inst_IHP_SRAM_bot_ConfigMem.Inst_frame4_bit0.Q
+ VPWR VGND sg13g2_dlhq_1
X_1251_ Tile_X0Y1_FrameData[5] Tile_X0Y1_FrameStrobe[2] Tile_X0Y1_IHP_SRAM_bot.Inst_IHP_SRAM_bot_ConfigMem.Inst_frame2_bit5.Q
+ VPWR VGND sg13g2_dlhq_1
X_1182_ Tile_X0Y1_FrameData[10] Tile_X0Y1_FrameStrobe[0] Tile_X0Y1_IHP_SRAM_bot.Inst_IHP_SRAM_bot_ConfigMem.Inst_frame0_bit10.Q
+ VPWR VGND sg13g2_dlhq_1
X_0897_ Tile_X0Y0_FrameData[29] Tile_X0Y1_FrameStrobe[1] Tile_X0Y0_IHP_SRAM_top.Inst_IHP_SRAM_top_ConfigMem.Inst_frame1_bit29.Q
+ VPWR VGND sg13g2_dlhq_1
XFILLER_71_0 VPWR VGND sg13g2_fill_1
Xoutput200 net200 Tile_X0Y0_WW4BEG[0] VPWR VGND sg13g2_buf_1
X_0966_ Tile_X0Y0_FrameData[24] Tile_X0Y1_FrameStrobe[3] Tile_X0Y0_IHP_SRAM_top.Inst_IHP_SRAM_top_ConfigMem.Inst_frame3_bit24.Q
+ VPWR VGND sg13g2_dlhq_1
X_1518_ Tile_X0Y1_FrameStrobe[12] net114 VPWR VGND sg13g2_buf_1
XFILLER_101_202 VPWR VGND sg13g2_decap_4
Xoutput211 net211 Tile_X0Y0_WW4BEG[5] VPWR VGND sg13g2_buf_1
Xoutput233 net233 Tile_X0Y1_FrameData_O[25] VPWR VGND sg13g2_buf_1
Xoutput255 net255 Tile_X0Y1_S2BEG[3] VPWR VGND sg13g2_buf_1
Xoutput266 net266 Tile_X0Y1_S2BEGb[6] VPWR VGND sg13g2_buf_1
Xoutput277 net277 Tile_X0Y1_S4BEG[3] VPWR VGND sg13g2_buf_1
Xoutput288 net288 Tile_X0Y1_W2BEG[0] VPWR VGND sg13g2_buf_1
Xoutput299 net299 Tile_X0Y1_W2BEGb[3] VPWR VGND sg13g2_buf_1
Xoutput244 net244 Tile_X0Y1_FrameData_O[6] VPWR VGND sg13g2_buf_1
X_1449_ Tile_X0Y1_FrameData[31] Tile_X0Y1_FrameStrobe[9] Tile_X0Y1_IHP_SRAM_bot.Inst_IHP_SRAM_bot_ConfigMem.Inst_frame9_bit31.Q
+ VPWR VGND sg13g2_dlhq_1
Xoutput222 net222 Tile_X0Y1_FrameData_O[15] VPWR VGND sg13g2_buf_1
XFILLER_82_130 VPWR VGND sg13g2_decap_8
XFILLER_90_39 VPWR VGND sg13g2_fill_1
XFILLER_23_88 VPWR VGND sg13g2_decap_8
XFILLER_23_99 VPWR VGND sg13g2_fill_1
XFILLER_65_108 VPWR VGND sg13g2_decap_4
XFILLER_64_73 VPWR VGND sg13g2_decap_4
X_0820_ VGND VPWR _0249_ _0251_ Tile_X0Y1_IHP_SRAM_bot.Inst_IHP_SRAM_bot_switch_matrix.S4BEG3
+ _0256_ sg13g2_a21oi_1
X_0751_ Tile_X0Y1_IHP_SRAM_bot.Inst_IHP_SRAM_bot_switch_matrix.J_NS4_BEG5 Tile_X0Y1_IHP_SRAM_bot.Inst_IHP_SRAM_bot_switch_matrix.J_NS4_BEG9
+ Tile_X0Y1_IHP_SRAM_bot.Inst_IHP_SRAM_bot_ConfigMem.Inst_frame8_bit5.Q _0194_ VPWR
+ VGND sg13g2_mux2_1
XFILLER_96_211 VPWR VGND sg13g2_fill_1
X_0682_ Tile_X0Y1_IHP_SRAM_bot.Inst_IHP_SRAM_bot_ConfigMem.Inst_frame4_bit18.Q Tile_X0Y1_E2MID[0]
+ _0163_ VPWR VGND sg13g2_nor2b_1
X_1303_ Tile_X0Y1_FrameData[17] Tile_X0Y1_FrameStrobe[4] Tile_X0Y1_IHP_SRAM_bot.Inst_IHP_SRAM_bot_ConfigMem.Inst_frame4_bit17.Q
+ VPWR VGND sg13g2_dlhq_1
X_1096_ Tile_X0Y0_FrameData[22] Tile_X0Y1_FrameStrobe[7] Tile_X0Y0_IHP_SRAM_top.Inst_IHP_SRAM_top_ConfigMem.Inst_frame7_bit22.Q
+ VPWR VGND sg13g2_dlhq_1
X_1234_ Tile_X0Y1_FrameData[22] Tile_X0Y1_FrameStrobe[2] Tile_X0Y1_IHP_SRAM_bot.Inst_IHP_SRAM_bot_ConfigMem.Inst_frame2_bit22.Q
+ VPWR VGND sg13g2_dlhq_1
X_1165_ Tile_X0Y1_FrameData[27] Tile_X0Y1_FrameStrobe[0] Tile_X0Y1_IHP_SRAM_bot.Inst_IHP_SRAM_bot_ConfigMem.Inst_frame0_bit27.Q
+ VPWR VGND sg13g2_dlhq_1
X_0949_ Tile_X0Y0_FrameData[9] Tile_X0Y1_FrameStrobe[2] Tile_X0Y0_IHP_SRAM_top.Inst_IHP_SRAM_top_ConfigMem.Inst_frame2_bit9.Q
+ VPWR VGND sg13g2_dlhq_1
XFILLER_70_122 VPWR VGND sg13g2_fill_2
XFILLER_55_163 VPWR VGND sg13g2_decap_8
XFILLER_55_174 VPWR VGND sg13g2_fill_1
XFILLER_109_165 VPWR VGND sg13g2_decap_8
XFILLER_109_143 VPWR VGND sg13g2_decap_4
XFILLER_50_64 VPWR VGND sg13g2_fill_1
XFILLER_59_73 VPWR VGND sg13g2_fill_2
XFILLER_1_0 VPWR VGND sg13g2_fill_2
XFILLER_75_72 VPWR VGND sg13g2_decap_8
X_0734_ VPWR _0178_ _0177_ VGND sg13g2_inv_1
X_0803_ VGND VPWR _0032_ _0240_ _0241_ Tile_X0Y1_IHP_SRAM_bot.Inst_IHP_SRAM_bot_ConfigMem.Inst_frame7_bit14.Q
+ sg13g2_a21oi_1
X_0665_ Tile_X0Y1_IHP_SRAM_bot.Inst_IHP_SRAM_bot_ConfigMem.Inst_frame1_bit10.Q Tile_X0Y1_N1END[1]
+ Tile_X0Y1_N4END[1] _0060_ Tile_X0Y0_S4END[5] Tile_X0Y1_IHP_SRAM_bot.Inst_IHP_SRAM_bot_ConfigMem.Inst_frame1_bit11.Q
+ _0160_ VPWR VGND sg13g2_mux4_1
X_0596_ Tile_X0Y0_IHP_SRAM_top.Inst_IHP_SRAM_top_switch_matrix.J_NS4_BEG7 Tile_X0Y0_IHP_SRAM_top.Inst_IHP_SRAM_top_switch_matrix.J_NS4_BEG11
+ Tile_X0Y0_IHP_SRAM_top.Inst_IHP_SRAM_top_ConfigMem.Inst_frame7_bit27.Q _0151_ VPWR
+ VGND sg13g2_mux2_1
XFILLER_34_0 VPWR VGND sg13g2_decap_4
X_1148_ Tile_X0Y0_FrameData[2] Tile_X0Y1_FrameStrobe[8] Tile_X0Y0_IHP_SRAM_top.Inst_IHP_SRAM_top_ConfigMem.Inst_frame8_bit2.Q
+ VPWR VGND sg13g2_dlhq_1
X_1079_ Tile_X0Y0_FrameData[7] Tile_X0Y1_FrameStrobe[6] Tile_X0Y0_IHP_SRAM_top.Inst_IHP_SRAM_top_ConfigMem.Inst_frame6_bit7.Q
+ VPWR VGND sg13g2_dlhq_1
X_1217_ Tile_X0Y1_FrameData[7] Tile_X0Y1_FrameStrobe[1] Tile_X0Y1_IHP_SRAM_bot.Inst_IHP_SRAM_bot_ConfigMem.Inst_frame1_bit7.Q
+ VPWR VGND sg13g2_dlhq_1
XFILLER_52_100 VPWR VGND sg13g2_decap_8
XFILLER_52_133 VPWR VGND sg13g2_decap_8
XFILLER_106_179 VPWR VGND sg13g2_decap_8
XFILLER_106_102 VPWR VGND sg13g2_decap_8
XFILLER_20_56 VPWR VGND sg13g2_decap_4
XFILLER_20_89 VPWR VGND sg13g2_fill_2
XFILLER_43_122 VPWR VGND sg13g2_fill_2
XANTENNA_7 VPWR VGND A_DOUT_SRAM18 sg13g2_antennanp
X_0381_ Tile_X0Y0_IHP_SRAM_top.Inst_IHP_SRAM_top_ConfigMem.Inst_frame7_bit0.Q Tile_X0Y0_E1END[3]
+ Tile_X0Y0_E6END[11] Tile_X0Y0_IHP_SRAM_top.Inst_IHP_SRAM_top_switch_matrix.J_NS4_BEG15
+ _0073_ Tile_X0Y0_IHP_SRAM_top.Inst_IHP_SRAM_top_ConfigMem.Inst_frame7_bit1.Q _0074_
+ VPWR VGND sg13g2_mux4_1
X_0450_ Tile_X0Y0_IHP_SRAM_top.Inst_IHP_SRAM_top_ConfigMem.Inst_frame5_bit2.Q A_DOUT_SRAM22
+ A_DOUT_SRAM30 Tile_X0Y0_IHP_SRAM_top.Inst_IHP_SRAM_top_switch_matrix.J_NS2_BEG1
+ Tile_X0Y0_IHP_SRAM_top.Inst_IHP_SRAM_top_switch_matrix.J_NS2_BEG6 Tile_X0Y0_IHP_SRAM_top.Inst_IHP_SRAM_top_ConfigMem.Inst_frame5_bit3.Q
+ Tile_X0Y0_IHP_SRAM_top.Inst_IHP_SRAM_top_switch_matrix.W2BEGb6 VPWR VGND sg13g2_mux4_1
XFILLER_86_93 VPWR VGND sg13g2_fill_2
X_1002_ Tile_X0Y0_FrameData[20] Tile_X0Y1_FrameStrobe[4] Tile_X0Y0_IHP_SRAM_top.Inst_IHP_SRAM_top_ConfigMem.Inst_frame4_bit20.Q
+ VPWR VGND sg13g2_dlhq_1
X_1697_ Tile_X0Y1_IHP_SRAM_bot.Inst_IHP_SRAM_bot_switch_matrix.W2BEGb6 net302 VPWR
+ VGND sg13g2_buf_1
X_0648_ Tile_X0Y1_IHP_SRAM_bot.Inst_IHP_SRAM_bot_ConfigMem.Inst_frame5_bit4.Q A_DOUT_SRAM5
+ A_DOUT_SRAM9 Tile_X0Y1_IHP_SRAM_bot.Inst_IHP_SRAM_bot_switch_matrix.J_NS4_BEG10
+ _0079_ Tile_X0Y1_IHP_SRAM_bot.Inst_IHP_SRAM_bot_ConfigMem.Inst_frame5_bit5.Q Tile_X0Y1_IHP_SRAM_bot.Inst_IHP_SRAM_bot_switch_matrix.WW4BEG5
+ VPWR VGND sg13g2_mux4_1
X_0717_ Tile_X0Y1_IHP_SRAM_bot.Inst_IHP_SRAM_bot_ConfigMem.Inst_frame3_bit28.Q Tile_X0Y1_EE4END[0]
+ Tile_X0Y1_EE4END[8] Tile_X0Y1_E6END[0] _0161_ Tile_X0Y1_IHP_SRAM_bot.Inst_IHP_SRAM_bot_ConfigMem.Inst_frame3_bit29.Q
+ net11 VPWR VGND sg13g2_mux4_1
X_0579_ _0134_ _0136_ Tile_X0Y0_IHP_SRAM_top.Inst_IHP_SRAM_top_switch_matrix.S4BEG0
+ VPWR VGND sg13g2_nor2_1
XFILLER_15_45 VPWR VGND sg13g2_fill_2
XFILLER_31_66 VPWR VGND sg13g2_fill_1
Xoutput99 net99 Tile_X0Y0_FrameData_O[28] VPWR VGND sg13g2_buf_1
XFILLER_102_171 VPWR VGND sg13g2_decap_4
Xoutput88 net88 Tile_X0Y0_FrameData_O[18] VPWR VGND sg13g2_buf_1
Xoutput55 net55 A_DIN_SRAM19 VPWR VGND sg13g2_buf_1
Xoutput44 net44 A_DIN_SRAM0 VPWR VGND sg13g2_buf_1
Xoutput9 net9 A_ADDR_SRAM8 VPWR VGND sg13g2_buf_1
Xoutput22 net22 A_BM_SRAM19 VPWR VGND sg13g2_buf_1
Xoutput33 net33 A_BM_SRAM29 VPWR VGND sg13g2_buf_1
Xoutput66 net66 A_DIN_SRAM29 VPWR VGND sg13g2_buf_1
Xoutput77 net77 A_REN_SRAM VPWR VGND sg13g2_buf_1
Xoutput11 net11 A_BM_SRAM0 VPWR VGND sg13g2_buf_1
XFILLER_102_193 VPWR VGND sg13g2_decap_8
XFILLER_56_96 VPWR VGND sg13g2_fill_2
X_1482_ Tile_X0Y0_FrameData[8] net109 VPWR VGND sg13g2_buf_1
X_0502_ Tile_X0Y0_IHP_SRAM_top.Inst_IHP_SRAM_top_ConfigMem.Inst_frame3_bit16.Q Tile_X0Y0_EE4END[1]
+ Tile_X0Y0_EE4END[9] Tile_X0Y0_E6END[9] Tile_X0Y0_IHP_SRAM_top.Inst_IHP_SRAM_top_switch_matrix.J_NS4_BEG9
+ Tile_X0Y0_IHP_SRAM_top.Inst_IHP_SRAM_top_ConfigMem.Inst_frame3_bit17.Q net62 VPWR
+ VGND sg13g2_mux4_1
X_1551_ Tile_X0Y1_N4END[13] net162 VPWR VGND sg13g2_buf_1
X_1620_ Tile_X0Y1_FrameData[9] net247 VPWR VGND sg13g2_buf_1
X_0433_ Tile_X0Y0_IHP_SRAM_top.Inst_IHP_SRAM_top_ConfigMem.Inst_frame6_bit1.Q Tile_X0Y0_IHP_SRAM_top.Inst_IHP_SRAM_top_switch_matrix.N1END1
+ A_DOUT_SRAM19 Tile_X0Y0_S1END[1] A_DOUT_SRAM22 Tile_X0Y0_IHP_SRAM_top.Inst_IHP_SRAM_top_ConfigMem.Inst_frame6_bit0.Q
+ Tile_X0Y0_IHP_SRAM_top.Inst_IHP_SRAM_top_switch_matrix.W1BEG1 VPWR VGND sg13g2_mux4_1
X_0364_ VPWR VGND _0061_ _0062_ Tile_X0Y1_IHP_SRAM_bot.Inst_IHP_SRAM_bot_ConfigMem.Inst_frame0_bit27.Q
+ _0009_ _0063_ Tile_X0Y1_IHP_SRAM_bot.Inst_IHP_SRAM_bot_ConfigMem.Inst_frame0_bit26.Q
+ sg13g2_a221oi_1
XFILLER_89_114 VPWR VGND sg13g2_decap_8
XFILLER_26_33 VPWR VGND sg13g2_fill_2
XFILLER_101_0 VPWR VGND sg13g2_fill_2
X_0982_ Tile_X0Y0_FrameData[8] Tile_X0Y1_FrameStrobe[3] Tile_X0Y0_IHP_SRAM_top.Inst_IHP_SRAM_top_ConfigMem.Inst_frame3_bit8.Q
+ VPWR VGND sg13g2_dlhq_1
X_1534_ Tile_X0Y0_IHP_SRAM_top.Inst_IHP_SRAM_top_switch_matrix.N2BEG4 net139 VPWR
+ VGND sg13g2_buf_1
X_1603_ Tile_X0Y0_IHP_SRAM_top.Inst_IHP_SRAM_top_switch_matrix.WW4BEG8 net214 VPWR
+ VGND sg13g2_buf_1
X_1465_ Tile_X0Y1_FrameData[15] Tile_X0Y1_FrameStrobe[9] Tile_X0Y1_IHP_SRAM_bot.Inst_IHP_SRAM_bot_ConfigMem.Inst_frame9_bit15.Q
+ VPWR VGND sg13g2_dlhq_1
X_1396_ Tile_X0Y1_FrameData[20] Tile_X0Y1_FrameStrobe[7] Tile_X0Y1_IHP_SRAM_bot.Inst_IHP_SRAM_bot_ConfigMem.Inst_frame7_bit20.Q
+ VPWR VGND sg13g2_dlhq_1
X_0347_ _0044_ _0046_ Tile_X0Y1_IHP_SRAM_bot.Inst_IHP_SRAM_bot_ConfigMem.Inst_frame1_bit0.Q
+ _0047_ VPWR VGND sg13g2_nand3_1
X_0416_ Tile_X0Y1_IHP_SRAM_bot.Inst_IHP_SRAM_bot_ConfigMem.Inst_frame9_bit31.Q Tile_X0Y1_E2MID[1]
+ Tile_X0Y1_E6END[1] Tile_X0Y1_E2END[1] _0083_ Tile_X0Y1_IHP_SRAM_bot.Inst_IHP_SRAM_bot_ConfigMem.Inst_frame9_bit30.Q
+ Tile_X0Y0_IHP_SRAM_top.Inst_IHP_SRAM_top_switch_matrix.N2BEGb6 VPWR VGND sg13g2_mux4_1
XFILLER_88_39 VPWR VGND sg13g2_fill_1
XFILLER_78_72 VPWR VGND sg13g2_decap_8
XFILLER_5_165 VPWR VGND sg13g2_decap_4
XFILLER_5_143 VPWR VGND sg13g2_fill_1
XFILLER_76_194 VPWR VGND sg13g2_fill_1
X_1250_ Tile_X0Y1_FrameData[6] Tile_X0Y1_FrameStrobe[2] Tile_X0Y1_IHP_SRAM_bot.Inst_IHP_SRAM_bot_ConfigMem.Inst_frame2_bit6.Q
+ VPWR VGND sg13g2_dlhq_1
X_1181_ Tile_X0Y1_FrameData[11] Tile_X0Y1_FrameStrobe[0] Tile_X0Y1_IHP_SRAM_bot.Inst_IHP_SRAM_bot_ConfigMem.Inst_frame0_bit11.Q
+ VPWR VGND sg13g2_dlhq_1
X_0896_ Tile_X0Y0_FrameData[30] Tile_X0Y1_FrameStrobe[1] Tile_X0Y0_IHP_SRAM_top.Inst_IHP_SRAM_top_ConfigMem.Inst_frame1_bit30.Q
+ VPWR VGND sg13g2_dlhq_1
Xoutput201 net201 Tile_X0Y0_WW4BEG[10] VPWR VGND sg13g2_buf_1
Xoutput212 net212 Tile_X0Y0_WW4BEG[6] VPWR VGND sg13g2_buf_1
Xoutput234 net234 Tile_X0Y1_FrameData_O[26] VPWR VGND sg13g2_buf_1
X_0965_ Tile_X0Y0_FrameData[25] Tile_X0Y1_FrameStrobe[3] Tile_X0Y0_IHP_SRAM_top.Inst_IHP_SRAM_top_ConfigMem.Inst_frame3_bit25.Q
+ VPWR VGND sg13g2_dlhq_1
XFILLER_64_0 VPWR VGND sg13g2_fill_2
Xoutput223 net223 Tile_X0Y1_FrameData_O[16] VPWR VGND sg13g2_buf_1
X_1517_ Tile_X0Y1_FrameStrobe[11] net113 VPWR VGND sg13g2_buf_1
Xoutput256 net256 Tile_X0Y1_S2BEG[4] VPWR VGND sg13g2_buf_1
Xoutput267 net267 Tile_X0Y1_S2BEGb[7] VPWR VGND sg13g2_buf_1
Xoutput278 net278 Tile_X0Y1_S4BEG[4] VPWR VGND sg13g2_buf_1
Xoutput289 net289 Tile_X0Y1_W2BEG[1] VPWR VGND sg13g2_buf_1
X_1448_ Tile_X0Y1_FrameData[0] Tile_X0Y1_FrameStrobe[8] Tile_X0Y1_IHP_SRAM_bot.Inst_IHP_SRAM_bot_ConfigMem.Inst_frame8_bit0.Q
+ VPWR VGND sg13g2_dlhq_1
Xoutput245 net245 Tile_X0Y1_FrameData_O[7] VPWR VGND sg13g2_buf_1
X_1379_ Tile_X0Y1_FrameData[5] Tile_X0Y1_FrameStrobe[6] Tile_X0Y1_IHP_SRAM_bot.Inst_IHP_SRAM_bot_ConfigMem.Inst_frame6_bit5.Q
+ VPWR VGND sg13g2_dlhq_1
XFILLER_2_124 VPWR VGND sg13g2_fill_2
XFILLER_104_81 VPWR VGND sg13g2_fill_2
XFILLER_58_150 VPWR VGND sg13g2_decap_4
X_0681_ Tile_X0Y1_IHP_SRAM_bot.Inst_IHP_SRAM_bot_ConfigMem.Inst_frame4_bit19.Q _0043_
+ _0162_ VPWR VGND Tile_X0Y1_IHP_SRAM_bot.Inst_IHP_SRAM_bot_ConfigMem.Inst_frame4_bit18.Q
+ sg13g2_nand3b_1
X_0750_ Tile_X0Y1_IHP_SRAM_bot.Inst_IHP_SRAM_bot_ConfigMem.Inst_frame8_bit6.Q VPWR
+ _0193_ VGND Tile_X0Y1_IHP_SRAM_bot.Inst_IHP_SRAM_bot_ConfigMem.Inst_frame8_bit5.Q
+ Tile_X0Y1_IHP_SRAM_bot.Inst_IHP_SRAM_bot_switch_matrix.J_NS4_BEG13 sg13g2_o21ai_1
X_1302_ Tile_X0Y1_FrameData[18] Tile_X0Y1_FrameStrobe[4] Tile_X0Y1_IHP_SRAM_bot.Inst_IHP_SRAM_bot_ConfigMem.Inst_frame4_bit18.Q
+ VPWR VGND sg13g2_dlhq_1
X_1233_ Tile_X0Y1_FrameData[23] Tile_X0Y1_FrameStrobe[2] Tile_X0Y1_IHP_SRAM_bot.Inst_IHP_SRAM_bot_ConfigMem.Inst_frame2_bit23.Q
+ VPWR VGND sg13g2_dlhq_1
X_1095_ Tile_X0Y0_FrameData[23] Tile_X0Y1_FrameStrobe[7] Tile_X0Y0_IHP_SRAM_top.Inst_IHP_SRAM_top_ConfigMem.Inst_frame7_bit23.Q
+ VPWR VGND sg13g2_dlhq_1
XFILLER_64_175 VPWR VGND sg13g2_decap_8
X_1164_ Tile_X0Y1_FrameData[28] Tile_X0Y1_FrameStrobe[0] Tile_X0Y1_IHP_SRAM_bot.Inst_IHP_SRAM_bot_ConfigMem.Inst_frame0_bit28.Q
+ VPWR VGND sg13g2_dlhq_1
X_0948_ Tile_X0Y0_FrameData[10] Tile_X0Y1_FrameStrobe[2] Tile_X0Y0_IHP_SRAM_top.Inst_IHP_SRAM_top_ConfigMem.Inst_frame2_bit10.Q
+ VPWR VGND sg13g2_dlhq_1
X_0879_ Tile_X0Y0_FrameData[15] Tile_X0Y1_FrameStrobe[0] Tile_X0Y0_IHP_SRAM_top.Inst_IHP_SRAM_top_ConfigMem.Inst_frame0_bit15.Q
+ VPWR VGND sg13g2_dlhq_1
XFILLER_85_18 VPWR VGND sg13g2_decap_8
XFILLER_55_120 VPWR VGND sg13g2_fill_1
XFILLER_109_122 VPWR VGND sg13g2_decap_8
XFILLER_61_134 VPWR VGND sg13g2_fill_2
XFILLER_61_123 VPWR VGND sg13g2_decap_8
X_0802_ Tile_X0Y1_E1END[2] Tile_X0Y1_EE4END[14] Tile_X0Y1_IHP_SRAM_bot.Inst_IHP_SRAM_bot_ConfigMem.Inst_frame7_bit12.Q
+ _0240_ VPWR VGND sg13g2_mux2_1
X_0733_ Tile_X0Y1_IHP_SRAM_bot.Inst_IHP_SRAM_bot_ConfigMem.Inst_frame8_bit3.Q VPWR
+ _0177_ VGND Tile_X0Y1_E6END[8] Tile_X0Y1_IHP_SRAM_bot.Inst_IHP_SRAM_bot_ConfigMem.Inst_frame8_bit2.Q
+ sg13g2_o21ai_1
X_0664_ Tile_X0Y1_IHP_SRAM_bot.Inst_IHP_SRAM_bot_ConfigMem.Inst_frame5_bit20.Q A_DOUT_SRAM1
+ A_DOUT_SRAM13 _0159_ _0079_ Tile_X0Y1_IHP_SRAM_bot.Inst_IHP_SRAM_bot_ConfigMem.Inst_frame5_bit21.Q
+ Tile_X0Y1_IHP_SRAM_bot.Inst_IHP_SRAM_bot_switch_matrix.WW4BEG13 VPWR VGND sg13g2_mux4_1
XFILLER_41_2 VPWR VGND sg13g2_fill_1
X_1216_ Tile_X0Y1_FrameData[8] Tile_X0Y1_FrameStrobe[1] Tile_X0Y1_IHP_SRAM_bot.Inst_IHP_SRAM_bot_ConfigMem.Inst_frame1_bit8.Q
+ VPWR VGND sg13g2_dlhq_1
XFILLER_27_0 VPWR VGND sg13g2_fill_1
X_0595_ _0148_ _0150_ Tile_X0Y0_IHP_SRAM_top.Inst_IHP_SRAM_top_switch_matrix.S4BEG2
+ VPWR VGND sg13g2_nor2_1
X_1147_ Tile_X0Y0_FrameData[3] Tile_X0Y1_FrameStrobe[8] Tile_X0Y0_IHP_SRAM_top.Inst_IHP_SRAM_top_ConfigMem.Inst_frame8_bit3.Q
+ VPWR VGND sg13g2_dlhq_1
XFILLER_52_178 VPWR VGND sg13g2_fill_1
X_1078_ Tile_X0Y0_FrameData[8] Tile_X0Y1_FrameStrobe[6] Tile_X0Y0_IHP_SRAM_top.Inst_IHP_SRAM_top_ConfigMem.Inst_frame6_bit8.Q
+ VPWR VGND sg13g2_dlhq_1
XFILLER_106_158 VPWR VGND sg13g2_decap_8
XFILLER_20_79 VPWR VGND sg13g2_fill_1
XFILLER_29_11 VPWR VGND sg13g2_fill_2
XFILLER_101_93 VPWR VGND sg13g2_decap_4
XFILLER_61_53 VPWR VGND sg13g2_fill_1
XFILLER_61_42 VPWR VGND sg13g2_decap_8
XANTENNA_8 VPWR VGND A_DOUT_SRAM19 sg13g2_antennanp
X_0380_ VPWR VGND _0071_ _0072_ Tile_X0Y0_IHP_SRAM_top.Inst_IHP_SRAM_top_ConfigMem.Inst_frame0_bit31.Q
+ _0005_ _0073_ Tile_X0Y0_IHP_SRAM_top.Inst_IHP_SRAM_top_ConfigMem.Inst_frame0_bit30.Q
+ sg13g2_a221oi_1
X_1001_ Tile_X0Y0_FrameData[21] Tile_X0Y1_FrameStrobe[4] Tile_X0Y0_IHP_SRAM_top.Inst_IHP_SRAM_top_ConfigMem.Inst_frame4_bit21.Q
+ VPWR VGND sg13g2_dlhq_1
XFILLER_34_167 VPWR VGND sg13g2_decap_4
X_0578_ Tile_X0Y0_IHP_SRAM_top.Inst_IHP_SRAM_top_ConfigMem.Inst_frame7_bit20.Q _0135_
+ _0136_ VPWR VGND sg13g2_nor2_1
X_1696_ Tile_X0Y1_IHP_SRAM_bot.Inst_IHP_SRAM_bot_switch_matrix.W2BEGb5 net301 VPWR
+ VGND sg13g2_buf_1
X_0716_ Tile_X0Y1_IHP_SRAM_bot.Inst_IHP_SRAM_bot_ConfigMem.Inst_frame3_bit26.Q Tile_X0Y1_E1END[3]
+ Tile_X0Y1_EE4END[7] Tile_X0Y1_EE4END[15] Tile_X0Y1_IHP_SRAM_bot.Inst_IHP_SRAM_bot_switch_matrix.J_NS4_BEG15
+ Tile_X0Y1_IHP_SRAM_bot.Inst_IHP_SRAM_bot_ConfigMem.Inst_frame3_bit27.Q net51 VPWR
+ VGND sg13g2_mux4_1
X_0647_ Tile_X0Y1_IHP_SRAM_bot.Inst_IHP_SRAM_bot_ConfigMem.Inst_frame1_bit28.Q Tile_X0Y1_N1END[2]
+ Tile_X0Y1_N4END[2] _0067_ Tile_X0Y0_S4END[6] Tile_X0Y1_IHP_SRAM_bot.Inst_IHP_SRAM_bot_ConfigMem.Inst_frame1_bit29.Q
+ Tile_X0Y1_IHP_SRAM_bot.Inst_IHP_SRAM_bot_switch_matrix.J_NS4_BEG10 VPWR VGND sg13g2_mux4_1
XFILLER_57_215 VPWR VGND sg13g2_fill_1
Xoutput12 net12 A_BM_SRAM1 VPWR VGND sg13g2_buf_1
Xoutput34 net34 A_BM_SRAM3 VPWR VGND sg13g2_buf_1
Xoutput23 net23 A_BM_SRAM2 VPWR VGND sg13g2_buf_1
Xoutput89 net89 Tile_X0Y0_FrameData_O[19] VPWR VGND sg13g2_buf_1
Xoutput56 net56 A_DIN_SRAM2 VPWR VGND sg13g2_buf_1
Xoutput67 net67 A_DIN_SRAM3 VPWR VGND sg13g2_buf_1
Xoutput45 net45 A_DIN_SRAM1 VPWR VGND sg13g2_buf_1
XFILLER_0_211 VPWR VGND sg13g2_decap_4
Xoutput78 net78 A_WEN_SRAM VPWR VGND sg13g2_buf_1
XFILLER_72_52 VPWR VGND sg13g2_fill_1
XFILLER_16_112 VPWR VGND sg13g2_fill_1
XFILLER_31_148 VPWR VGND sg13g2_fill_1
X_0501_ Tile_X0Y0_IHP_SRAM_top.Inst_IHP_SRAM_top_ConfigMem.Inst_frame3_bit14.Q Tile_X0Y0_EE4END[0]
+ Tile_X0Y0_EE4END[8] Tile_X0Y0_E6END[8] Tile_X0Y0_IHP_SRAM_top.Inst_IHP_SRAM_top_switch_matrix.J_NS4_BEG8
+ Tile_X0Y0_IHP_SRAM_top.Inst_IHP_SRAM_top_ConfigMem.Inst_frame3_bit15.Q net61 VPWR
+ VGND sg13g2_mux4_1
X_1481_ Tile_X0Y0_FrameData[7] net108 VPWR VGND sg13g2_buf_1
X_0432_ Tile_X0Y0_IHP_SRAM_top.Inst_IHP_SRAM_top_ConfigMem.Inst_frame7_bit31.Q Tile_X0Y0_IHP_SRAM_top.Inst_IHP_SRAM_top_switch_matrix.N1END0
+ A_DOUT_SRAM18 Tile_X0Y0_S1END[0] A_DOUT_SRAM23 Tile_X0Y0_IHP_SRAM_top.Inst_IHP_SRAM_top_ConfigMem.Inst_frame7_bit30.Q
+ Tile_X0Y0_IHP_SRAM_top.Inst_IHP_SRAM_top_switch_matrix.W1BEG0 VPWR VGND sg13g2_mux4_1
X_1550_ Tile_X0Y1_N4END[12] net161 VPWR VGND sg13g2_buf_1
X_0363_ Tile_X0Y1_N1END[1] Tile_X0Y1_IHP_SRAM_bot.Inst_IHP_SRAM_bot_ConfigMem.Inst_frame0_bit26.Q
+ Tile_X0Y1_IHP_SRAM_bot.Inst_IHP_SRAM_bot_ConfigMem.Inst_frame0_bit27.Q _0062_ VPWR
+ VGND sg13g2_nor3_1
XFILLER_94_0 VPWR VGND sg13g2_fill_1
XFILLER_7_80 VPWR VGND sg13g2_fill_1
X_1679_ Tile_X0Y1_IHP_SRAM_bot.Inst_IHP_SRAM_bot_switch_matrix.W1BEG0 net284 VPWR
+ VGND sg13g2_buf_1
XFILLER_9_119 VPWR VGND sg13g2_fill_1
XFILLER_107_81 VPWR VGND sg13g2_decap_8
XFILLER_88_181 VPWR VGND sg13g2_fill_2
XFILLER_67_85 VPWR VGND sg13g2_decap_8
X_0981_ Tile_X0Y0_FrameData[9] Tile_X0Y1_FrameStrobe[3] Tile_X0Y0_IHP_SRAM_top.Inst_IHP_SRAM_top_ConfigMem.Inst_frame3_bit9.Q
+ VPWR VGND sg13g2_dlhq_1
X_1602_ Tile_X0Y0_IHP_SRAM_top.Inst_IHP_SRAM_top_switch_matrix.WW4BEG7 net213 VPWR
+ VGND sg13g2_buf_1
X_1533_ Tile_X0Y0_IHP_SRAM_top.Inst_IHP_SRAM_top_switch_matrix.N2BEG3 net138 VPWR
+ VGND sg13g2_buf_1
X_1395_ Tile_X0Y1_FrameData[21] Tile_X0Y1_FrameStrobe[7] Tile_X0Y1_IHP_SRAM_bot.Inst_IHP_SRAM_bot_ConfigMem.Inst_frame7_bit21.Q
+ VPWR VGND sg13g2_dlhq_1
X_1464_ Tile_X0Y1_FrameData[16] Tile_X0Y1_FrameStrobe[9] Tile_X0Y1_IHP_SRAM_bot.Inst_IHP_SRAM_bot_ConfigMem.Inst_frame9_bit16.Q
+ VPWR VGND sg13g2_dlhq_1
X_0415_ Tile_X0Y1_IHP_SRAM_bot.Inst_IHP_SRAM_bot_ConfigMem.Inst_frame0_bit20.Q Tile_X0Y1_N2MID[6]
+ Tile_X0Y1_N2END[6] Tile_X0Y0_IHP_SRAM_top.Inst_IHP_SRAM_top_switch_matrix.S2BEG6
+ Tile_X0Y0_S2MID[6] Tile_X0Y1_IHP_SRAM_bot.Inst_IHP_SRAM_bot_ConfigMem.Inst_frame0_bit21.Q
+ _0083_ VPWR VGND sg13g2_mux4_1
X_0346_ _0046_ _0045_ Tile_X0Y1_E2END[4] Tile_X0Y0_S2MID[3] Tile_X0Y1_IHP_SRAM_bot.Inst_IHP_SRAM_bot_ConfigMem.Inst_frame1_bit2.Q
+ VPWR VGND sg13g2_a22oi_1
XFILLER_68_118 VPWR VGND sg13g2_fill_1
XFILLER_94_72 VPWR VGND sg13g2_fill_2
X_1180_ Tile_X0Y1_FrameData[12] Tile_X0Y1_FrameStrobe[0] Tile_X0Y1_IHP_SRAM_bot.Inst_IHP_SRAM_bot_ConfigMem.Inst_frame0_bit12.Q
+ VPWR VGND sg13g2_dlhq_1
X_0964_ Tile_X0Y0_FrameData[26] Tile_X0Y1_FrameStrobe[3] Tile_X0Y0_IHP_SRAM_top.Inst_IHP_SRAM_top_ConfigMem.Inst_frame3_bit26.Q
+ VPWR VGND sg13g2_dlhq_1
X_1516_ Tile_X0Y1_FrameStrobe[10] net112 VPWR VGND sg13g2_buf_1
X_0895_ Tile_X0Y0_FrameData[31] Tile_X0Y1_FrameStrobe[1] Tile_X0Y0_IHP_SRAM_top.Inst_IHP_SRAM_top_ConfigMem.Inst_frame1_bit31.Q
+ VPWR VGND sg13g2_dlhq_1
Xoutput202 net202 Tile_X0Y0_WW4BEG[11] VPWR VGND sg13g2_buf_1
Xoutput235 net235 Tile_X0Y1_FrameData_O[27] VPWR VGND sg13g2_buf_1
Xoutput213 net213 Tile_X0Y0_WW4BEG[7] VPWR VGND sg13g2_buf_1
Xoutput224 net224 Tile_X0Y1_FrameData_O[17] VPWR VGND sg13g2_buf_1
Xoutput257 net257 Tile_X0Y1_S2BEG[5] VPWR VGND sg13g2_buf_1
Xoutput268 net268 Tile_X0Y1_S4BEG[0] VPWR VGND sg13g2_buf_1
Xoutput246 net246 Tile_X0Y1_FrameData_O[8] VPWR VGND sg13g2_buf_1
X_1378_ Tile_X0Y1_FrameData[6] Tile_X0Y1_FrameStrobe[6] Tile_X0Y1_IHP_SRAM_bot.Inst_IHP_SRAM_bot_ConfigMem.Inst_frame6_bit6.Q
+ VPWR VGND sg13g2_dlhq_1
Xoutput279 net279 Tile_X0Y1_S4BEG[5] VPWR VGND sg13g2_buf_1
X_1447_ Tile_X0Y1_FrameData[1] Tile_X0Y1_FrameStrobe[8] Tile_X0Y1_IHP_SRAM_bot.Inst_IHP_SRAM_bot_ConfigMem.Inst_frame8_bit1.Q
+ VPWR VGND sg13g2_dlhq_1
X_0329_ VPWR _0032_ Tile_X0Y1_IHP_SRAM_bot.Inst_IHP_SRAM_bot_ConfigMem.Inst_frame7_bit13.Q
+ VGND sg13g2_inv_1
XFILLER_104_60 VPWR VGND sg13g2_decap_8
XFILLER_89_94 VPWR VGND sg13g2_fill_2
X_0680_ Tile_X0Y1_IHP_SRAM_bot.Inst_IHP_SRAM_bot_ConfigMem.Inst_frame4_bit17.Q A_DOUT_SRAM3
+ Tile_X0Y1_IHP_SRAM_bot.Inst_IHP_SRAM_bot_switch_matrix.J_NS4_BEG4 _0161_ _0084_
+ Tile_X0Y1_IHP_SRAM_bot.Inst_IHP_SRAM_bot_ConfigMem.Inst_frame4_bit16.Q Tile_X0Y1_IHP_SRAM_bot.Inst_IHP_SRAM_bot_switch_matrix.W6BEG11
+ VPWR VGND sg13g2_mux4_1
X_1301_ Tile_X0Y1_FrameData[19] Tile_X0Y1_FrameStrobe[4] Tile_X0Y1_IHP_SRAM_bot.Inst_IHP_SRAM_bot_ConfigMem.Inst_frame4_bit19.Q
+ VPWR VGND sg13g2_dlhq_1
X_1232_ Tile_X0Y1_FrameData[24] Tile_X0Y1_FrameStrobe[2] Tile_X0Y1_IHP_SRAM_bot.Inst_IHP_SRAM_bot_ConfigMem.Inst_frame2_bit24.Q
+ VPWR VGND sg13g2_dlhq_1
XFILLER_49_151 VPWR VGND sg13g2_decap_4
X_1163_ Tile_X0Y1_FrameData[29] Tile_X0Y1_FrameStrobe[0] Tile_X0Y1_IHP_SRAM_bot.Inst_IHP_SRAM_bot_ConfigMem.Inst_frame0_bit29.Q
+ VPWR VGND sg13g2_dlhq_1
X_1094_ Tile_X0Y0_FrameData[24] Tile_X0Y1_FrameStrobe[7] Tile_X0Y0_IHP_SRAM_top.Inst_IHP_SRAM_top_ConfigMem.Inst_frame7_bit24.Q
+ VPWR VGND sg13g2_dlhq_1
X_0947_ Tile_X0Y0_FrameData[11] Tile_X0Y1_FrameStrobe[2] Tile_X0Y0_IHP_SRAM_top.Inst_IHP_SRAM_top_ConfigMem.Inst_frame2_bit11.Q
+ VPWR VGND sg13g2_dlhq_1
X_0878_ Tile_X0Y0_FrameData[16] Tile_X0Y1_FrameStrobe[0] Tile_X0Y0_IHP_SRAM_top.Inst_IHP_SRAM_top_ConfigMem.Inst_frame0_bit16.Q
+ VPWR VGND sg13g2_dlhq_1
XFILLER_70_124 VPWR VGND sg13g2_fill_1
XFILLER_34_89 VPWR VGND sg13g2_decap_8
XFILLER_109_101 VPWR VGND sg13g2_decap_8
XFILLER_59_20 VPWR VGND sg13g2_fill_2
X_0801_ _0238_ VPWR _0239_ VGND _0031_ _0159_ sg13g2_o21ai_1
X_0732_ Tile_X0Y1_IHP_SRAM_bot.Inst_IHP_SRAM_bot_ConfigMem.Inst_frame2_bit26.Q Tile_X0Y1_E1END[3]
+ Tile_X0Y1_EE4END[7] Tile_X0Y1_EE4END[15] Tile_X0Y1_IHP_SRAM_bot.Inst_IHP_SRAM_bot_switch_matrix.J_NS4_BEG15
+ Tile_X0Y1_IHP_SRAM_bot.Inst_IHP_SRAM_bot_ConfigMem.Inst_frame2_bit27.Q net18 VPWR
+ VGND sg13g2_mux4_1
X_0663_ Tile_X0Y1_IHP_SRAM_bot.Inst_IHP_SRAM_bot_ConfigMem.Inst_frame1_bit12.Q Tile_X0Y1_N1END[2]
+ Tile_X0Y1_N4END[2] _0067_ Tile_X0Y0_S4END[6] Tile_X0Y1_IHP_SRAM_bot.Inst_IHP_SRAM_bot_ConfigMem.Inst_frame1_bit13.Q
+ _0159_ VPWR VGND sg13g2_mux4_1
X_0594_ Tile_X0Y0_IHP_SRAM_top.Inst_IHP_SRAM_top_ConfigMem.Inst_frame7_bit26.Q _0149_
+ _0150_ VPWR VGND sg13g2_nor2_1
X_1146_ Tile_X0Y0_FrameData[4] Tile_X0Y1_FrameStrobe[8] Tile_X0Y0_IHP_SRAM_top.Inst_IHP_SRAM_top_ConfigMem.Inst_frame8_bit4.Q
+ VPWR VGND sg13g2_dlhq_1
X_1215_ Tile_X0Y1_FrameData[9] Tile_X0Y1_FrameStrobe[1] Tile_X0Y1_IHP_SRAM_bot.Inst_IHP_SRAM_bot_ConfigMem.Inst_frame1_bit9.Q
+ VPWR VGND sg13g2_dlhq_1
XFILLER_37_165 VPWR VGND sg13g2_decap_4
X_1077_ Tile_X0Y0_FrameData[9] Tile_X0Y1_FrameStrobe[6] Tile_X0Y0_IHP_SRAM_top.Inst_IHP_SRAM_top_ConfigMem.Inst_frame6_bit9.Q
+ VPWR VGND sg13g2_dlhq_1
XFILLER_106_137 VPWR VGND sg13g2_decap_8
XFILLER_4_209 VPWR VGND sg13g2_fill_2
XFILLER_96_18 VPWR VGND sg13g2_decap_8
XFILLER_29_34 VPWR VGND sg13g2_decap_4
XFILLER_28_154 VPWR VGND sg13g2_decap_8
XFILLER_43_113 VPWR VGND sg13g2_fill_1
XANTENNA_9 VPWR VGND A_DOUT_SRAM19 sg13g2_antennanp
XFILLER_86_95 VPWR VGND sg13g2_fill_1
X_1000_ Tile_X0Y0_FrameData[22] Tile_X0Y1_FrameStrobe[4] Tile_X0Y0_IHP_SRAM_top.Inst_IHP_SRAM_top_ConfigMem.Inst_frame4_bit22.Q
+ VPWR VGND sg13g2_dlhq_1
XFILLER_34_146 VPWR VGND sg13g2_decap_4
X_0715_ Tile_X0Y1_IHP_SRAM_bot.Inst_IHP_SRAM_bot_ConfigMem.Inst_frame3_bit24.Q Tile_X0Y1_E1END[2]
+ Tile_X0Y1_EE4END[6] Tile_X0Y1_EE4END[14] Tile_X0Y1_IHP_SRAM_bot.Inst_IHP_SRAM_bot_switch_matrix.J_NS4_BEG14
+ Tile_X0Y1_IHP_SRAM_bot.Inst_IHP_SRAM_bot_ConfigMem.Inst_frame3_bit25.Q net50 VPWR
+ VGND sg13g2_mux4_1
XFILLER_106_39 VPWR VGND sg13g2_decap_8
X_0577_ Tile_X0Y0_IHP_SRAM_top.Inst_IHP_SRAM_top_ConfigMem.Inst_frame7_bit18.Q Tile_X0Y0_E1END[0]
+ Tile_X0Y0_EE4END[12] Tile_X0Y0_E6END[4] Tile_X0Y0_IHP_SRAM_top.Inst_IHP_SRAM_top_switch_matrix.J_NS4_BEG0
+ Tile_X0Y0_IHP_SRAM_top.Inst_IHP_SRAM_top_ConfigMem.Inst_frame7_bit19.Q _0135_ VPWR
+ VGND sg13g2_mux4_1
X_0646_ Tile_X0Y1_IHP_SRAM_bot.Inst_IHP_SRAM_bot_ConfigMem.Inst_frame5_bit2.Q A_DOUT_SRAM4
+ A_DOUT_SRAM8 Tile_X0Y1_IHP_SRAM_bot.Inst_IHP_SRAM_bot_switch_matrix.J_NS4_BEG11
+ _0080_ Tile_X0Y1_IHP_SRAM_bot.Inst_IHP_SRAM_bot_ConfigMem.Inst_frame5_bit3.Q Tile_X0Y1_IHP_SRAM_bot.Inst_IHP_SRAM_bot_switch_matrix.WW4BEG4
+ VPWR VGND sg13g2_mux4_1
X_1695_ Tile_X0Y1_IHP_SRAM_bot.Inst_IHP_SRAM_bot_switch_matrix.W2BEGb4 net300 VPWR
+ VGND sg13g2_buf_1
X_1129_ Tile_X0Y0_FrameData[21] Tile_X0Y1_FrameStrobe[8] Tile_X0Y0_IHP_SRAM_top.Inst_IHP_SRAM_top_ConfigMem.Inst_frame8_bit21.Q
+ VPWR VGND sg13g2_dlhq_1
XFILLER_15_47 VPWR VGND sg13g2_fill_1
XFILLER_33_190 VPWR VGND sg13g2_decap_4
Xoutput57 net57 A_DIN_SRAM20 VPWR VGND sg13g2_buf_1
Xoutput46 net46 A_DIN_SRAM10 VPWR VGND sg13g2_buf_1
Xoutput13 net13 A_BM_SRAM10 VPWR VGND sg13g2_buf_1
Xoutput35 net35 A_BM_SRAM30 VPWR VGND sg13g2_buf_1
Xoutput24 net24 A_BM_SRAM20 VPWR VGND sg13g2_buf_1
Xoutput79 net79 Tile_X0Y0_FrameData_O[0] VPWR VGND sg13g2_buf_1
Xoutput68 net68 A_DIN_SRAM30 VPWR VGND sg13g2_buf_1
XFILLER_56_98 VPWR VGND sg13g2_fill_1
X_0500_ Tile_X0Y0_IHP_SRAM_top.Inst_IHP_SRAM_top_ConfigMem.Inst_frame3_bit12.Q Tile_X0Y0_EE4END[7]
+ Tile_X0Y0_EE4END[15] Tile_X0Y0_E6END[7] Tile_X0Y0_IHP_SRAM_top.Inst_IHP_SRAM_top_switch_matrix.J_NS4_BEG7
+ Tile_X0Y0_IHP_SRAM_top.Inst_IHP_SRAM_top_ConfigMem.Inst_frame3_bit13.Q net60 VPWR
+ VGND sg13g2_mux4_1
X_1480_ Tile_X0Y0_FrameData[6] net107 VPWR VGND sg13g2_buf_1
X_0431_ Tile_X0Y1_IHP_SRAM_bot.Inst_IHP_SRAM_bot_ConfigMem.Inst_frame9_bit11.Q Tile_X0Y1_E1END[0]
+ Tile_X0Y1_IHP_SRAM_bot.Inst_IHP_SRAM_bot_switch_matrix.J_NS4_BEG12 Tile_X0Y1_E6END[4]
+ _0091_ Tile_X0Y1_IHP_SRAM_bot.Inst_IHP_SRAM_bot_ConfigMem.Inst_frame9_bit10.Q Tile_X0Y0_IHP_SRAM_top.Inst_IHP_SRAM_top_switch_matrix.N1END0
+ VPWR VGND sg13g2_mux4_1
X_0362_ _0061_ _0060_ Tile_X0Y1_IHP_SRAM_bot.Inst_IHP_SRAM_bot_ConfigMem.Inst_frame0_bit26.Q
+ VPWR VGND sg13g2_nand2b_1
XFILLER_22_116 VPWR VGND sg13g2_fill_2
XFILLER_30_182 VPWR VGND sg13g2_fill_1
X_1678_ Tile_X0Y1_IHP_SRAM_bot.Inst_IHP_SRAM_bot_switch_matrix.S4BEG3 net274 VPWR
+ VGND sg13g2_buf_1
X_0629_ Tile_X0Y1_IHP_SRAM_bot.Inst_IHP_SRAM_bot_ConfigMem.Inst_frame6_bit2.Q A_DOUT_SRAM4
+ A_DOUT_SRAM12 _0080_ _0081_ Tile_X0Y1_IHP_SRAM_bot.Inst_IHP_SRAM_bot_ConfigMem.Inst_frame6_bit3.Q
+ Tile_X0Y1_IHP_SRAM_bot.Inst_IHP_SRAM_bot_switch_matrix.W2BEG4 VPWR VGND sg13g2_mux4_1
XFILLER_42_56 VPWR VGND sg13g2_decap_8
XFILLER_107_60 VPWR VGND sg13g2_decap_8
X_0980_ Tile_X0Y0_FrameData[10] Tile_X0Y1_FrameStrobe[3] Tile_X0Y0_IHP_SRAM_top.Inst_IHP_SRAM_top_ConfigMem.Inst_frame3_bit10.Q
+ VPWR VGND sg13g2_dlhq_1
X_1532_ Tile_X0Y0_IHP_SRAM_top.Inst_IHP_SRAM_top_switch_matrix.N2BEG2 net137 VPWR
+ VGND sg13g2_buf_1
X_1601_ Tile_X0Y0_IHP_SRAM_top.Inst_IHP_SRAM_top_switch_matrix.WW4BEG6 net212 VPWR
+ VGND sg13g2_buf_1
XFILLER_8_142 VPWR VGND sg13g2_fill_2
X_0414_ Tile_X0Y0_IHP_SRAM_top.Inst_IHP_SRAM_top_ConfigMem.Inst_frame7_bit14.Q Tile_X0Y0_E1END[2]
+ Tile_X0Y0_E2MID[1] Tile_X0Y0_E2END[1] Tile_X0Y0_IHP_SRAM_top.Inst_IHP_SRAM_top_switch_matrix.J_NS2_BEG6
+ Tile_X0Y0_IHP_SRAM_top.Inst_IHP_SRAM_top_ConfigMem.Inst_frame7_bit15.Q Tile_X0Y0_IHP_SRAM_top.Inst_IHP_SRAM_top_switch_matrix.S2BEG6
+ VPWR VGND sg13g2_mux4_1
X_1394_ Tile_X0Y1_FrameData[22] Tile_X0Y1_FrameStrobe[7] Tile_X0Y1_IHP_SRAM_bot.Inst_IHP_SRAM_bot_ConfigMem.Inst_frame7_bit22.Q
+ VPWR VGND sg13g2_dlhq_1
X_0345_ Tile_X0Y1_IHP_SRAM_bot.Inst_IHP_SRAM_bot_ConfigMem.Inst_frame1_bit1.Q Tile_X0Y1_IHP_SRAM_bot.Inst_IHP_SRAM_bot_ConfigMem.Inst_frame1_bit2.Q
+ _0045_ VPWR VGND sg13g2_nor2_1
X_1463_ Tile_X0Y1_FrameData[17] Tile_X0Y1_FrameStrobe[9] Tile_X0Y1_IHP_SRAM_bot.Inst_IHP_SRAM_bot_ConfigMem.Inst_frame9_bit17.Q
+ VPWR VGND sg13g2_dlhq_1
XFILLER_37_78 VPWR VGND sg13g2_decap_8
XFILLER_94_40 VPWR VGND sg13g2_decap_8
X_0894_ Tile_X0Y0_FrameData[0] Tile_X0Y1_FrameStrobe[0] Tile_X0Y0_IHP_SRAM_top.Inst_IHP_SRAM_top_ConfigMem.Inst_frame0_bit0.Q
+ VPWR VGND sg13g2_dlhq_1
X_0963_ Tile_X0Y0_FrameData[27] Tile_X0Y1_FrameStrobe[3] Tile_X0Y0_IHP_SRAM_top.Inst_IHP_SRAM_top_ConfigMem.Inst_frame3_bit27.Q
+ VPWR VGND sg13g2_dlhq_1
X_1515_ Tile_X0Y1_FrameStrobe[9] net130 VPWR VGND sg13g2_buf_1
Xoutput203 net203 Tile_X0Y0_WW4BEG[12] VPWR VGND sg13g2_buf_1
Xoutput236 net236 Tile_X0Y1_FrameData_O[28] VPWR VGND sg13g2_buf_1
Xoutput214 net214 Tile_X0Y0_WW4BEG[8] VPWR VGND sg13g2_buf_1
XFILLER_64_2 VPWR VGND sg13g2_fill_1
Xoutput225 net225 Tile_X0Y1_FrameData_O[18] VPWR VGND sg13g2_buf_1
Xoutput258 net258 Tile_X0Y1_S2BEG[6] VPWR VGND sg13g2_buf_1
Xoutput269 net269 Tile_X0Y1_S4BEG[10] VPWR VGND sg13g2_buf_1
Xoutput247 net247 Tile_X0Y1_FrameData_O[9] VPWR VGND sg13g2_buf_1
X_1377_ Tile_X0Y1_FrameData[7] Tile_X0Y1_FrameStrobe[6] Tile_X0Y1_IHP_SRAM_bot.Inst_IHP_SRAM_bot_ConfigMem.Inst_frame6_bit7.Q
+ VPWR VGND sg13g2_dlhq_1
X_1446_ Tile_X0Y1_FrameData[2] Tile_X0Y1_FrameStrobe[8] Tile_X0Y1_IHP_SRAM_bot.Inst_IHP_SRAM_bot_ConfigMem.Inst_frame8_bit2.Q
+ VPWR VGND sg13g2_dlhq_1
X_0328_ VPWR _0031_ Tile_X0Y1_IHP_SRAM_bot.Inst_IHP_SRAM_bot_ConfigMem.Inst_frame7_bit12.Q
+ VGND sg13g2_inv_1
XFILLER_99_18 VPWR VGND sg13g2_decap_4
XFILLER_104_83 VPWR VGND sg13g2_fill_1
XFILLER_73_155 VPWR VGND sg13g2_fill_2
XFILLER_73_111 VPWR VGND sg13g2_fill_1
XFILLER_43_7 VPWR VGND sg13g2_fill_1
XFILLER_1_192 VPWR VGND sg13g2_fill_2
X_1300_ Tile_X0Y1_FrameData[20] Tile_X0Y1_FrameStrobe[4] Tile_X0Y1_IHP_SRAM_bot.Inst_IHP_SRAM_bot_ConfigMem.Inst_frame4_bit20.Q
+ VPWR VGND sg13g2_dlhq_1
X_1231_ Tile_X0Y1_FrameData[25] Tile_X0Y1_FrameStrobe[2] Tile_X0Y1_IHP_SRAM_bot.Inst_IHP_SRAM_bot_ConfigMem.Inst_frame2_bit25.Q
+ VPWR VGND sg13g2_dlhq_1
X_1162_ Tile_X0Y1_FrameData[30] Tile_X0Y1_FrameStrobe[0] Tile_X0Y1_IHP_SRAM_bot.Inst_IHP_SRAM_bot_ConfigMem.Inst_frame0_bit30.Q
+ VPWR VGND sg13g2_dlhq_1
X_1093_ Tile_X0Y0_FrameData[25] Tile_X0Y1_FrameStrobe[7] Tile_X0Y0_IHP_SRAM_top.Inst_IHP_SRAM_top_ConfigMem.Inst_frame7_bit25.Q
+ VPWR VGND sg13g2_dlhq_1
X_0877_ Tile_X0Y0_FrameData[17] Tile_X0Y1_FrameStrobe[0] Tile_X0Y0_IHP_SRAM_top.Inst_IHP_SRAM_top_ConfigMem.Inst_frame0_bit17.Q
+ VPWR VGND sg13g2_dlhq_1
X_0946_ Tile_X0Y0_FrameData[12] Tile_X0Y1_FrameStrobe[2] Tile_X0Y0_IHP_SRAM_top.Inst_IHP_SRAM_top_ConfigMem.Inst_frame2_bit12.Q
+ VPWR VGND sg13g2_dlhq_1
X_1429_ Tile_X0Y1_FrameData[19] Tile_X0Y1_FrameStrobe[8] Tile_X0Y1_IHP_SRAM_bot.Inst_IHP_SRAM_bot_ConfigMem.Inst_frame8_bit19.Q
+ VPWR VGND sg13g2_dlhq_1
XFILLER_55_199 VPWR VGND sg13g2_fill_1
XFILLER_78_203 VPWR VGND sg13g2_fill_1
XFILLER_46_177 VPWR VGND sg13g2_fill_2
X_0731_ Tile_X0Y1_IHP_SRAM_bot.Inst_IHP_SRAM_bot_ConfigMem.Inst_frame2_bit24.Q Tile_X0Y1_E1END[2]
+ Tile_X0Y1_EE4END[6] Tile_X0Y1_EE4END[14] Tile_X0Y1_IHP_SRAM_bot.Inst_IHP_SRAM_bot_switch_matrix.J_NS4_BEG14
+ Tile_X0Y1_IHP_SRAM_bot.Inst_IHP_SRAM_bot_ConfigMem.Inst_frame2_bit25.Q net17 VPWR
+ VGND sg13g2_mux4_1
X_0800_ VPWR _0238_ _0237_ VGND sg13g2_inv_1
XFILLER_108_190 VPWR VGND sg13g2_fill_1
X_0662_ Tile_X0Y1_IHP_SRAM_bot.Inst_IHP_SRAM_bot_ConfigMem.Inst_frame5_bit18.Q A_DOUT_SRAM0
+ A_DOUT_SRAM12 _0158_ _0080_ Tile_X0Y1_IHP_SRAM_bot.Inst_IHP_SRAM_bot_ConfigMem.Inst_frame5_bit19.Q
+ Tile_X0Y1_IHP_SRAM_bot.Inst_IHP_SRAM_bot_switch_matrix.WW4BEG12 VPWR VGND sg13g2_mux4_1
X_0593_ Tile_X0Y0_IHP_SRAM_top.Inst_IHP_SRAM_top_ConfigMem.Inst_frame7_bit25.Q Tile_X0Y0_E1END[2]
+ Tile_X0Y0_E6END[6] Tile_X0Y0_EE4END[14] Tile_X0Y0_IHP_SRAM_top.Inst_IHP_SRAM_top_switch_matrix.J_NS4_BEG2
+ Tile_X0Y0_IHP_SRAM_top.Inst_IHP_SRAM_top_ConfigMem.Inst_frame7_bit24.Q _0149_ VPWR
+ VGND sg13g2_mux4_1
X_1145_ Tile_X0Y0_FrameData[5] Tile_X0Y1_FrameStrobe[8] Tile_X0Y0_IHP_SRAM_top.Inst_IHP_SRAM_top_ConfigMem.Inst_frame8_bit5.Q
+ VPWR VGND sg13g2_dlhq_1
X_1214_ Tile_X0Y1_FrameData[10] Tile_X0Y1_FrameStrobe[1] Tile_X0Y1_IHP_SRAM_bot.Inst_IHP_SRAM_bot_ConfigMem.Inst_frame1_bit10.Q
+ VPWR VGND sg13g2_dlhq_1
XFILLER_52_169 VPWR VGND sg13g2_decap_8
X_1076_ Tile_X0Y0_FrameData[10] Tile_X0Y1_FrameStrobe[6] Tile_X0Y0_IHP_SRAM_top.Inst_IHP_SRAM_top_ConfigMem.Inst_frame6_bit10.Q
+ VPWR VGND sg13g2_dlhq_1
XFILLER_106_116 VPWR VGND sg13g2_decap_8
X_0929_ Tile_X0Y0_FrameData[29] Tile_X0Y1_FrameStrobe[2] Tile_X0Y0_IHP_SRAM_top.Inst_IHP_SRAM_top_ConfigMem.Inst_frame2_bit29.Q
+ VPWR VGND sg13g2_dlhq_1
XFILLER_45_34 VPWR VGND sg13g2_decap_8
XFILLER_105_182 VPWR VGND sg13g2_decap_8
XFILLER_34_125 VPWR VGND sg13g2_decap_4
XFILLER_42_180 VPWR VGND sg13g2_fill_2
XFILLER_42_191 VPWR VGND sg13g2_fill_1
X_1694_ Tile_X0Y1_IHP_SRAM_bot.Inst_IHP_SRAM_bot_switch_matrix.W2BEGb3 net299 VPWR
+ VGND sg13g2_buf_1
X_0714_ Tile_X0Y1_IHP_SRAM_bot.Inst_IHP_SRAM_bot_ConfigMem.Inst_frame3_bit22.Q Tile_X0Y1_E1END[1]
+ Tile_X0Y1_EE4END[5] Tile_X0Y1_EE4END[13] Tile_X0Y1_IHP_SRAM_bot.Inst_IHP_SRAM_bot_switch_matrix.J_NS4_BEG13
+ Tile_X0Y1_IHP_SRAM_bot.Inst_IHP_SRAM_bot_ConfigMem.Inst_frame3_bit23.Q net49 VPWR
+ VGND sg13g2_mux4_1
X_0645_ Tile_X0Y1_IHP_SRAM_bot.Inst_IHP_SRAM_bot_ConfigMem.Inst_frame1_bit30.Q Tile_X0Y1_N1END[3]
+ Tile_X0Y1_N4END[3] _0074_ Tile_X0Y0_S4END[7] Tile_X0Y1_IHP_SRAM_bot.Inst_IHP_SRAM_bot_ConfigMem.Inst_frame1_bit31.Q
+ Tile_X0Y1_IHP_SRAM_bot.Inst_IHP_SRAM_bot_switch_matrix.J_NS4_BEG11 VPWR VGND sg13g2_mux4_1
XFILLER_111_152 VPWR VGND sg13g2_decap_8
XFILLER_103_119 VPWR VGND sg13g2_decap_8
X_0576_ VGND VPWR _0015_ _0130_ _0134_ _0133_ sg13g2_a21oi_1
X_1128_ Tile_X0Y0_FrameData[22] Tile_X0Y1_FrameStrobe[8] Tile_X0Y0_IHP_SRAM_top.Inst_IHP_SRAM_top_ConfigMem.Inst_frame8_bit22.Q
+ VPWR VGND sg13g2_dlhq_1
XFILLER_25_169 VPWR VGND sg13g2_fill_2
X_1059_ Tile_X0Y0_FrameData[27] Tile_X0Y1_FrameStrobe[6] Tile_X0Y0_IHP_SRAM_top.Inst_IHP_SRAM_top_ConfigMem.Inst_frame6_bit27.Q
+ VPWR VGND sg13g2_dlhq_1
Xoutput69 net69 A_DIN_SRAM31 VPWR VGND sg13g2_buf_1
Xoutput47 net47 A_DIN_SRAM11 VPWR VGND sg13g2_buf_1
Xoutput58 net58 A_DIN_SRAM21 VPWR VGND sg13g2_buf_1
Xoutput14 net14 A_BM_SRAM11 VPWR VGND sg13g2_buf_1
Xoutput25 net25 A_BM_SRAM21 VPWR VGND sg13g2_buf_1
Xoutput36 net36 A_BM_SRAM31 VPWR VGND sg13g2_buf_1
XFILLER_97_73 VPWR VGND sg13g2_fill_2
X_0361_ Tile_X0Y0_IHP_SRAM_top.Inst_IHP_SRAM_top_ConfigMem.Inst_frame8_bit28.Q Tile_X0Y0_E1END[1]
+ Tile_X0Y0_E6END[9] Tile_X0Y0_IHP_SRAM_top.Inst_IHP_SRAM_top_switch_matrix.J_NS4_BEG13
+ _0059_ Tile_X0Y0_IHP_SRAM_top.Inst_IHP_SRAM_top_ConfigMem.Inst_frame8_bit29.Q _0060_
+ VPWR VGND sg13g2_mux4_1
X_0430_ VPWR VGND _0090_ _0089_ Tile_X0Y1_IHP_SRAM_bot.Inst_IHP_SRAM_bot_ConfigMem.Inst_frame0_bit25.Q
+ _0010_ _0091_ Tile_X0Y1_IHP_SRAM_bot.Inst_IHP_SRAM_bot_ConfigMem.Inst_frame0_bit24.Q
+ sg13g2_a221oi_1
XFILLER_89_128 VPWR VGND sg13g2_fill_1
X_0628_ Tile_X0Y1_IHP_SRAM_bot.Inst_IHP_SRAM_bot_ConfigMem.Inst_frame6_bit0.Q A_DOUT_SRAM3
+ A_DOUT_SRAM11 _0080_ _0081_ Tile_X0Y1_IHP_SRAM_bot.Inst_IHP_SRAM_bot_ConfigMem.Inst_frame6_bit1.Q
+ Tile_X0Y1_IHP_SRAM_bot.Inst_IHP_SRAM_bot_switch_matrix.W2BEG3 VPWR VGND sg13g2_mux4_1
X_1677_ Tile_X0Y1_IHP_SRAM_bot.Inst_IHP_SRAM_bot_switch_matrix.S4BEG2 net273 VPWR
+ VGND sg13g2_buf_1
XFILLER_97_183 VPWR VGND sg13g2_decap_8
X_0559_ Tile_X0Y0_IHP_SRAM_top.Inst_IHP_SRAM_top_ConfigMem.Inst_frame8_bit22.Q VPWR
+ _0119_ VGND _0117_ _0118_ sg13g2_o21ai_1
XFILLER_13_117 VPWR VGND sg13g2_fill_1
XFILLER_95_109 VPWR VGND sg13g2_decap_4
XFILLER_83_31 VPWR VGND sg13g2_fill_2
X_1531_ Tile_X0Y0_IHP_SRAM_top.Inst_IHP_SRAM_top_switch_matrix.N2BEG1 net136 VPWR
+ VGND sg13g2_buf_1
X_1600_ Tile_X0Y0_IHP_SRAM_top.Inst_IHP_SRAM_top_switch_matrix.WW4BEG5 net211 VPWR
+ VGND sg13g2_buf_1
X_1462_ Tile_X0Y1_FrameData[18] Tile_X0Y1_FrameStrobe[9] Tile_X0Y1_IHP_SRAM_bot.Inst_IHP_SRAM_bot_ConfigMem.Inst_frame9_bit18.Q
+ VPWR VGND sg13g2_dlhq_1
X_0413_ Tile_X0Y0_IHP_SRAM_top.Inst_IHP_SRAM_top_ConfigMem.Inst_frame8_bit8.Q Tile_X0Y0_E2MID[2]
+ Tile_X0Y0_E2END[2] Tile_X0Y0_E6END[2] Tile_X0Y0_IHP_SRAM_top.Inst_IHP_SRAM_top_switch_matrix.J_NS2_BEG5
+ Tile_X0Y0_IHP_SRAM_top.Inst_IHP_SRAM_top_ConfigMem.Inst_frame8_bit9.Q Tile_X0Y0_IHP_SRAM_top.Inst_IHP_SRAM_top_switch_matrix.N2BEG5
+ VPWR VGND sg13g2_mux4_1
X_1393_ Tile_X0Y1_FrameData[23] Tile_X0Y1_FrameStrobe[7] Tile_X0Y1_IHP_SRAM_bot.Inst_IHP_SRAM_bot_ConfigMem.Inst_frame7_bit23.Q
+ VPWR VGND sg13g2_dlhq_1
XFILLER_27_209 VPWR VGND sg13g2_fill_2
X_0344_ Tile_X0Y1_IHP_SRAM_bot.Inst_IHP_SRAM_bot_ConfigMem.Inst_frame1_bit1.Q VPWR
+ _0044_ VGND Tile_X0Y1_IHP_SRAM_bot.Inst_IHP_SRAM_bot_ConfigMem.Inst_frame1_bit2.Q
+ Tile_X0Y0_IHP_SRAM_top.Inst_IHP_SRAM_top_switch_matrix.S2BEG0 sg13g2_o21ai_1
XFILLER_104_203 VPWR VGND sg13g2_fill_1
XFILLER_76_120 VPWR VGND sg13g2_decap_8
XFILLER_94_74 VPWR VGND sg13g2_fill_1
X_0893_ Tile_X0Y0_FrameData[1] Tile_X0Y1_FrameStrobe[0] Tile_X0Y0_IHP_SRAM_top.Inst_IHP_SRAM_top_ConfigMem.Inst_frame0_bit1.Q
+ VPWR VGND sg13g2_dlhq_1
X_0962_ Tile_X0Y0_FrameData[28] Tile_X0Y1_FrameStrobe[3] Tile_X0Y0_IHP_SRAM_top.Inst_IHP_SRAM_top_ConfigMem.Inst_frame3_bit28.Q
+ VPWR VGND sg13g2_dlhq_1
XFILLER_101_206 VPWR VGND sg13g2_fill_2
X_1514_ Tile_X0Y1_FrameStrobe[8] net129 VPWR VGND sg13g2_buf_1
Xoutput204 net204 Tile_X0Y0_WW4BEG[13] VPWR VGND sg13g2_buf_1
Xoutput237 net237 Tile_X0Y1_FrameData_O[29] VPWR VGND sg13g2_buf_1
Xoutput215 net215 Tile_X0Y0_WW4BEG[9] VPWR VGND sg13g2_buf_1
Xoutput226 net226 Tile_X0Y1_FrameData_O[19] VPWR VGND sg13g2_buf_1
Xoutput248 net248 Tile_X0Y1_S1BEG[0] VPWR VGND sg13g2_buf_1
XFILLER_4_72 VPWR VGND sg13g2_fill_2
Xoutput259 net259 Tile_X0Y1_S2BEG[7] VPWR VGND sg13g2_buf_1
X_1445_ Tile_X0Y1_FrameData[3] Tile_X0Y1_FrameStrobe[8] Tile_X0Y1_IHP_SRAM_bot.Inst_IHP_SRAM_bot_ConfigMem.Inst_frame8_bit3.Q
+ VPWR VGND sg13g2_dlhq_1
XFILLER_82_123 VPWR VGND sg13g2_decap_8
XFILLER_67_142 VPWR VGND sg13g2_decap_4
X_1376_ Tile_X0Y1_FrameData[8] Tile_X0Y1_FrameStrobe[6] Tile_X0Y1_IHP_SRAM_bot.Inst_IHP_SRAM_bot_ConfigMem.Inst_frame6_bit8.Q
+ VPWR VGND sg13g2_dlhq_1
X_0327_ VPWR _0030_ Tile_X0Y1_IHP_SRAM_bot.Inst_IHP_SRAM_bot_ConfigMem.Inst_frame7_bit10.Q
+ VGND sg13g2_inv_1
XFILLER_58_120 VPWR VGND sg13g2_fill_1
XFILLER_64_77 VPWR VGND sg13g2_fill_1
XFILLER_89_96 VPWR VGND sg13g2_fill_1
X_1092_ Tile_X0Y0_FrameData[26] Tile_X0Y1_FrameStrobe[7] Tile_X0Y0_IHP_SRAM_top.Inst_IHP_SRAM_top_ConfigMem.Inst_frame7_bit26.Q
+ VPWR VGND sg13g2_dlhq_1
X_1230_ Tile_X0Y1_FrameData[26] Tile_X0Y1_FrameStrobe[2] Tile_X0Y1_IHP_SRAM_bot.Inst_IHP_SRAM_bot_ConfigMem.Inst_frame2_bit26.Q
+ VPWR VGND sg13g2_dlhq_1
X_1161_ Tile_X0Y1_FrameData[31] Tile_X0Y1_FrameStrobe[0] Tile_X0Y1_IHP_SRAM_bot.Inst_IHP_SRAM_bot_ConfigMem.Inst_frame0_bit31.Q
+ VPWR VGND sg13g2_dlhq_1
X_0945_ Tile_X0Y0_FrameData[13] Tile_X0Y1_FrameStrobe[2] Tile_X0Y0_IHP_SRAM_top.Inst_IHP_SRAM_top_ConfigMem.Inst_frame2_bit13.Q
+ VPWR VGND sg13g2_dlhq_1
X_0876_ Tile_X0Y0_FrameData[18] Tile_X0Y1_FrameStrobe[0] Tile_X0Y0_IHP_SRAM_top.Inst_IHP_SRAM_top_ConfigMem.Inst_frame0_bit18.Q
+ VPWR VGND sg13g2_dlhq_1
X_1428_ Tile_X0Y1_FrameData[20] Tile_X0Y1_FrameStrobe[8] Tile_X0Y1_IHP_SRAM_bot.Inst_IHP_SRAM_bot_ConfigMem.Inst_frame8_bit20.Q
+ VPWR VGND sg13g2_dlhq_1
XFILLER_70_115 VPWR VGND sg13g2_decap_8
X_1359_ Tile_X0Y1_FrameData[25] Tile_X0Y1_FrameStrobe[6] Tile_X0Y1_IHP_SRAM_bot.Inst_IHP_SRAM_bot_ConfigMem.Inst_frame6_bit25.Q
+ VPWR VGND sg13g2_dlhq_1
XFILLER_55_156 VPWR VGND sg13g2_decap_8
XFILLER_109_136 VPWR VGND sg13g2_decap_8
XFILLER_34_47 VPWR VGND sg13g2_decap_4
XFILLER_50_57 VPWR VGND sg13g2_decap_8
XFILLER_109_158 VPWR VGND sg13g2_decap_8
X_0730_ Tile_X0Y1_IHP_SRAM_bot.Inst_IHP_SRAM_bot_ConfigMem.Inst_frame2_bit22.Q Tile_X0Y1_E1END[1]
+ Tile_X0Y1_EE4END[5] Tile_X0Y1_EE4END[13] Tile_X0Y1_IHP_SRAM_bot.Inst_IHP_SRAM_bot_switch_matrix.J_NS4_BEG13
+ Tile_X0Y1_IHP_SRAM_bot.Inst_IHP_SRAM_bot_ConfigMem.Inst_frame2_bit23.Q net16 VPWR
+ VGND sg13g2_mux4_1
X_0661_ Tile_X0Y1_IHP_SRAM_bot.Inst_IHP_SRAM_bot_ConfigMem.Inst_frame1_bit14.Q Tile_X0Y1_N1END[3]
+ Tile_X0Y1_N4END[3] _0074_ Tile_X0Y0_S4END[7] Tile_X0Y1_IHP_SRAM_bot.Inst_IHP_SRAM_bot_ConfigMem.Inst_frame1_bit15.Q
+ _0158_ VPWR VGND sg13g2_mux4_1
X_0592_ VGND VPWR _0017_ _0144_ _0148_ _0147_ sg13g2_a21oi_1
X_1213_ Tile_X0Y1_FrameData[11] Tile_X0Y1_FrameStrobe[1] Tile_X0Y1_IHP_SRAM_bot.Inst_IHP_SRAM_bot_ConfigMem.Inst_frame1_bit11.Q
+ VPWR VGND sg13g2_dlhq_1
X_1144_ Tile_X0Y0_FrameData[6] Tile_X0Y1_FrameStrobe[8] Tile_X0Y0_IHP_SRAM_top.Inst_IHP_SRAM_top_ConfigMem.Inst_frame8_bit6.Q
+ VPWR VGND sg13g2_dlhq_1
XFILLER_1_84 VPWR VGND sg13g2_fill_1
XFILLER_52_126 VPWR VGND sg13g2_decap_8
X_1075_ Tile_X0Y0_FrameData[11] Tile_X0Y1_FrameStrobe[6] Tile_X0Y0_IHP_SRAM_top.Inst_IHP_SRAM_top_ConfigMem.Inst_frame6_bit11.Q
+ VPWR VGND sg13g2_dlhq_1
X_0928_ Tile_X0Y0_FrameData[30] Tile_X0Y1_FrameStrobe[2] Tile_X0Y0_IHP_SRAM_top.Inst_IHP_SRAM_top_ConfigMem.Inst_frame2_bit30.Q
+ VPWR VGND sg13g2_dlhq_1
X_0859_ Tile_X0Y1_E2END[3] Tile_X0Y1_IHP_SRAM_bot.Inst_IHP_SRAM_bot_ConfigMem.Inst_frame1_bit5.Q
+ Tile_X0Y1_IHP_SRAM_bot.Inst_IHP_SRAM_bot_ConfigMem.Inst_frame1_bit6.Q _0294_ VPWR
+ VGND sg13g2_nor3_1
XFILLER_28_112 VPWR VGND sg13g2_fill_2
XFILLER_105_161 VPWR VGND sg13g2_decap_8
X_0644_ Tile_X0Y1_IHP_SRAM_bot.Inst_IHP_SRAM_bot_ConfigMem.Inst_frame5_bit0.Q A_DOUT_SRAM3
+ A_DOUT_SRAM15 Tile_X0Y1_IHP_SRAM_bot.Inst_IHP_SRAM_bot_switch_matrix.J_NS4_BEG12
+ _0081_ Tile_X0Y1_IHP_SRAM_bot.Inst_IHP_SRAM_bot_ConfigMem.Inst_frame5_bit1.Q Tile_X0Y1_IHP_SRAM_bot.Inst_IHP_SRAM_bot_switch_matrix.WW4BEG3
+ VPWR VGND sg13g2_mux4_1
X_1693_ Tile_X0Y1_IHP_SRAM_bot.Inst_IHP_SRAM_bot_switch_matrix.W2BEGb2 net298 VPWR
+ VGND sg13g2_buf_1
X_0713_ Tile_X0Y1_IHP_SRAM_bot.Inst_IHP_SRAM_bot_ConfigMem.Inst_frame3_bit20.Q Tile_X0Y1_E1END[0]
+ Tile_X0Y1_EE4END[4] Tile_X0Y1_EE4END[12] Tile_X0Y1_IHP_SRAM_bot.Inst_IHP_SRAM_bot_switch_matrix.J_NS4_BEG12
+ Tile_X0Y1_IHP_SRAM_bot.Inst_IHP_SRAM_bot_ConfigMem.Inst_frame3_bit21.Q net48 VPWR
+ VGND sg13g2_mux4_1
XFILLER_111_131 VPWR VGND sg13g2_decap_8
X_0575_ Tile_X0Y0_IHP_SRAM_top.Inst_IHP_SRAM_top_ConfigMem.Inst_frame7_bit20.Q VPWR
+ _0133_ VGND _0131_ _0132_ sg13g2_o21ai_1
XFILLER_25_0 VPWR VGND sg13g2_fill_1
X_1127_ Tile_X0Y0_FrameData[23] Tile_X0Y1_FrameStrobe[8] Tile_X0Y0_IHP_SRAM_top.Inst_IHP_SRAM_top_ConfigMem.Inst_frame8_bit23.Q
+ VPWR VGND sg13g2_dlhq_1
X_1058_ Tile_X0Y0_FrameData[28] Tile_X0Y1_FrameStrobe[6] Tile_X0Y0_IHP_SRAM_top.Inst_IHP_SRAM_top_ConfigMem.Inst_frame6_bit28.Q
+ VPWR VGND sg13g2_dlhq_1
XFILLER_31_59 VPWR VGND sg13g2_decap_8
XFILLER_103_7 VPWR VGND sg13g2_decap_8
XFILLER_102_153 VPWR VGND sg13g2_decap_8
XFILLER_102_120 VPWR VGND sg13g2_decap_8
Xoutput48 net48 A_DIN_SRAM12 VPWR VGND sg13g2_buf_1
Xoutput59 net59 A_DIN_SRAM22 VPWR VGND sg13g2_buf_1
Xoutput15 net15 A_BM_SRAM12 VPWR VGND sg13g2_buf_1
Xoutput37 net37 A_BM_SRAM4 VPWR VGND sg13g2_buf_1
Xoutput26 net26 A_BM_SRAM22 VPWR VGND sg13g2_buf_1
XFILLER_102_186 VPWR VGND sg13g2_decap_8
XFILLER_102_164 VPWR VGND sg13g2_decap_8
XFILLER_16_137 VPWR VGND sg13g2_fill_1
XFILLER_56_89 VPWR VGND sg13g2_decap_8
XFILLER_72_88 VPWR VGND sg13g2_fill_2
X_0360_ VPWR VGND _0057_ _0058_ Tile_X0Y0_IHP_SRAM_top.Inst_IHP_SRAM_top_ConfigMem.Inst_frame0_bit27.Q
+ _0003_ _0059_ Tile_X0Y0_IHP_SRAM_top.Inst_IHP_SRAM_top_ConfigMem.Inst_frame0_bit26.Q
+ sg13g2_a221oi_1
X_0558_ Tile_X0Y0_IHP_SRAM_top.Inst_IHP_SRAM_top_ConfigMem.Inst_frame8_bit21.Q VPWR
+ _0118_ VGND Tile_X0Y0_IHP_SRAM_top.Inst_IHP_SRAM_top_ConfigMem.Inst_frame8_bit20.Q
+ Tile_X0Y0_IHP_SRAM_top.Inst_IHP_SRAM_top_switch_matrix.J_NS4_BEG14 sg13g2_o21ai_1
X_1676_ Tile_X0Y1_IHP_SRAM_bot.Inst_IHP_SRAM_bot_switch_matrix.S4BEG1 net272 VPWR
+ VGND sg13g2_buf_1
X_0627_ Tile_X0Y1_IHP_SRAM_bot.Inst_IHP_SRAM_bot_ConfigMem.Inst_frame7_bit30.Q A_DOUT_SRAM2
+ A_DOUT_SRAM10 _0079_ _0082_ Tile_X0Y1_IHP_SRAM_bot.Inst_IHP_SRAM_bot_ConfigMem.Inst_frame7_bit31.Q
+ Tile_X0Y1_IHP_SRAM_bot.Inst_IHP_SRAM_bot_switch_matrix.W2BEG2 VPWR VGND sg13g2_mux4_1
X_0489_ Tile_X0Y0_IHP_SRAM_top.Inst_IHP_SRAM_top_ConfigMem.Inst_frame4_bit23.Q A_DOUT_SRAM16
+ Tile_X0Y0_IHP_SRAM_top.Inst_IHP_SRAM_top_switch_matrix.J_NS4_BEG7 Tile_X0Y0_IHP_SRAM_top.Inst_IHP_SRAM_top_switch_matrix.J_NS4_BEG3
+ Tile_X0Y0_IHP_SRAM_top.Inst_IHP_SRAM_top_switch_matrix.J_NS2_BEG4 Tile_X0Y0_IHP_SRAM_top.Inst_IHP_SRAM_top_ConfigMem.Inst_frame4_bit22.Q
+ Tile_X0Y0_IHP_SRAM_top.Inst_IHP_SRAM_top_switch_matrix.W6BEG8 VPWR VGND sg13g2_mux4_1
XFILLER_26_26 VPWR VGND sg13g2_decap_8
XFILLER_26_59 VPWR VGND sg13g2_decap_4
XFILLER_42_14 VPWR VGND sg13g2_fill_1
XFILLER_107_95 VPWR VGND sg13g2_decap_8
X_1530_ Tile_X0Y0_IHP_SRAM_top.Inst_IHP_SRAM_top_switch_matrix.N2BEG0 net135 VPWR
+ VGND sg13g2_buf_1
X_0412_ Tile_X0Y0_IHP_SRAM_top.Inst_IHP_SRAM_top_ConfigMem.Inst_frame0_bit19.Q Tile_X0Y0_IHP_SRAM_top.Inst_IHP_SRAM_top_switch_matrix.N2BEGb5
+ Tile_X0Y0_S2MID[5] Tile_X0Y1_N2MID[5] Tile_X0Y0_S2END[5] Tile_X0Y0_IHP_SRAM_top.Inst_IHP_SRAM_top_ConfigMem.Inst_frame0_bit18.Q
+ Tile_X0Y0_IHP_SRAM_top.Inst_IHP_SRAM_top_switch_matrix.J_NS2_BEG5 VPWR VGND sg13g2_mux4_1
X_1392_ Tile_X0Y1_FrameData[24] Tile_X0Y1_FrameStrobe[7] Tile_X0Y1_IHP_SRAM_bot.Inst_IHP_SRAM_bot_ConfigMem.Inst_frame7_bit24.Q
+ VPWR VGND sg13g2_dlhq_1
X_1461_ Tile_X0Y1_FrameData[19] Tile_X0Y1_FrameStrobe[9] Tile_X0Y1_IHP_SRAM_bot.Inst_IHP_SRAM_bot_ConfigMem.Inst_frame9_bit19.Q
+ VPWR VGND sg13g2_dlhq_1
X_0343_ Tile_X0Y0_IHP_SRAM_top.Inst_IHP_SRAM_top_ConfigMem.Inst_frame0_bit9.Q Tile_X0Y0_IHP_SRAM_top.Inst_IHP_SRAM_top_switch_matrix.N2BEGb0
+ Tile_X0Y0_S2MID[0] Tile_X0Y1_N2MID[0] Tile_X0Y0_S2END[0] Tile_X0Y0_IHP_SRAM_top.Inst_IHP_SRAM_top_ConfigMem.Inst_frame0_bit8.Q
+ Tile_X0Y0_IHP_SRAM_top.Inst_IHP_SRAM_top_switch_matrix.J_NS2_BEG0 VPWR VGND sg13g2_mux4_1
XFILLER_92_0 VPWR VGND sg13g2_fill_1
X_1659_ Tile_X0Y0_IHP_SRAM_top.Inst_IHP_SRAM_top_switch_matrix.S2BEG4 net264 VPWR
+ VGND sg13g2_buf_1
XFILLER_26_210 VPWR VGND sg13g2_fill_2
XFILLER_41_213 VPWR VGND sg13g2_fill_2
XFILLER_76_176 VPWR VGND sg13g2_fill_1
X_0961_ Tile_X0Y0_FrameData[29] Tile_X0Y1_FrameStrobe[3] Tile_X0Y0_IHP_SRAM_top.Inst_IHP_SRAM_top_ConfigMem.Inst_frame3_bit29.Q
+ VPWR VGND sg13g2_dlhq_1
Xoutput205 net205 Tile_X0Y0_WW4BEG[14] VPWR VGND sg13g2_buf_1
X_0892_ Tile_X0Y0_FrameData[2] Tile_X0Y1_FrameStrobe[0] Tile_X0Y0_IHP_SRAM_top.Inst_IHP_SRAM_top_ConfigMem.Inst_frame0_bit2.Q
+ VPWR VGND sg13g2_dlhq_1
Xoutput216 net216 Tile_X0Y1_FrameData_O[0] VPWR VGND sg13g2_buf_1
X_1513_ Tile_X0Y1_FrameStrobe[7] net128 VPWR VGND sg13g2_buf_1
X_1375_ Tile_X0Y1_FrameData[9] Tile_X0Y1_FrameStrobe[6] Tile_X0Y1_IHP_SRAM_bot.Inst_IHP_SRAM_bot_ConfigMem.Inst_frame6_bit9.Q
+ VPWR VGND sg13g2_dlhq_1
Xoutput249 net249 Tile_X0Y1_S1BEG[1] VPWR VGND sg13g2_buf_1
X_1444_ Tile_X0Y1_FrameData[4] Tile_X0Y1_FrameStrobe[8] Tile_X0Y1_IHP_SRAM_bot.Inst_IHP_SRAM_bot_ConfigMem.Inst_frame8_bit4.Q
+ VPWR VGND sg13g2_dlhq_1
Xoutput238 net238 Tile_X0Y1_FrameData_O[2] VPWR VGND sg13g2_buf_1
Xoutput227 net227 Tile_X0Y1_FrameData_O[1] VPWR VGND sg13g2_buf_1
XFILLER_67_187 VPWR VGND sg13g2_fill_2
X_0326_ VPWR _0029_ Tile_X0Y1_IHP_SRAM_bot.Inst_IHP_SRAM_bot_ConfigMem.Inst_frame7_bit9.Q
+ VGND sg13g2_inv_1
XFILLER_23_49 VPWR VGND sg13g2_fill_1
XFILLER_58_176 VPWR VGND sg13g2_fill_2
XFILLER_58_154 VPWR VGND sg13g2_fill_1
XFILLER_58_143 VPWR VGND sg13g2_decap_8
XFILLER_104_74 VPWR VGND sg13g2_decap_8
XFILLER_80_88 VPWR VGND sg13g2_decap_4
XFILLER_1_194 VPWR VGND sg13g2_fill_1
XFILLER_29_7 VPWR VGND sg13g2_decap_4
X_1160_ Tile_X0Y0_FrameData[22] Tile_X0Y1_FrameStrobe[9] Tile_X0Y0_IHP_SRAM_top.Inst_IHP_SRAM_top_ConfigMem.Inst_frame9_bit22.Q
+ VPWR VGND sg13g2_dlhq_1
X_1091_ Tile_X0Y0_FrameData[27] Tile_X0Y1_FrameStrobe[7] Tile_X0Y0_IHP_SRAM_top.Inst_IHP_SRAM_top_ConfigMem.Inst_frame7_bit27.Q
+ VPWR VGND sg13g2_dlhq_1
XFILLER_64_135 VPWR VGND sg13g2_fill_2
XFILLER_64_102 VPWR VGND sg13g2_decap_8
X_0944_ Tile_X0Y0_FrameData[14] Tile_X0Y1_FrameStrobe[2] Tile_X0Y0_IHP_SRAM_top.Inst_IHP_SRAM_top_ConfigMem.Inst_frame2_bit14.Q
+ VPWR VGND sg13g2_dlhq_1
X_0875_ Tile_X0Y0_FrameData[19] Tile_X0Y1_FrameStrobe[0] Tile_X0Y0_IHP_SRAM_top.Inst_IHP_SRAM_top_ConfigMem.Inst_frame0_bit19.Q
+ VPWR VGND sg13g2_dlhq_1
X_1358_ Tile_X0Y1_FrameData[26] Tile_X0Y1_FrameStrobe[6] Tile_X0Y1_IHP_SRAM_bot.Inst_IHP_SRAM_bot_ConfigMem.Inst_frame6_bit26.Q
+ VPWR VGND sg13g2_dlhq_1
X_1427_ Tile_X0Y1_FrameData[21] Tile_X0Y1_FrameStrobe[8] Tile_X0Y1_IHP_SRAM_bot.Inst_IHP_SRAM_bot_ConfigMem.Inst_frame8_bit21.Q
+ VPWR VGND sg13g2_dlhq_1
X_0309_ VPWR _0012_ Tile_X0Y0_IHP_SRAM_top.Inst_IHP_SRAM_top_ConfigMem.Inst_frame8_bit18.Q
+ VGND sg13g2_inv_1
X_1289_ Tile_X0Y1_FrameData[31] Tile_X0Y1_FrameStrobe[4] Tile_X0Y1_IHP_SRAM_bot.Inst_IHP_SRAM_bot_ConfigMem.Inst_frame4_bit31.Q
+ VPWR VGND sg13g2_dlhq_1
XFILLER_109_115 VPWR VGND sg13g2_decap_8
XFILLER_50_36 VPWR VGND sg13g2_decap_4
XFILLER_61_116 VPWR VGND sg13g2_decap_8
XFILLER_108_181 VPWR VGND sg13g2_fill_2
XFILLER_108_170 VPWR VGND sg13g2_decap_8
X_0591_ Tile_X0Y0_IHP_SRAM_top.Inst_IHP_SRAM_top_ConfigMem.Inst_frame7_bit26.Q VPWR
+ _0147_ VGND _0145_ _0146_ sg13g2_o21ai_1
X_0660_ Tile_X0Y1_IHP_SRAM_bot.Inst_IHP_SRAM_bot_ConfigMem.Inst_frame5_bit16.Q A_DOUT_SRAM7
+ A_DOUT_SRAM11 Tile_X0Y1_IHP_SRAM_bot.Inst_IHP_SRAM_bot_switch_matrix.J_NS4_BEG4
+ _0081_ Tile_X0Y1_IHP_SRAM_bot.Inst_IHP_SRAM_bot_ConfigMem.Inst_frame5_bit17.Q Tile_X0Y1_IHP_SRAM_bot.Inst_IHP_SRAM_bot_switch_matrix.WW4BEG11
+ VPWR VGND sg13g2_mux4_1
X_1212_ Tile_X0Y1_FrameData[12] Tile_X0Y1_FrameStrobe[1] Tile_X0Y1_IHP_SRAM_bot.Inst_IHP_SRAM_bot_ConfigMem.Inst_frame1_bit12.Q
+ VPWR VGND sg13g2_dlhq_1
XFILLER_37_102 VPWR VGND sg13g2_fill_2
X_1143_ Tile_X0Y0_FrameData[7] Tile_X0Y1_FrameStrobe[8] Tile_X0Y0_IHP_SRAM_top.Inst_IHP_SRAM_top_ConfigMem.Inst_frame8_bit7.Q
+ VPWR VGND sg13g2_dlhq_1
X_1074_ Tile_X0Y0_FrameData[12] Tile_X0Y1_FrameStrobe[6] Tile_X0Y0_IHP_SRAM_top.Inst_IHP_SRAM_top_ConfigMem.Inst_frame6_bit12.Q
+ VPWR VGND sg13g2_dlhq_1
X_0927_ Tile_X0Y0_FrameData[31] Tile_X0Y1_FrameStrobe[2] Tile_X0Y0_IHP_SRAM_top.Inst_IHP_SRAM_top_ConfigMem.Inst_frame2_bit31.Q
+ VPWR VGND sg13g2_dlhq_1
X_0789_ VPWR _0228_ _0227_ VGND sg13g2_inv_1
X_0858_ VGND VPWR Tile_X0Y0_S2MID[2] _0037_ _0293_ _0292_ sg13g2_a21oi_1
XFILLER_45_25 VPWR VGND sg13g2_decap_4
XFILLER_101_97 VPWR VGND sg13g2_fill_2
XFILLER_3_201 VPWR VGND sg13g2_decap_8
XFILLER_105_151 VPWR VGND sg13g2_decap_4
XFILLER_42_182 VPWR VGND sg13g2_fill_1
XFILLER_111_110 VPWR VGND sg13g2_decap_8
X_0574_ Tile_X0Y0_IHP_SRAM_top.Inst_IHP_SRAM_top_ConfigMem.Inst_frame7_bit19.Q VPWR
+ _0132_ VGND Tile_X0Y0_IHP_SRAM_top.Inst_IHP_SRAM_top_ConfigMem.Inst_frame7_bit18.Q
+ Tile_X0Y0_IHP_SRAM_top.Inst_IHP_SRAM_top_switch_matrix.J_NS4_BEG12 sg13g2_o21ai_1
X_1692_ Tile_X0Y1_IHP_SRAM_bot.Inst_IHP_SRAM_bot_switch_matrix.W2BEGb1 net297 VPWR
+ VGND sg13g2_buf_1
X_0643_ Tile_X0Y1_IHP_SRAM_bot.Inst_IHP_SRAM_bot_ConfigMem.Inst_frame6_bit30.Q A_DOUT_SRAM2
+ A_DOUT_SRAM14 Tile_X0Y1_IHP_SRAM_bot.Inst_IHP_SRAM_bot_switch_matrix.J_NS4_BEG13
+ _0082_ Tile_X0Y1_IHP_SRAM_bot.Inst_IHP_SRAM_bot_ConfigMem.Inst_frame6_bit31.Q Tile_X0Y1_IHP_SRAM_bot.Inst_IHP_SRAM_bot_switch_matrix.WW4BEG2
+ VPWR VGND sg13g2_mux4_1
X_0712_ Tile_X0Y1_IHP_SRAM_bot.Inst_IHP_SRAM_bot_ConfigMem.Inst_frame3_bit18.Q Tile_X0Y1_EE4END[3]
+ Tile_X0Y1_EE4END[11] Tile_X0Y1_E6END[11] Tile_X0Y1_IHP_SRAM_bot.Inst_IHP_SRAM_bot_switch_matrix.J_NS4_BEG11
+ Tile_X0Y1_IHP_SRAM_bot.Inst_IHP_SRAM_bot_ConfigMem.Inst_frame3_bit19.Q net47 VPWR
+ VGND sg13g2_mux4_1
X_1126_ Tile_X0Y0_FrameData[24] Tile_X0Y1_FrameStrobe[8] Tile_X0Y0_IHP_SRAM_top.Inst_IHP_SRAM_top_ConfigMem.Inst_frame8_bit24.Q
+ VPWR VGND sg13g2_dlhq_1
XFILLER_18_0 VPWR VGND sg13g2_fill_1
X_1057_ Tile_X0Y0_FrameData[29] Tile_X0Y1_FrameStrobe[6] Tile_X0Y0_IHP_SRAM_top.Inst_IHP_SRAM_top_ConfigMem.Inst_frame6_bit29.Q
+ VPWR VGND sg13g2_dlhq_1
XFILLER_25_116 VPWR VGND sg13g2_fill_1
Xoutput49 net49 A_DIN_SRAM13 VPWR VGND sg13g2_buf_1
XFILLER_0_204 VPWR VGND sg13g2_decap_8
XFILLER_0_215 VPWR VGND sg13g2_fill_1
Xoutput16 net16 A_BM_SRAM13 VPWR VGND sg13g2_buf_1
Xoutput38 net38 A_BM_SRAM5 VPWR VGND sg13g2_buf_1
Xoutput27 net27 A_BM_SRAM23 VPWR VGND sg13g2_buf_1
XFILLER_16_105 VPWR VGND sg13g2_decap_8
X_0557_ Tile_X0Y0_IHP_SRAM_top.Inst_IHP_SRAM_top_switch_matrix.J_NS2_BEG2 Tile_X0Y0_IHP_SRAM_top.Inst_IHP_SRAM_top_ConfigMem.Inst_frame8_bit20.Q
+ _0117_ VPWR VGND sg13g2_nor2b_1
X_1675_ Tile_X0Y1_IHP_SRAM_bot.Inst_IHP_SRAM_bot_switch_matrix.S4BEG0 net271 VPWR
+ VGND sg13g2_buf_1
X_0626_ Tile_X0Y1_IHP_SRAM_bot.Inst_IHP_SRAM_bot_ConfigMem.Inst_frame7_bit28.Q A_DOUT_SRAM1
+ A_DOUT_SRAM9 _0078_ _0083_ Tile_X0Y1_IHP_SRAM_bot.Inst_IHP_SRAM_bot_ConfigMem.Inst_frame7_bit29.Q
+ Tile_X0Y1_IHP_SRAM_bot.Inst_IHP_SRAM_bot_switch_matrix.W2BEG1 VPWR VGND sg13g2_mux4_1
X_1109_ Tile_X0Y0_FrameData[9] Tile_X0Y1_FrameStrobe[7] Tile_X0Y0_IHP_SRAM_top.Inst_IHP_SRAM_top_ConfigMem.Inst_frame7_bit9.Q
+ VPWR VGND sg13g2_dlhq_1
X_0488_ Tile_X0Y0_IHP_SRAM_top.Inst_IHP_SRAM_top_ConfigMem.Inst_frame4_bit20.Q A_DOUT_SRAM23
+ Tile_X0Y0_IHP_SRAM_top.Inst_IHP_SRAM_top_switch_matrix.J_NS4_BEG4 Tile_X0Y0_IHP_SRAM_top.Inst_IHP_SRAM_top_switch_matrix.J_NS4_BEG8
+ Tile_X0Y0_IHP_SRAM_top.Inst_IHP_SRAM_top_switch_matrix.J_NS2_BEG3 Tile_X0Y0_IHP_SRAM_top.Inst_IHP_SRAM_top_ConfigMem.Inst_frame4_bit21.Q
+ Tile_X0Y0_IHP_SRAM_top.Inst_IHP_SRAM_top_switch_matrix.W6BEG7 VPWR VGND sg13g2_mux4_1
XFILLER_107_74 VPWR VGND sg13g2_decap_8
XFILLER_88_174 VPWR VGND sg13g2_decap_8
XFILLER_67_78 VPWR VGND sg13g2_decap_8
XFILLER_8_178 VPWR VGND sg13g2_fill_1
XFILLER_79_163 VPWR VGND sg13g2_fill_2
X_1391_ Tile_X0Y1_FrameData[25] Tile_X0Y1_FrameStrobe[7] Tile_X0Y1_IHP_SRAM_bot.Inst_IHP_SRAM_bot_ConfigMem.Inst_frame7_bit25.Q
+ VPWR VGND sg13g2_dlhq_1
X_0411_ Tile_X0Y1_IHP_SRAM_bot.Inst_IHP_SRAM_bot_ConfigMem.Inst_frame9_bit29.Q Tile_X0Y1_E2MID[2]
+ Tile_X0Y1_E6END[2] Tile_X0Y1_E2END[2] _0082_ Tile_X0Y1_IHP_SRAM_bot.Inst_IHP_SRAM_bot_ConfigMem.Inst_frame9_bit28.Q
+ Tile_X0Y0_IHP_SRAM_top.Inst_IHP_SRAM_top_switch_matrix.N2BEGb5 VPWR VGND sg13g2_mux4_1
X_0342_ Tile_X0Y1_IHP_SRAM_bot.Inst_IHP_SRAM_bot_ConfigMem.Inst_frame9_bit18.Q Tile_X0Y1_E2MID[7]
+ Tile_X0Y1_E2END[7] Tile_X0Y1_E6END[7] _0043_ Tile_X0Y1_IHP_SRAM_bot.Inst_IHP_SRAM_bot_ConfigMem.Inst_frame9_bit19.Q
+ Tile_X0Y0_IHP_SRAM_top.Inst_IHP_SRAM_top_switch_matrix.N2BEGb0 VPWR VGND sg13g2_mux4_1
X_1460_ Tile_X0Y1_FrameData[20] Tile_X0Y1_FrameStrobe[9] Tile_X0Y1_IHP_SRAM_bot.Inst_IHP_SRAM_bot_ConfigMem.Inst_frame9_bit20.Q
+ VPWR VGND sg13g2_dlhq_1
XFILLER_35_211 VPWR VGND sg13g2_fill_1
XFILLER_85_0 VPWR VGND sg13g2_fill_1
X_1658_ Tile_X0Y0_IHP_SRAM_top.Inst_IHP_SRAM_top_switch_matrix.S2BEG3 net263 VPWR
+ VGND sg13g2_buf_1
XFILLER_85_155 VPWR VGND sg13g2_decap_8
X_1589_ Tile_X0Y0_IHP_SRAM_top.Inst_IHP_SRAM_top_switch_matrix.W6BEG6 net196 VPWR
+ VGND sg13g2_buf_1
X_0609_ Tile_X0Y1_IHP_SRAM_bot.Inst_IHP_SRAM_bot_ConfigMem.Inst_frame8_bit14.Q Tile_X0Y1_E1END[0]
+ Tile_X0Y1_E6END[8] Tile_X0Y1_IHP_SRAM_bot.Inst_IHP_SRAM_bot_switch_matrix.J_NS4_BEG12
+ _0091_ Tile_X0Y1_IHP_SRAM_bot.Inst_IHP_SRAM_bot_ConfigMem.Inst_frame8_bit15.Q Tile_X0Y1_IHP_SRAM_bot.Inst_IHP_SRAM_bot_switch_matrix.S1BEG0
+ VPWR VGND sg13g2_mux4_1
XFILLER_94_54 VPWR VGND sg13g2_fill_1
XFILLER_91_147 VPWR VGND sg13g2_fill_2
X_0960_ Tile_X0Y0_FrameData[30] Tile_X0Y1_FrameStrobe[3] Tile_X0Y0_IHP_SRAM_top.Inst_IHP_SRAM_top_ConfigMem.Inst_frame3_bit30.Q
+ VPWR VGND sg13g2_dlhq_1
X_1512_ Tile_X0Y1_FrameStrobe[6] net127 VPWR VGND sg13g2_buf_1
Xoutput239 net239 Tile_X0Y1_FrameData_O[30] VPWR VGND sg13g2_buf_1
Xoutput206 net206 Tile_X0Y0_WW4BEG[15] VPWR VGND sg13g2_buf_1
X_0891_ Tile_X0Y0_FrameData[3] Tile_X0Y1_FrameStrobe[0] Tile_X0Y0_IHP_SRAM_top.Inst_IHP_SRAM_top_ConfigMem.Inst_frame0_bit3.Q
+ VPWR VGND sg13g2_dlhq_1
Xoutput228 net228 Tile_X0Y1_FrameData_O[20] VPWR VGND sg13g2_buf_1
Xoutput217 net217 Tile_X0Y1_FrameData_O[10] VPWR VGND sg13g2_buf_1
XFILLER_67_122 VPWR VGND sg13g2_fill_2
X_1374_ Tile_X0Y1_FrameData[10] Tile_X0Y1_FrameStrobe[6] Tile_X0Y1_IHP_SRAM_bot.Inst_IHP_SRAM_bot_ConfigMem.Inst_frame6_bit10.Q
+ VPWR VGND sg13g2_dlhq_1
X_0325_ VPWR _0028_ Tile_X0Y1_IHP_SRAM_bot.Inst_IHP_SRAM_bot_ConfigMem.Inst_frame7_bit7.Q
+ VGND sg13g2_inv_1
X_1443_ Tile_X0Y1_FrameData[5] Tile_X0Y1_FrameStrobe[8] Tile_X0Y1_IHP_SRAM_bot.Inst_IHP_SRAM_bot_ConfigMem.Inst_frame8_bit5.Q
+ VPWR VGND sg13g2_dlhq_1
XFILLER_104_53 VPWR VGND sg13g2_decap_8
XFILLER_1_173 VPWR VGND sg13g2_fill_2
XFILLER_49_144 VPWR VGND sg13g2_decap_8
XFILLER_49_155 VPWR VGND sg13g2_fill_1
X_1090_ Tile_X0Y0_FrameData[28] Tile_X0Y1_FrameStrobe[7] Tile_X0Y0_IHP_SRAM_top.Inst_IHP_SRAM_top_ConfigMem.Inst_frame7_bit28.Q
+ VPWR VGND sg13g2_dlhq_1
X_0874_ Tile_X0Y0_FrameData[20] Tile_X0Y1_FrameStrobe[0] Tile_X0Y0_IHP_SRAM_top.Inst_IHP_SRAM_top_ConfigMem.Inst_frame0_bit20.Q
+ VPWR VGND sg13g2_dlhq_1
X_0943_ Tile_X0Y0_FrameData[15] Tile_X0Y1_FrameStrobe[2] Tile_X0Y0_IHP_SRAM_top.Inst_IHP_SRAM_top_ConfigMem.Inst_frame2_bit15.Q
+ VPWR VGND sg13g2_dlhq_1
XFILLER_48_0 VPWR VGND sg13g2_fill_2
X_0308_ VPWR _0011_ Tile_X0Y0_IHP_SRAM_top.Inst_IHP_SRAM_top_ConfigMem.Inst_frame8_bit15.Q
+ VGND sg13g2_inv_1
X_1357_ Tile_X0Y1_FrameData[27] Tile_X0Y1_FrameStrobe[6] Tile_X0Y1_IHP_SRAM_bot.Inst_IHP_SRAM_bot_ConfigMem.Inst_frame6_bit27.Q
+ VPWR VGND sg13g2_dlhq_1
X_1288_ Tile_X0Y1_FrameData[0] Tile_X0Y1_FrameStrobe[3] Tile_X0Y1_IHP_SRAM_bot.Inst_IHP_SRAM_bot_ConfigMem.Inst_frame3_bit0.Q
+ VPWR VGND sg13g2_dlhq_1
X_1426_ Tile_X0Y1_FrameData[22] Tile_X0Y1_FrameStrobe[8] Tile_X0Y1_IHP_SRAM_bot.Inst_IHP_SRAM_bot_ConfigMem.Inst_frame8_bit22.Q
+ VPWR VGND sg13g2_dlhq_1
XFILLER_93_209 VPWR VGND sg13g2_fill_2
Xclkbuf_1_1__f_Tile_X0Y1_UserCLK clknet_0_Tile_X0Y1_UserCLK clknet_1_1__leaf_Tile_X0Y1_UserCLK
+ VPWR VGND sg13g2_buf_8
XFILLER_46_125 VPWR VGND sg13g2_fill_1
X_0590_ Tile_X0Y0_IHP_SRAM_top.Inst_IHP_SRAM_top_ConfigMem.Inst_frame7_bit25.Q VPWR
+ _0146_ VGND Tile_X0Y0_IHP_SRAM_top.Inst_IHP_SRAM_top_ConfigMem.Inst_frame7_bit24.Q
+ Tile_X0Y0_IHP_SRAM_top.Inst_IHP_SRAM_top_switch_matrix.J_NS4_BEG14 sg13g2_o21ai_1
X_1142_ Tile_X0Y0_FrameData[8] Tile_X0Y1_FrameStrobe[8] Tile_X0Y0_IHP_SRAM_top.Inst_IHP_SRAM_top_ConfigMem.Inst_frame8_bit8.Q
+ VPWR VGND sg13g2_dlhq_1
X_1211_ Tile_X0Y1_FrameData[13] Tile_X0Y1_FrameStrobe[1] Tile_X0Y1_IHP_SRAM_bot.Inst_IHP_SRAM_bot_ConfigMem.Inst_frame1_bit13.Q
+ VPWR VGND sg13g2_dlhq_1
X_1073_ Tile_X0Y0_FrameData[13] Tile_X0Y1_FrameStrobe[6] Tile_X0Y0_IHP_SRAM_top.Inst_IHP_SRAM_top_ConfigMem.Inst_frame6_bit13.Q
+ VPWR VGND sg13g2_dlhq_1
XFILLER_60_150 VPWR VGND sg13g2_fill_1
XFILLER_37_169 VPWR VGND sg13g2_fill_2
X_0926_ Tile_X0Y0_FrameData[0] Tile_X0Y1_FrameStrobe[1] Tile_X0Y0_IHP_SRAM_top.Inst_IHP_SRAM_top_ConfigMem.Inst_frame1_bit0.Q
+ VPWR VGND sg13g2_dlhq_1
X_0857_ VGND VPWR _0001_ Tile_X0Y1_IHP_SRAM_bot.Inst_IHP_SRAM_bot_ConfigMem.Inst_frame1_bit5.Q
+ _0292_ Tile_X0Y1_IHP_SRAM_bot.Inst_IHP_SRAM_bot_ConfigMem.Inst_frame1_bit6.Q sg13g2_a21oi_1
X_1409_ Tile_X0Y1_FrameData[7] Tile_X0Y1_FrameStrobe[7] Tile_X0Y1_IHP_SRAM_bot.Inst_IHP_SRAM_bot_ConfigMem.Inst_frame7_bit7.Q
+ VPWR VGND sg13g2_dlhq_1
XFILLER_29_38 VPWR VGND sg13g2_fill_2
X_0788_ Tile_X0Y1_IHP_SRAM_bot.Inst_IHP_SRAM_bot_ConfigMem.Inst_frame7_bit10.Q VPWR
+ _0227_ VGND Tile_X0Y1_E6END[5] Tile_X0Y1_IHP_SRAM_bot.Inst_IHP_SRAM_bot_ConfigMem.Inst_frame7_bit9.Q
+ sg13g2_o21ai_1
XFILLER_28_147 VPWR VGND sg13g2_decap_8
XFILLER_36_180 VPWR VGND sg13g2_decap_8
XFILLER_45_48 VPWR VGND sg13g2_fill_1
XFILLER_105_196 VPWR VGND sg13g2_decap_8
X_1691_ Tile_X0Y1_IHP_SRAM_bot.Inst_IHP_SRAM_bot_switch_matrix.W2BEGb0 net296 VPWR
+ VGND sg13g2_buf_1
X_0711_ Tile_X0Y1_IHP_SRAM_bot.Inst_IHP_SRAM_bot_ConfigMem.Inst_frame3_bit16.Q Tile_X0Y1_EE4END[2]
+ Tile_X0Y1_EE4END[10] Tile_X0Y1_E6END[10] Tile_X0Y1_IHP_SRAM_bot.Inst_IHP_SRAM_bot_switch_matrix.J_NS4_BEG10
+ Tile_X0Y1_IHP_SRAM_bot.Inst_IHP_SRAM_bot_ConfigMem.Inst_frame3_bit17.Q net46 VPWR
+ VGND sg13g2_mux4_1
X_0573_ Tile_X0Y0_IHP_SRAM_top.Inst_IHP_SRAM_top_switch_matrix.J_NS2_BEG4 Tile_X0Y0_IHP_SRAM_top.Inst_IHP_SRAM_top_ConfigMem.Inst_frame7_bit18.Q
+ _0131_ VPWR VGND sg13g2_nor2b_1
X_0642_ Tile_X0Y1_IHP_SRAM_bot.Inst_IHP_SRAM_bot_ConfigMem.Inst_frame6_bit28.Q A_DOUT_SRAM1
+ A_DOUT_SRAM13 Tile_X0Y1_IHP_SRAM_bot.Inst_IHP_SRAM_bot_switch_matrix.J_NS4_BEG14
+ _0083_ Tile_X0Y1_IHP_SRAM_bot.Inst_IHP_SRAM_bot_ConfigMem.Inst_frame6_bit29.Q Tile_X0Y1_IHP_SRAM_bot.Inst_IHP_SRAM_bot_switch_matrix.WW4BEG1
+ VPWR VGND sg13g2_mux4_1
X_1125_ Tile_X0Y0_FrameData[25] Tile_X0Y1_FrameStrobe[8] Tile_X0Y0_IHP_SRAM_top.Inst_IHP_SRAM_top_ConfigMem.Inst_frame8_bit25.Q
+ VPWR VGND sg13g2_dlhq_1
X_1056_ Tile_X0Y0_FrameData[30] Tile_X0Y1_FrameStrobe[6] Tile_X0Y0_IHP_SRAM_top.Inst_IHP_SRAM_top_ConfigMem.Inst_frame6_bit30.Q
+ VPWR VGND sg13g2_dlhq_1
XFILLER_33_183 VPWR VGND sg13g2_decap_8
X_0909_ Tile_X0Y0_FrameData[17] Tile_X0Y1_FrameStrobe[1] Tile_X0Y0_IHP_SRAM_top.Inst_IHP_SRAM_top_ConfigMem.Inst_frame1_bit17.Q
+ VPWR VGND sg13g2_dlhq_1
Xoutput17 net17 A_BM_SRAM14 VPWR VGND sg13g2_buf_1
Xoutput28 net28 A_BM_SRAM24 VPWR VGND sg13g2_buf_1
Xoutput39 net39 A_BM_SRAM6 VPWR VGND sg13g2_buf_1
XFILLER_21_61 VPWR VGND sg13g2_decap_4
XFILLER_30_142 VPWR VGND sg13g2_fill_2
X_1674_ Tile_X0Y0_IHP_SRAM_top.Inst_IHP_SRAM_top_switch_matrix.S4BEG3 net270 VPWR
+ VGND sg13g2_buf_1
X_0625_ Tile_X0Y1_IHP_SRAM_bot.Inst_IHP_SRAM_bot_ConfigMem.Inst_frame7_bit26.Q A_DOUT_SRAM0
+ A_DOUT_SRAM8 _0043_ _0084_ Tile_X0Y1_IHP_SRAM_bot.Inst_IHP_SRAM_bot_ConfigMem.Inst_frame7_bit27.Q
+ Tile_X0Y1_IHP_SRAM_bot.Inst_IHP_SRAM_bot_switch_matrix.W2BEG0 VPWR VGND sg13g2_mux4_1
X_0556_ Tile_X0Y0_IHP_SRAM_top.Inst_IHP_SRAM_top_switch_matrix.J_NS4_BEG6 Tile_X0Y0_IHP_SRAM_top.Inst_IHP_SRAM_top_switch_matrix.J_NS4_BEG10
+ Tile_X0Y0_IHP_SRAM_top.Inst_IHP_SRAM_top_ConfigMem.Inst_frame8_bit20.Q _0116_ VPWR
+ VGND sg13g2_mux2_1
X_0487_ Tile_X0Y0_IHP_SRAM_top.Inst_IHP_SRAM_top_ConfigMem.Inst_frame4_bit18.Q A_DOUT_SRAM22
+ Tile_X0Y0_IHP_SRAM_top.Inst_IHP_SRAM_top_switch_matrix.J_NS4_BEG5 Tile_X0Y0_IHP_SRAM_top.Inst_IHP_SRAM_top_switch_matrix.J_NS4_BEG9
+ Tile_X0Y0_IHP_SRAM_top.Inst_IHP_SRAM_top_switch_matrix.J_NS2_BEG2 Tile_X0Y0_IHP_SRAM_top.Inst_IHP_SRAM_top_ConfigMem.Inst_frame4_bit19.Q
+ Tile_X0Y0_IHP_SRAM_top.Inst_IHP_SRAM_top_switch_matrix.W6BEG6 VPWR VGND sg13g2_mux4_1
XFILLER_30_0 VPWR VGND sg13g2_fill_1
X_1108_ Tile_X0Y0_FrameData[10] Tile_X0Y1_FrameStrobe[7] Tile_X0Y0_IHP_SRAM_top.Inst_IHP_SRAM_top_ConfigMem.Inst_frame7_bit10.Q
+ VPWR VGND sg13g2_dlhq_1
X_1039_ Tile_X0Y0_FrameData[15] Tile_X0Y1_FrameStrobe[5] Tile_X0Y0_IHP_SRAM_top.Inst_IHP_SRAM_top_ConfigMem.Inst_frame5_bit15.Q
+ VPWR VGND sg13g2_dlhq_1
XFILLER_21_175 VPWR VGND sg13g2_fill_1
XFILLER_42_49 VPWR VGND sg13g2_decap_8
XFILLER_107_53 VPWR VGND sg13g2_decap_8
XFILLER_32_93 VPWR VGND sg13g2_fill_1
X_1390_ Tile_X0Y1_FrameData[26] Tile_X0Y1_FrameStrobe[7] Tile_X0Y1_IHP_SRAM_bot.Inst_IHP_SRAM_bot_ConfigMem.Inst_frame7_bit26.Q
+ VPWR VGND sg13g2_dlhq_1
X_0341_ Tile_X0Y1_IHP_SRAM_bot.Inst_IHP_SRAM_bot_ConfigMem.Inst_frame0_bit8.Q Tile_X0Y1_N2MID[0]
+ Tile_X0Y1_N2END[0] Tile_X0Y0_IHP_SRAM_top.Inst_IHP_SRAM_top_switch_matrix.S2BEG0
+ Tile_X0Y0_S2MID[0] Tile_X0Y1_IHP_SRAM_bot.Inst_IHP_SRAM_bot_ConfigMem.Inst_frame0_bit9.Q
+ _0043_ VPWR VGND sg13g2_mux4_1
X_0410_ Tile_X0Y1_IHP_SRAM_bot.Inst_IHP_SRAM_bot_ConfigMem.Inst_frame0_bit18.Q Tile_X0Y1_N2MID[5]
+ Tile_X0Y1_N2END[5] Tile_X0Y0_IHP_SRAM_top.Inst_IHP_SRAM_top_switch_matrix.S2BEG5
+ Tile_X0Y0_S2MID[5] Tile_X0Y1_IHP_SRAM_bot.Inst_IHP_SRAM_bot_ConfigMem.Inst_frame0_bit19.Q
+ _0082_ VPWR VGND sg13g2_mux4_1
XFILLER_50_215 VPWR VGND sg13g2_fill_1
X_0608_ Tile_X0Y0_IHP_SRAM_top.Inst_IHP_SRAM_top_ConfigMem.Inst_frame9_bit23.Q Tile_X0Y0_E1END[0]
+ Tile_X0Y0_IHP_SRAM_top.Inst_IHP_SRAM_top_switch_matrix.J_NS4_BEG12 Tile_X0Y0_E6END[4]
+ _0087_ Tile_X0Y0_IHP_SRAM_top.Inst_IHP_SRAM_top_ConfigMem.Inst_frame9_bit22.Q Tile_X0Y0_IHP_SRAM_top.Inst_IHP_SRAM_top_switch_matrix.N1BEG0
+ VPWR VGND sg13g2_mux4_1
X_1588_ Tile_X0Y0_IHP_SRAM_top.Inst_IHP_SRAM_top_switch_matrix.W6BEG5 net195 VPWR
+ VGND sg13g2_buf_1
X_1726_ Tile_X0Y1_IHP_SRAM_bot.Inst_IHP_SRAM_bot_switch_matrix.WW4BEG15 net322 VPWR
+ VGND sg13g2_buf_1
X_1657_ Tile_X0Y0_IHP_SRAM_top.Inst_IHP_SRAM_top_switch_matrix.S2BEG2 net262 VPWR
+ VGND sg13g2_buf_1
X_0539_ VPWR VGND Tile_X0Y0_IHP_SRAM_top.Inst_IHP_SRAM_top_ConfigMem.Inst_frame1_bit6.Q
+ _0100_ _0101_ Tile_X0Y0_IHP_SRAM_top.Inst_IHP_SRAM_top_ConfigMem.Inst_frame1_bit7.Q
+ net10 _0042_ sg13g2_a221oi_1
XFILLER_41_215 VPWR VGND sg13g2_fill_1
XFILLER_78_12 VPWR VGND sg13g2_fill_2
XFILLER_76_156 VPWR VGND sg13g2_fill_2
X_0890_ Tile_X0Y0_FrameData[4] Tile_X0Y1_FrameStrobe[0] Tile_X0Y0_IHP_SRAM_top.Inst_IHP_SRAM_top_ConfigMem.Inst_frame0_bit4.Q
+ VPWR VGND sg13g2_dlhq_1
X_1511_ Tile_X0Y1_FrameStrobe[5] net126 VPWR VGND sg13g2_buf_1
Xoutput207 net207 Tile_X0Y0_WW4BEG[1] VPWR VGND sg13g2_buf_1
Xoutput229 net229 Tile_X0Y1_FrameData_O[21] VPWR VGND sg13g2_buf_1
X_1442_ Tile_X0Y1_FrameData[6] Tile_X0Y1_FrameStrobe[8] Tile_X0Y1_IHP_SRAM_bot.Inst_IHP_SRAM_bot_ConfigMem.Inst_frame8_bit6.Q
+ VPWR VGND sg13g2_dlhq_1
Xoutput218 net218 Tile_X0Y1_FrameData_O[11] VPWR VGND sg13g2_buf_1
XFILLER_67_189 VPWR VGND sg13g2_fill_1
X_1373_ Tile_X0Y1_FrameData[11] Tile_X0Y1_FrameStrobe[6] Tile_X0Y1_IHP_SRAM_bot.Inst_IHP_SRAM_bot_ConfigMem.Inst_frame6_bit11.Q
+ VPWR VGND sg13g2_dlhq_1
X_0324_ VPWR _0027_ Tile_X0Y1_IHP_SRAM_bot.Inst_IHP_SRAM_bot_ConfigMem.Inst_frame7_bit6.Q
+ VGND sg13g2_inv_1
XFILLER_82_137 VPWR VGND sg13g2_fill_1
XFILLER_23_18 VPWR VGND sg13g2_decap_8
X_1709_ Tile_X0Y1_IHP_SRAM_bot.Inst_IHP_SRAM_bot_switch_matrix.W6BEG10 net305 VPWR
+ VGND sg13g2_buf_1
XFILLER_73_148 VPWR VGND sg13g2_decap_8
XFILLER_48_59 VPWR VGND sg13g2_fill_1
XFILLER_14_215 VPWR VGND sg13g2_fill_1
XFILLER_72_170 VPWR VGND sg13g2_fill_2
XFILLER_54_80 VPWR VGND sg13g2_fill_2
X_0873_ Tile_X0Y0_FrameData[21] Tile_X0Y1_FrameStrobe[0] Tile_X0Y0_IHP_SRAM_top.Inst_IHP_SRAM_top_ConfigMem.Inst_frame0_bit21.Q
+ VPWR VGND sg13g2_dlhq_1
X_0942_ Tile_X0Y0_FrameData[16] Tile_X0Y1_FrameStrobe[2] Tile_X0Y0_IHP_SRAM_top.Inst_IHP_SRAM_top_ConfigMem.Inst_frame2_bit16.Q
+ VPWR VGND sg13g2_dlhq_1
X_1425_ Tile_X0Y1_FrameData[23] Tile_X0Y1_FrameStrobe[8] Tile_X0Y1_IHP_SRAM_bot.Inst_IHP_SRAM_bot_ConfigMem.Inst_frame8_bit23.Q
+ VPWR VGND sg13g2_dlhq_1
X_0307_ VPWR _0010_ Tile_X0Y1_E6END[0] VGND sg13g2_inv_1
X_1356_ Tile_X0Y1_FrameData[28] Tile_X0Y1_FrameStrobe[6] Tile_X0Y1_IHP_SRAM_bot.Inst_IHP_SRAM_bot_ConfigMem.Inst_frame6_bit28.Q
+ VPWR VGND sg13g2_dlhq_1
X_1287_ Tile_X0Y1_FrameData[1] Tile_X0Y1_FrameStrobe[3] Tile_X0Y1_IHP_SRAM_bot.Inst_IHP_SRAM_bot_ConfigMem.Inst_frame3_bit1.Q
+ VPWR VGND sg13g2_dlhq_1
XFILLER_55_126 VPWR VGND sg13g2_fill_2
XFILLER_55_137 VPWR VGND sg13g2_fill_2
XFILLER_75_79 VPWR VGND sg13g2_fill_2
XFILLER_108_194 VPWR VGND sg13g2_fill_1
X_1141_ Tile_X0Y0_FrameData[9] Tile_X0Y1_FrameStrobe[8] Tile_X0Y0_IHP_SRAM_top.Inst_IHP_SRAM_top_ConfigMem.Inst_frame8_bit9.Q
+ VPWR VGND sg13g2_dlhq_1
X_1072_ Tile_X0Y0_FrameData[14] Tile_X0Y1_FrameStrobe[6] Tile_X0Y0_IHP_SRAM_top.Inst_IHP_SRAM_top_ConfigMem.Inst_frame6_bit14.Q
+ VPWR VGND sg13g2_dlhq_1
X_1210_ Tile_X0Y1_FrameData[14] Tile_X0Y1_FrameStrobe[1] Tile_X0Y1_IHP_SRAM_bot.Inst_IHP_SRAM_bot_ConfigMem.Inst_frame1_bit14.Q
+ VPWR VGND sg13g2_dlhq_1
XFILLER_52_107 VPWR VGND sg13g2_fill_2
XFILLER_45_181 VPWR VGND sg13g2_fill_2
XFILLER_106_109 VPWR VGND sg13g2_decap_8
X_0925_ Tile_X0Y0_FrameData[1] Tile_X0Y1_FrameStrobe[1] Tile_X0Y0_IHP_SRAM_top.Inst_IHP_SRAM_top_ConfigMem.Inst_frame1_bit1.Q
+ VPWR VGND sg13g2_dlhq_1
X_0787_ VGND VPWR _0219_ _0221_ Tile_X0Y1_IHP_SRAM_bot.Inst_IHP_SRAM_bot_switch_matrix.S4BEG0
+ _0226_ sg13g2_a21oi_1
X_0856_ _0288_ _0289_ _0290_ _0291_ VPWR VGND sg13g2_nor3_1
X_1408_ Tile_X0Y1_FrameData[8] Tile_X0Y1_FrameStrobe[7] Tile_X0Y1_IHP_SRAM_bot.Inst_IHP_SRAM_bot_ConfigMem.Inst_frame7_bit8.Q
+ VPWR VGND sg13g2_dlhq_1
X_1339_ Tile_X0Y1_FrameData[13] Tile_X0Y1_FrameStrobe[5] Tile_X0Y1_IHP_SRAM_bot.Inst_IHP_SRAM_bot_ConfigMem.Inst_frame5_bit13.Q
+ VPWR VGND sg13g2_dlhq_1
XFILLER_105_175 VPWR VGND sg13g2_decap_8
XFILLER_105_142 VPWR VGND sg13g2_decap_4
XFILLER_86_89 VPWR VGND sg13g2_fill_1
XFILLER_34_118 VPWR VGND sg13g2_decap_8
X_0641_ Tile_X0Y1_IHP_SRAM_bot.Inst_IHP_SRAM_bot_ConfigMem.Inst_frame6_bit26.Q A_DOUT_SRAM0
+ A_DOUT_SRAM12 Tile_X0Y1_IHP_SRAM_bot.Inst_IHP_SRAM_bot_switch_matrix.J_NS4_BEG15
+ _0084_ Tile_X0Y1_IHP_SRAM_bot.Inst_IHP_SRAM_bot_ConfigMem.Inst_frame6_bit27.Q Tile_X0Y1_IHP_SRAM_bot.Inst_IHP_SRAM_bot_switch_matrix.WW4BEG0
+ VPWR VGND sg13g2_mux4_1
X_1690_ Tile_X0Y1_IHP_SRAM_bot.Inst_IHP_SRAM_bot_switch_matrix.W2BEG7 net295 VPWR
+ VGND sg13g2_buf_1
X_0710_ Tile_X0Y1_IHP_SRAM_bot.Inst_IHP_SRAM_bot_ConfigMem.Inst_frame3_bit14.Q Tile_X0Y1_EE4END[1]
+ Tile_X0Y1_EE4END[9] Tile_X0Y1_E6END[9] Tile_X0Y1_IHP_SRAM_bot.Inst_IHP_SRAM_bot_switch_matrix.J_NS4_BEG9
+ Tile_X0Y1_IHP_SRAM_bot.Inst_IHP_SRAM_bot_ConfigMem.Inst_frame3_bit15.Q net75 VPWR
+ VGND sg13g2_mux4_1
XFILLER_111_145 VPWR VGND sg13g2_decap_8
X_0572_ Tile_X0Y0_IHP_SRAM_top.Inst_IHP_SRAM_top_switch_matrix.J_NS4_BEG4 Tile_X0Y0_IHP_SRAM_top.Inst_IHP_SRAM_top_switch_matrix.J_NS4_BEG8
+ Tile_X0Y0_IHP_SRAM_top.Inst_IHP_SRAM_top_ConfigMem.Inst_frame7_bit18.Q _0130_ VPWR
+ VGND sg13g2_mux2_1
X_1124_ Tile_X0Y0_FrameData[26] Tile_X0Y1_FrameStrobe[8] Tile_X0Y0_IHP_SRAM_top.Inst_IHP_SRAM_top_ConfigMem.Inst_frame8_bit26.Q
+ VPWR VGND sg13g2_dlhq_1
X_1055_ Tile_X0Y0_FrameData[31] Tile_X0Y1_FrameStrobe[6] Tile_X0Y0_IHP_SRAM_top.Inst_IHP_SRAM_top_ConfigMem.Inst_frame6_bit31.Q
+ VPWR VGND sg13g2_dlhq_1
XFILLER_31_18 VPWR VGND sg13g2_fill_2
X_0908_ Tile_X0Y0_FrameData[18] Tile_X0Y1_FrameStrobe[1] Tile_X0Y0_IHP_SRAM_top.Inst_IHP_SRAM_top_ConfigMem.Inst_frame1_bit18.Q
+ VPWR VGND sg13g2_dlhq_1
Xoutput18 net18 A_BM_SRAM15 VPWR VGND sg13g2_buf_1
Xoutput29 net29 A_BM_SRAM25 VPWR VGND sg13g2_buf_1
X_0839_ _0275_ Tile_X0Y1_E2END[5] Tile_X0Y1_IHP_SRAM_bot.Inst_IHP_SRAM_bot_ConfigMem.Inst_frame2_bit30.Q
+ VPWR VGND sg13g2_nand2b_1
XFILLER_24_151 VPWR VGND sg13g2_fill_2
XFILLER_108_0 VPWR VGND sg13g2_fill_1
XFILLER_62_80 VPWR VGND sg13g2_fill_2
X_0624_ Tile_X0Y1_IHP_SRAM_bot.Inst_IHP_SRAM_bot_ConfigMem.Inst_frame7_bit25.Q Tile_X0Y1_N1END[3]
+ A_DOUT_SRAM1 _0074_ A_DOUT_SRAM4 Tile_X0Y1_IHP_SRAM_bot.Inst_IHP_SRAM_bot_ConfigMem.Inst_frame7_bit24.Q
+ Tile_X0Y1_IHP_SRAM_bot.Inst_IHP_SRAM_bot_switch_matrix.W1BEG3 VPWR VGND sg13g2_mux4_1
X_1673_ Tile_X0Y0_IHP_SRAM_top.Inst_IHP_SRAM_top_switch_matrix.S4BEG2 net269 VPWR
+ VGND sg13g2_buf_1
X_0555_ _0113_ _0115_ Tile_X0Y0_IHP_SRAM_top.Inst_IHP_SRAM_top_switch_matrix.N4BEG1
+ VPWR VGND sg13g2_nor2_1
X_0486_ Tile_X0Y0_IHP_SRAM_top.Inst_IHP_SRAM_top_ConfigMem.Inst_frame4_bit17.Q A_DOUT_SRAM21
+ Tile_X0Y0_IHP_SRAM_top.Inst_IHP_SRAM_top_switch_matrix.J_NS4_BEG10 Tile_X0Y0_IHP_SRAM_top.Inst_IHP_SRAM_top_switch_matrix.J_NS4_BEG6
+ Tile_X0Y0_IHP_SRAM_top.Inst_IHP_SRAM_top_switch_matrix.J_NS2_BEG1 Tile_X0Y0_IHP_SRAM_top.Inst_IHP_SRAM_top_ConfigMem.Inst_frame4_bit16.Q
+ Tile_X0Y0_IHP_SRAM_top.Inst_IHP_SRAM_top_switch_matrix.W6BEG5 VPWR VGND sg13g2_mux4_1
XFILLER_23_0 VPWR VGND sg13g2_fill_1
XFILLER_38_210 VPWR VGND sg13g2_fill_2
X_1107_ Tile_X0Y0_FrameData[11] Tile_X0Y1_FrameStrobe[7] Tile_X0Y0_IHP_SRAM_top.Inst_IHP_SRAM_top_ConfigMem.Inst_frame7_bit11.Q
+ VPWR VGND sg13g2_dlhq_1
X_1038_ Tile_X0Y0_FrameData[16] Tile_X0Y1_FrameStrobe[5] Tile_X0Y0_IHP_SRAM_top.Inst_IHP_SRAM_top_ConfigMem.Inst_frame5_bit16.Q
+ VPWR VGND sg13g2_dlhq_1
XFILLER_107_32 VPWR VGND sg13g2_decap_8
XFILLER_29_210 VPWR VGND sg13g2_fill_2
XFILLER_32_72 VPWR VGND sg13g2_decap_8
X_0340_ Tile_X0Y0_IHP_SRAM_top.Inst_IHP_SRAM_top_ConfigMem.Inst_frame7_bit2.Q Tile_X0Y0_E2MID[7]
+ Tile_X0Y0_E2END[7] Tile_X0Y0_E6END[8] Tile_X0Y0_IHP_SRAM_top.Inst_IHP_SRAM_top_switch_matrix.J_NS2_BEG0
+ Tile_X0Y0_IHP_SRAM_top.Inst_IHP_SRAM_top_ConfigMem.Inst_frame7_bit3.Q Tile_X0Y0_IHP_SRAM_top.Inst_IHP_SRAM_top_switch_matrix.S2BEG0
+ VPWR VGND sg13g2_mux4_1
XFILLER_57_80 VPWR VGND sg13g2_fill_2
X_1725_ Tile_X0Y1_IHP_SRAM_bot.Inst_IHP_SRAM_bot_switch_matrix.WW4BEG14 net321 VPWR
+ VGND sg13g2_buf_1
X_0538_ _0101_ Tile_X0Y0_E2END[4] Tile_X0Y0_IHP_SRAM_top.Inst_IHP_SRAM_top_ConfigMem.Inst_frame1_bit7.Q
+ VPWR VGND sg13g2_nand2b_1
X_1587_ Tile_X0Y0_IHP_SRAM_top.Inst_IHP_SRAM_top_switch_matrix.W6BEG4 net194 VPWR
+ VGND sg13g2_buf_1
X_1656_ Tile_X0Y0_IHP_SRAM_top.Inst_IHP_SRAM_top_switch_matrix.S2BEG1 net261 VPWR
+ VGND sg13g2_buf_1
X_0607_ Tile_X0Y1_IHP_SRAM_bot.Inst_IHP_SRAM_bot_ConfigMem.Inst_frame0_bit6.Q Tile_X0Y1_N1END[3]
+ Tile_X0Y1_N4END[3] _0074_ Tile_X0Y0_S4END[7] Tile_X0Y1_IHP_SRAM_bot.Inst_IHP_SRAM_bot_ConfigMem.Inst_frame0_bit7.Q
+ Tile_X0Y1_IHP_SRAM_bot.Inst_IHP_SRAM_bot_switch_matrix.J_NS4_BEG15 VPWR VGND sg13g2_mux4_1
XFILLER_85_146 VPWR VGND sg13g2_decap_4
X_0469_ Tile_X0Y0_IHP_SRAM_top.Inst_IHP_SRAM_top_ConfigMem.Inst_frame1_bit18.Q Tile_X0Y0_IHP_SRAM_top.Inst_IHP_SRAM_top_switch_matrix.N1END1
+ Tile_X0Y1_N4END[5] Tile_X0Y0_S1END[1] Tile_X0Y0_S4END[1] Tile_X0Y0_IHP_SRAM_top.Inst_IHP_SRAM_top_ConfigMem.Inst_frame1_bit19.Q
+ Tile_X0Y0_IHP_SRAM_top.Inst_IHP_SRAM_top_switch_matrix.J_NS4_BEG5 VPWR VGND sg13g2_mux4_1
XFILLER_76_102 VPWR VGND sg13g2_fill_1
X_1510_ Tile_X0Y1_FrameStrobe[4] net125 VPWR VGND sg13g2_buf_1
Xoutput208 net208 Tile_X0Y0_WW4BEG[2] VPWR VGND sg13g2_buf_1
Xoutput219 net219 Tile_X0Y1_FrameData_O[12] VPWR VGND sg13g2_buf_1
X_1441_ Tile_X0Y1_FrameData[7] Tile_X0Y1_FrameStrobe[8] Tile_X0Y1_IHP_SRAM_bot.Inst_IHP_SRAM_bot_ConfigMem.Inst_frame8_bit7.Q
+ VPWR VGND sg13g2_dlhq_1
XFILLER_75_190 VPWR VGND sg13g2_fill_1
XFILLER_67_124 VPWR VGND sg13g2_fill_1
X_1372_ Tile_X0Y1_FrameData[12] Tile_X0Y1_FrameStrobe[6] Tile_X0Y1_IHP_SRAM_bot.Inst_IHP_SRAM_bot_ConfigMem.Inst_frame6_bit12.Q
+ VPWR VGND sg13g2_dlhq_1
X_0323_ VPWR _0026_ Tile_X0Y1_IHP_SRAM_bot.Inst_IHP_SRAM_bot_ConfigMem.Inst_frame8_bit12.Q
+ VGND sg13g2_inv_1
XFILLER_90_0 VPWR VGND sg13g2_fill_1
X_1708_ Tile_X0Y1_IHP_SRAM_bot.Inst_IHP_SRAM_bot_switch_matrix.W6BEG9 net315 VPWR
+ VGND sg13g2_buf_1
X_1639_ Tile_X0Y1_FrameData[28] net236 VPWR VGND sg13g2_buf_1
XFILLER_66_190 VPWR VGND sg13g2_fill_2
XFILLER_1_175 VPWR VGND sg13g2_fill_1
X_0941_ Tile_X0Y0_FrameData[17] Tile_X0Y1_FrameStrobe[2] Tile_X0Y0_IHP_SRAM_top.Inst_IHP_SRAM_top_ConfigMem.Inst_frame2_bit17.Q
+ VPWR VGND sg13g2_dlhq_1
XFILLER_57_190 VPWR VGND sg13g2_fill_2
X_0872_ Tile_X0Y0_FrameData[22] Tile_X0Y1_FrameStrobe[0] Tile_X0Y0_IHP_SRAM_top.Inst_IHP_SRAM_top_ConfigMem.Inst_frame0_bit22.Q
+ VPWR VGND sg13g2_dlhq_1
XFILLER_62_4 VPWR VGND sg13g2_fill_2
XFILLER_87_208 VPWR VGND sg13g2_decap_4
X_1355_ Tile_X0Y1_FrameData[29] Tile_X0Y1_FrameStrobe[6] Tile_X0Y1_IHP_SRAM_bot.Inst_IHP_SRAM_bot_ConfigMem.Inst_frame6_bit29.Q
+ VPWR VGND sg13g2_dlhq_1
X_1424_ Tile_X0Y1_FrameData[24] Tile_X0Y1_FrameStrobe[8] Tile_X0Y1_IHP_SRAM_bot.Inst_IHP_SRAM_bot_ConfigMem.Inst_frame8_bit24.Q
+ VPWR VGND sg13g2_dlhq_1
X_1286_ Tile_X0Y1_FrameData[2] Tile_X0Y1_FrameStrobe[3] Tile_X0Y1_IHP_SRAM_bot.Inst_IHP_SRAM_bot_ConfigMem.Inst_frame3_bit2.Q
+ VPWR VGND sg13g2_dlhq_1
X_0306_ VPWR _0009_ Tile_X0Y1_E6END[1] VGND sg13g2_inv_1
XFILLER_55_116 VPWR VGND sg13g2_decap_4
XFILLER_109_129 VPWR VGND sg13g2_decap_8
XFILLER_39_190 VPWR VGND sg13g2_fill_2
XFILLER_34_8 VPWR VGND sg13g2_fill_1
X_1140_ Tile_X0Y0_FrameData[10] Tile_X0Y1_FrameStrobe[8] Tile_X0Y0_IHP_SRAM_top.Inst_IHP_SRAM_top_ConfigMem.Inst_frame8_bit10.Q
+ VPWR VGND sg13g2_dlhq_1
X_1071_ Tile_X0Y0_FrameData[15] Tile_X0Y1_FrameStrobe[6] Tile_X0Y0_IHP_SRAM_top.Inst_IHP_SRAM_top_ConfigMem.Inst_frame6_bit15.Q
+ VPWR VGND sg13g2_dlhq_1
X_0924_ Tile_X0Y0_FrameData[2] Tile_X0Y1_FrameStrobe[1] Tile_X0Y0_IHP_SRAM_top.Inst_IHP_SRAM_top_ConfigMem.Inst_frame1_bit2.Q
+ VPWR VGND sg13g2_dlhq_1
XFILLER_60_141 VPWR VGND sg13g2_decap_8
X_0786_ VGND VPWR _0028_ _0224_ _0226_ _0225_ sg13g2_a21oi_1
X_0855_ Tile_X0Y1_IHP_SRAM_bot.Inst_IHP_SRAM_bot_ConfigMem.Inst_frame1_bit4.Q VPWR
+ _0290_ VGND Tile_X0Y0_S2MID[3] _0283_ sg13g2_o21ai_1
XFILLER_53_0 VPWR VGND sg13g2_fill_1
X_1338_ Tile_X0Y1_FrameData[14] Tile_X0Y1_FrameStrobe[5] Tile_X0Y1_IHP_SRAM_bot.Inst_IHP_SRAM_bot_ConfigMem.Inst_frame5_bit14.Q
+ VPWR VGND sg13g2_dlhq_1
X_1407_ Tile_X0Y1_FrameData[9] Tile_X0Y1_FrameStrobe[7] Tile_X0Y1_IHP_SRAM_bot.Inst_IHP_SRAM_bot_ConfigMem.Inst_frame7_bit9.Q
+ VPWR VGND sg13g2_dlhq_1
X_1269_ Tile_X0Y1_FrameData[19] Tile_X0Y1_FrameStrobe[3] Tile_X0Y1_IHP_SRAM_bot.Inst_IHP_SRAM_bot_ConfigMem.Inst_frame3_bit19.Q
+ VPWR VGND sg13g2_dlhq_1
XFILLER_61_49 VPWR VGND sg13g2_decap_4
XFILLER_105_121 VPWR VGND sg13g2_decap_8
XFILLER_3_215 VPWR VGND sg13g2_fill_1
XFILLER_86_68 VPWR VGND sg13g2_decap_4
XFILLER_19_84 VPWR VGND sg13g2_decap_4
XFILLER_42_130 VPWR VGND sg13g2_fill_1
X_0571_ _0127_ _0129_ Tile_X0Y0_IHP_SRAM_top.Inst_IHP_SRAM_top_switch_matrix.N4BEG3
+ VPWR VGND sg13g2_nor2_1
X_0640_ Tile_X0Y1_IHP_SRAM_bot.Inst_IHP_SRAM_bot_ConfigMem.Inst_frame6_bit24.Q A_DOUT_SRAM7
+ A_DOUT_SRAM15 _0043_ _0084_ Tile_X0Y1_IHP_SRAM_bot.Inst_IHP_SRAM_bot_ConfigMem.Inst_frame6_bit25.Q
+ Tile_X0Y1_IHP_SRAM_bot.Inst_IHP_SRAM_bot_switch_matrix.W2BEGb7 VPWR VGND sg13g2_mux4_1
XFILLER_51_60 VPWR VGND sg13g2_fill_1
XFILLER_111_124 VPWR VGND sg13g2_decap_8
X_1123_ Tile_X0Y0_FrameData[27] Tile_X0Y1_FrameStrobe[8] Tile_X0Y0_IHP_SRAM_top.Inst_IHP_SRAM_top_ConfigMem.Inst_frame8_bit27.Q
+ VPWR VGND sg13g2_dlhq_1
X_1054_ Tile_X0Y0_FrameData[0] Tile_X0Y1_FrameStrobe[5] Tile_X0Y0_IHP_SRAM_top.Inst_IHP_SRAM_top_ConfigMem.Inst_frame5_bit0.Q
+ VPWR VGND sg13g2_dlhq_1
XFILLER_33_141 VPWR VGND sg13g2_decap_4
X_0907_ Tile_X0Y0_FrameData[19] Tile_X0Y1_FrameStrobe[1] Tile_X0Y0_IHP_SRAM_top.Inst_IHP_SRAM_top_ConfigMem.Inst_frame1_bit19.Q
+ VPWR VGND sg13g2_dlhq_1
Xoutput19 net19 A_BM_SRAM16 VPWR VGND sg13g2_buf_1
X_0838_ _0271_ _0272_ Tile_X0Y1_IHP_SRAM_bot.Inst_IHP_SRAM_bot_ConfigMem.Inst_frame2_bit28.Q
+ _0274_ VPWR VGND _0273_ sg13g2_nand4_1
X_0769_ Tile_X0Y1_E1END[3] Tile_X0Y1_EE4END[3] Tile_X0Y1_IHP_SRAM_bot.Inst_IHP_SRAM_bot_ConfigMem.Inst_frame8_bit11.Q
+ _0210_ VPWR VGND sg13g2_mux2_1
XFILLER_102_179 VPWR VGND sg13g2_decap_8
XFILLER_102_146 VPWR VGND sg13g2_decap_8
XFILLER_97_45 VPWR VGND sg13g2_decap_8
XFILLER_46_71 VPWR VGND sg13g2_fill_2
XFILLER_7_21 VPWR VGND sg13g2_fill_2
XFILLER_97_122 VPWR VGND sg13g2_decap_4
X_0554_ Tile_X0Y0_IHP_SRAM_top.Inst_IHP_SRAM_top_ConfigMem.Inst_frame8_bit19.Q _0114_
+ _0115_ VPWR VGND sg13g2_nor2_1
X_0623_ Tile_X0Y1_IHP_SRAM_bot.Inst_IHP_SRAM_bot_ConfigMem.Inst_frame7_bit23.Q Tile_X0Y1_N1END[2]
+ A_DOUT_SRAM0 _0067_ A_DOUT_SRAM5 Tile_X0Y1_IHP_SRAM_bot.Inst_IHP_SRAM_bot_ConfigMem.Inst_frame7_bit22.Q
+ Tile_X0Y1_IHP_SRAM_bot.Inst_IHP_SRAM_bot_switch_matrix.W1BEG2 VPWR VGND sg13g2_mux4_1
X_1672_ Tile_X0Y0_IHP_SRAM_top.Inst_IHP_SRAM_top_switch_matrix.S4BEG1 net283 VPWR
+ VGND sg13g2_buf_1
X_0485_ Tile_X0Y0_IHP_SRAM_top.Inst_IHP_SRAM_top_ConfigMem.Inst_frame4_bit15.Q A_DOUT_SRAM20
+ Tile_X0Y0_IHP_SRAM_top.Inst_IHP_SRAM_top_switch_matrix.J_NS4_BEG11 Tile_X0Y0_IHP_SRAM_top.Inst_IHP_SRAM_top_switch_matrix.J_NS4_BEG7
+ Tile_X0Y0_IHP_SRAM_top.Inst_IHP_SRAM_top_switch_matrix.J_NS2_BEG0 Tile_X0Y0_IHP_SRAM_top.Inst_IHP_SRAM_top_ConfigMem.Inst_frame4_bit14.Q
+ Tile_X0Y0_IHP_SRAM_top.Inst_IHP_SRAM_top_switch_matrix.W6BEG4 VPWR VGND sg13g2_mux4_1
X_1106_ Tile_X0Y0_FrameData[12] Tile_X0Y1_FrameStrobe[7] Tile_X0Y0_IHP_SRAM_top.Inst_IHP_SRAM_top_ConfigMem.Inst_frame7_bit12.Q
+ VPWR VGND sg13g2_dlhq_1
X_1037_ Tile_X0Y0_FrameData[17] Tile_X0Y1_FrameStrobe[5] Tile_X0Y0_IHP_SRAM_top.Inst_IHP_SRAM_top_ConfigMem.Inst_frame5_bit17.Q
+ VPWR VGND sg13g2_dlhq_1
XFILLER_107_88 VPWR VGND sg13g2_decap_8
XFILLER_88_111 VPWR VGND sg13g2_fill_1
XFILLER_12_155 VPWR VGND sg13g2_fill_2
XFILLER_12_133 VPWR VGND sg13g2_decap_4
X_1724_ Tile_X0Y1_IHP_SRAM_bot.Inst_IHP_SRAM_bot_switch_matrix.WW4BEG13 net320 VPWR
+ VGND sg13g2_buf_1
XFILLER_104_208 VPWR VGND sg13g2_decap_4
X_1586_ Tile_X0Y0_IHP_SRAM_top.Inst_IHP_SRAM_top_switch_matrix.W6BEG3 net193 VPWR
+ VGND sg13g2_buf_1
X_0537_ Tile_X0Y0_E2MID[4] Tile_X0Y0_IHP_SRAM_top.Inst_IHP_SRAM_top_ConfigMem.Inst_frame1_bit6.Q
+ Tile_X0Y0_IHP_SRAM_top.Inst_IHP_SRAM_top_ConfigMem.Inst_frame1_bit7.Q _0100_ VPWR
+ VGND sg13g2_nor3_1
X_1655_ Tile_X0Y0_IHP_SRAM_top.Inst_IHP_SRAM_top_switch_matrix.S2BEG0 net260 VPWR
+ VGND sg13g2_buf_1
X_0606_ Tile_X0Y1_IHP_SRAM_bot.Inst_IHP_SRAM_bot_ConfigMem.Inst_frame0_bit4.Q Tile_X0Y1_N1END[2]
+ Tile_X0Y1_N4END[2] _0067_ Tile_X0Y0_S4END[6] Tile_X0Y1_IHP_SRAM_bot.Inst_IHP_SRAM_bot_ConfigMem.Inst_frame0_bit5.Q
+ Tile_X0Y1_IHP_SRAM_bot.Inst_IHP_SRAM_bot_switch_matrix.J_NS4_BEG14 VPWR VGND sg13g2_mux4_1
X_0399_ Tile_X0Y0_IHP_SRAM_top.Inst_IHP_SRAM_top_ConfigMem.Inst_frame7_bit8.Q Tile_X0Y0_E2MID[4]
+ Tile_X0Y0_E2END[4] Tile_X0Y0_E6END[11] Tile_X0Y0_IHP_SRAM_top.Inst_IHP_SRAM_top_switch_matrix.J_NS2_BEG3
+ Tile_X0Y0_IHP_SRAM_top.Inst_IHP_SRAM_top_ConfigMem.Inst_frame7_bit9.Q Tile_X0Y0_IHP_SRAM_top.Inst_IHP_SRAM_top_switch_matrix.S2BEG3
+ VPWR VGND sg13g2_mux4_1
X_0468_ Tile_X0Y0_IHP_SRAM_top.Inst_IHP_SRAM_top_ConfigMem.Inst_frame5_bit24.Q A_DOUT_SRAM21
+ A_DOUT_SRAM25 Tile_X0Y0_IHP_SRAM_top.Inst_IHP_SRAM_top_switch_matrix.J_NS4_BEG6
+ Tile_X0Y0_IHP_SRAM_top.Inst_IHP_SRAM_top_switch_matrix.J_NS2_BEG6 Tile_X0Y0_IHP_SRAM_top.Inst_IHP_SRAM_top_ConfigMem.Inst_frame5_bit25.Q
+ Tile_X0Y0_IHP_SRAM_top.Inst_IHP_SRAM_top_switch_matrix.WW4BEG9 VPWR VGND sg13g2_mux4_1
XFILLER_76_158 VPWR VGND sg13g2_fill_1
Xoutput209 net209 Tile_X0Y0_WW4BEG[3] VPWR VGND sg13g2_buf_1
XFILLER_4_195 VPWR VGND sg13g2_decap_8
X_1371_ Tile_X0Y1_FrameData[13] Tile_X0Y1_FrameStrobe[6] Tile_X0Y1_IHP_SRAM_bot.Inst_IHP_SRAM_bot_ConfigMem.Inst_frame6_bit13.Q
+ VPWR VGND sg13g2_dlhq_1
X_1440_ Tile_X0Y1_FrameData[8] Tile_X0Y1_FrameStrobe[8] Tile_X0Y1_IHP_SRAM_bot.Inst_IHP_SRAM_bot_ConfigMem.Inst_frame8_bit8.Q
+ VPWR VGND sg13g2_dlhq_1
X_0322_ VPWR _0025_ Tile_X0Y1_IHP_SRAM_bot.Inst_IHP_SRAM_bot_ConfigMem.Inst_frame8_bit11.Q
+ VGND sg13g2_inv_1
X_1707_ Tile_X0Y1_IHP_SRAM_bot.Inst_IHP_SRAM_bot_switch_matrix.W6BEG8 net314 VPWR
+ VGND sg13g2_buf_1
X_1638_ Tile_X0Y1_FrameData[27] net235 VPWR VGND sg13g2_buf_1
X_1569_ Tile_X0Y0_IHP_SRAM_top.Inst_IHP_SRAM_top_switch_matrix.W2BEG2 net174 VPWR
+ VGND sg13g2_buf_1
XFILLER_58_136 VPWR VGND sg13g2_decap_8
XFILLER_104_67 VPWR VGND sg13g2_decap_8
XFILLER_81_183 VPWR VGND sg13g2_fill_2
XFILLER_13_20 VPWR VGND sg13g2_fill_1
XFILLER_96_209 VPWR VGND sg13g2_fill_2
XFILLER_89_35 VPWR VGND sg13g2_decap_4
XFILLER_38_72 VPWR VGND sg13g2_fill_1
X_0940_ Tile_X0Y0_FrameData[18] Tile_X0Y1_FrameStrobe[2] Tile_X0Y0_IHP_SRAM_top.Inst_IHP_SRAM_top_ConfigMem.Inst_frame2_bit18.Q
+ VPWR VGND sg13g2_dlhq_1
XFILLER_72_172 VPWR VGND sg13g2_fill_1
X_0871_ Tile_X0Y0_FrameData[23] Tile_X0Y1_FrameStrobe[0] Tile_X0Y0_IHP_SRAM_top.Inst_IHP_SRAM_top_ConfigMem.Inst_frame0_bit23.Q
+ VPWR VGND sg13g2_dlhq_1
X_1354_ Tile_X0Y1_FrameData[30] Tile_X0Y1_FrameStrobe[6] Tile_X0Y1_IHP_SRAM_bot.Inst_IHP_SRAM_bot_ConfigMem.Inst_frame6_bit30.Q
+ VPWR VGND sg13g2_dlhq_1
X_0305_ VPWR _0008_ Tile_X0Y1_E6END[2] VGND sg13g2_inv_1
X_1423_ Tile_X0Y1_FrameData[25] Tile_X0Y1_FrameStrobe[8] Tile_X0Y1_IHP_SRAM_bot.Inst_IHP_SRAM_bot_ConfigMem.Inst_frame8_bit25.Q
+ VPWR VGND sg13g2_dlhq_1
X_1285_ Tile_X0Y1_FrameData[3] Tile_X0Y1_FrameStrobe[3] Tile_X0Y1_IHP_SRAM_bot.Inst_IHP_SRAM_bot_ConfigMem.Inst_frame3_bit3.Q
+ VPWR VGND sg13g2_dlhq_1
XFILLER_63_161 VPWR VGND sg13g2_fill_1
XFILLER_55_128 VPWR VGND sg13g2_fill_1
XFILLER_109_108 VPWR VGND sg13g2_decap_8
XFILLER_50_18 VPWR VGND sg13g2_fill_1
XFILLER_61_109 VPWR VGND sg13g2_decap_8
XFILLER_54_150 VPWR VGND sg13g2_fill_1
XFILLER_108_163 VPWR VGND sg13g2_decap_8
XFILLER_65_81 VPWR VGND sg13g2_fill_2
X_1070_ Tile_X0Y0_FrameData[16] Tile_X0Y1_FrameStrobe[6] Tile_X0Y0_IHP_SRAM_top.Inst_IHP_SRAM_top_ConfigMem.Inst_frame6_bit16.Q
+ VPWR VGND sg13g2_dlhq_1
XFILLER_45_183 VPWR VGND sg13g2_fill_1
X_0923_ Tile_X0Y0_FrameData[3] Tile_X0Y1_FrameStrobe[1] Tile_X0Y0_IHP_SRAM_top.Inst_IHP_SRAM_top_ConfigMem.Inst_frame1_bit3.Q
+ VPWR VGND sg13g2_dlhq_1
X_0854_ Tile_X0Y1_E2END[4] Tile_X0Y1_IHP_SRAM_bot.Inst_IHP_SRAM_bot_ConfigMem.Inst_frame1_bit5.Q
+ Tile_X0Y1_IHP_SRAM_bot.Inst_IHP_SRAM_bot_ConfigMem.Inst_frame1_bit6.Q _0289_ VPWR
+ VGND sg13g2_nor3_1
X_0785_ Tile_X0Y1_IHP_SRAM_bot.Inst_IHP_SRAM_bot_ConfigMem.Inst_frame7_bit8.Q VPWR
+ _0225_ VGND _0222_ _0223_ sg13g2_o21ai_1
XFILLER_46_0 VPWR VGND sg13g2_decap_8
X_1337_ Tile_X0Y1_FrameData[15] Tile_X0Y1_FrameStrobe[5] Tile_X0Y1_IHP_SRAM_bot.Inst_IHP_SRAM_bot_ConfigMem.Inst_frame5_bit15.Q
+ VPWR VGND sg13g2_dlhq_1
X_1268_ Tile_X0Y1_FrameData[20] Tile_X0Y1_FrameStrobe[3] Tile_X0Y1_IHP_SRAM_bot.Inst_IHP_SRAM_bot_ConfigMem.Inst_frame3_bit20.Q
+ VPWR VGND sg13g2_dlhq_1
X_1406_ Tile_X0Y1_FrameData[10] Tile_X0Y1_FrameStrobe[7] Tile_X0Y1_IHP_SRAM_bot.Inst_IHP_SRAM_bot_ConfigMem.Inst_frame7_bit10.Q
+ VPWR VGND sg13g2_dlhq_1
XFILLER_45_18 VPWR VGND sg13g2_decap_8
XFILLER_45_29 VPWR VGND sg13g2_fill_2
X_1199_ Tile_X0Y1_FrameData[25] Tile_X0Y1_FrameStrobe[1] Tile_X0Y1_IHP_SRAM_bot.Inst_IHP_SRAM_bot_ConfigMem.Inst_frame1_bit25.Q
+ VPWR VGND sg13g2_dlhq_1
XFILLER_51_142 VPWR VGND sg13g2_decap_4
XFILLER_105_155 VPWR VGND sg13g2_fill_2
XFILLER_10_98 VPWR VGND sg13g2_fill_1
XFILLER_42_153 VPWR VGND sg13g2_decap_4
XFILLER_111_103 VPWR VGND sg13g2_decap_8
X_0570_ Tile_X0Y0_IHP_SRAM_top.Inst_IHP_SRAM_top_ConfigMem.Inst_frame8_bit25.Q _0128_
+ _0129_ VPWR VGND sg13g2_nor2_1
X_1122_ Tile_X0Y0_FrameData[28] Tile_X0Y1_FrameStrobe[8] Tile_X0Y0_IHP_SRAM_top.Inst_IHP_SRAM_top_ConfigMem.Inst_frame8_bit28.Q
+ VPWR VGND sg13g2_dlhq_1
X_1053_ Tile_X0Y0_FrameData[1] Tile_X0Y1_FrameStrobe[5] Tile_X0Y0_IHP_SRAM_top.Inst_IHP_SRAM_top_ConfigMem.Inst_frame5_bit1.Q
+ VPWR VGND sg13g2_dlhq_1
X_0906_ Tile_X0Y0_FrameData[20] Tile_X0Y1_FrameStrobe[1] Tile_X0Y0_IHP_SRAM_top.Inst_IHP_SRAM_top_ConfigMem.Inst_frame1_bit20.Q
+ VPWR VGND sg13g2_dlhq_1
X_0837_ VGND VPWR _0273_ _0258_ Tile_X0Y0_S2MID[3] sg13g2_or2_1
X_0699_ VGND VPWR Tile_X0Y1_E2END[4] Tile_X0Y1_IHP_SRAM_bot.Inst_IHP_SRAM_bot_ConfigMem.Inst_frame4_bit26.Q
+ _0176_ _0175_ sg13g2_a21oi_1
X_0768_ _0208_ VPWR _0209_ VGND _0025_ _0158_ sg13g2_o21ai_1
XFILLER_71_215 VPWR VGND sg13g2_fill_1
XANTENNA_60 VPWR VGND net164 sg13g2_antennanp
XFILLER_62_215 VPWR VGND sg13g2_fill_1
XFILLER_15_120 VPWR VGND sg13g2_decap_4
XFILLER_15_142 VPWR VGND sg13g2_fill_2
X_1671_ Tile_X0Y0_IHP_SRAM_top.Inst_IHP_SRAM_top_switch_matrix.S4BEG0 net282 VPWR
+ VGND sg13g2_buf_1
X_0484_ Tile_X0Y0_IHP_SRAM_top.Inst_IHP_SRAM_top_ConfigMem.Inst_frame4_bit12.Q Tile_X0Y1_N4END[7]
+ Tile_X0Y0_S4END[3] Tile_X0Y0_IHP_SRAM_top.Inst_IHP_SRAM_top_switch_matrix.J_NS4_BEG8
+ Tile_X0Y0_IHP_SRAM_top.Inst_IHP_SRAM_top_switch_matrix.J_NS4_BEG12 Tile_X0Y0_IHP_SRAM_top.Inst_IHP_SRAM_top_ConfigMem.Inst_frame4_bit13.Q
+ Tile_X0Y0_IHP_SRAM_top.Inst_IHP_SRAM_top_switch_matrix.W6BEG3 VPWR VGND sg13g2_mux4_1
X_0553_ Tile_X0Y0_IHP_SRAM_top.Inst_IHP_SRAM_top_ConfigMem.Inst_frame8_bit18.Q Tile_X0Y0_E1END[1]
+ Tile_X0Y0_E6END[9] Tile_X0Y0_EE4END[1] Tile_X0Y0_IHP_SRAM_top.Inst_IHP_SRAM_top_switch_matrix.J_NS4_BEG1
+ Tile_X0Y0_IHP_SRAM_top.Inst_IHP_SRAM_top_ConfigMem.Inst_frame8_bit17.Q _0114_ VPWR
+ VGND sg13g2_mux4_1
X_0622_ Tile_X0Y1_IHP_SRAM_bot.Inst_IHP_SRAM_bot_ConfigMem.Inst_frame7_bit21.Q Tile_X0Y1_N1END[1]
+ A_DOUT_SRAM3 _0060_ A_DOUT_SRAM6 Tile_X0Y1_IHP_SRAM_bot.Inst_IHP_SRAM_bot_ConfigMem.Inst_frame7_bit20.Q
+ Tile_X0Y1_IHP_SRAM_bot.Inst_IHP_SRAM_bot_switch_matrix.W1BEG1 VPWR VGND sg13g2_mux4_1
X_1105_ Tile_X0Y0_FrameData[13] Tile_X0Y1_FrameStrobe[7] Tile_X0Y0_IHP_SRAM_top.Inst_IHP_SRAM_top_ConfigMem.Inst_frame7_bit13.Q
+ VPWR VGND sg13g2_dlhq_1
X_1036_ Tile_X0Y0_FrameData[18] Tile_X0Y1_FrameStrobe[5] Tile_X0Y0_IHP_SRAM_top.Inst_IHP_SRAM_top_ConfigMem.Inst_frame5_bit18.Q
+ VPWR VGND sg13g2_dlhq_1
XFILLER_107_67 VPWR VGND sg13g2_decap_8
XFILLER_88_167 VPWR VGND sg13g2_decap_8
XFILLER_67_16 VPWR VGND sg13g2_fill_2
XFILLER_12_101 VPWR VGND sg13g2_fill_1
XFILLER_44_215 VPWR VGND sg13g2_fill_1
X_1723_ Tile_X0Y1_IHP_SRAM_bot.Inst_IHP_SRAM_bot_switch_matrix.WW4BEG12 net319 VPWR
+ VGND sg13g2_buf_1
X_1654_ Tile_X0Y1_IHP_SRAM_bot.Inst_IHP_SRAM_bot_switch_matrix.S2BEG7 net259 VPWR
+ VGND sg13g2_buf_1
X_0536_ VPWR VGND Tile_X0Y0_IHP_SRAM_top.Inst_IHP_SRAM_top_ConfigMem.Inst_frame1_bit4.Q
+ _0098_ _0099_ Tile_X0Y0_IHP_SRAM_top.Inst_IHP_SRAM_top_ConfigMem.Inst_frame1_bit5.Q
+ net9 _0041_ sg13g2_a221oi_1
X_0467_ Tile_X0Y0_IHP_SRAM_top.Inst_IHP_SRAM_top_ConfigMem.Inst_frame1_bit20.Q Tile_X0Y0_IHP_SRAM_top.Inst_IHP_SRAM_top_switch_matrix.N1END2
+ Tile_X0Y1_N4END[6] Tile_X0Y0_S1END[2] Tile_X0Y0_S4END[2] Tile_X0Y0_IHP_SRAM_top.Inst_IHP_SRAM_top_ConfigMem.Inst_frame1_bit21.Q
+ Tile_X0Y0_IHP_SRAM_top.Inst_IHP_SRAM_top_switch_matrix.J_NS4_BEG6 VPWR VGND sg13g2_mux4_1
X_1585_ Tile_X0Y0_IHP_SRAM_top.Inst_IHP_SRAM_top_switch_matrix.W6BEG2 net192 VPWR
+ VGND sg13g2_buf_1
X_0605_ Tile_X0Y1_IHP_SRAM_bot.Inst_IHP_SRAM_bot_ConfigMem.Inst_frame0_bit2.Q Tile_X0Y1_N1END[1]
+ Tile_X0Y1_N4END[1] _0060_ Tile_X0Y0_S4END[5] Tile_X0Y1_IHP_SRAM_bot.Inst_IHP_SRAM_bot_ConfigMem.Inst_frame0_bit3.Q
+ Tile_X0Y1_IHP_SRAM_bot.Inst_IHP_SRAM_bot_switch_matrix.J_NS4_BEG13 VPWR VGND sg13g2_mux4_1
X_0398_ Tile_X0Y0_IHP_SRAM_top.Inst_IHP_SRAM_top_ConfigMem.Inst_frame8_bit2.Q Tile_X0Y0_E2MID[5]
+ Tile_X0Y0_E2END[5] Tile_X0Y0_E6END[5] Tile_X0Y0_IHP_SRAM_top.Inst_IHP_SRAM_top_switch_matrix.J_NS2_BEG2
+ Tile_X0Y0_IHP_SRAM_top.Inst_IHP_SRAM_top_ConfigMem.Inst_frame8_bit3.Q Tile_X0Y0_IHP_SRAM_top.Inst_IHP_SRAM_top_switch_matrix.N2BEG2
+ VPWR VGND sg13g2_mux4_1
X_1019_ Tile_X0Y0_FrameData[3] Tile_X0Y1_FrameStrobe[4] Tile_X0Y0_IHP_SRAM_top.Inst_IHP_SRAM_top_ConfigMem.Inst_frame4_bit3.Q
+ VPWR VGND sg13g2_dlhq_1
XFILLER_94_47 VPWR VGND sg13g2_decap_8
X_1370_ Tile_X0Y1_FrameData[14] Tile_X0Y1_FrameStrobe[6] Tile_X0Y1_IHP_SRAM_bot.Inst_IHP_SRAM_bot_ConfigMem.Inst_frame6_bit14.Q
+ VPWR VGND sg13g2_dlhq_1
XFILLER_4_23 VPWR VGND sg13g2_fill_2
X_0321_ VPWR _0024_ Tile_X0Y1_IHP_SRAM_bot.Inst_IHP_SRAM_bot_ConfigMem.Inst_frame8_bit9.Q
+ VGND sg13g2_inv_1
XFILLER_90_184 VPWR VGND sg13g2_fill_2
XFILLER_76_0 VPWR VGND sg13g2_fill_1
X_1706_ Tile_X0Y1_IHP_SRAM_bot.Inst_IHP_SRAM_bot_switch_matrix.W6BEG7 net313 VPWR
+ VGND sg13g2_buf_1
X_1637_ Tile_X0Y1_FrameData[26] net234 VPWR VGND sg13g2_buf_1
X_1499_ Tile_X0Y0_FrameData[25] net96 VPWR VGND sg13g2_buf_1
XFILLER_73_129 VPWR VGND sg13g2_fill_2
X_0519_ Tile_X0Y0_IHP_SRAM_top.Inst_IHP_SRAM_top_ConfigMem.Inst_frame2_bit18.Q Tile_X0Y0_EE4END[2]
+ Tile_X0Y0_EE4END[10] Tile_X0Y0_E6END[10] Tile_X0Y0_IHP_SRAM_top.Inst_IHP_SRAM_top_switch_matrix.J_NS4_BEG10
+ Tile_X0Y0_IHP_SRAM_top.Inst_IHP_SRAM_top_ConfigMem.Inst_frame2_bit19.Q net30 VPWR
+ VGND sg13g2_mux4_1
X_1568_ Tile_X0Y0_IHP_SRAM_top.Inst_IHP_SRAM_top_switch_matrix.W2BEG1 net173 VPWR
+ VGND sg13g2_buf_1
XFILLER_66_192 VPWR VGND sg13g2_fill_1
XFILLER_1_122 VPWR VGND sg13g2_fill_2
XFILLER_1_199 VPWR VGND sg13g2_decap_8
XFILLER_72_151 VPWR VGND sg13g2_fill_2
XFILLER_54_50 VPWR VGND sg13g2_fill_2
X_0870_ Tile_X0Y0_FrameData[24] Tile_X0Y1_FrameStrobe[0] Tile_X0Y0_IHP_SRAM_top.Inst_IHP_SRAM_top_ConfigMem.Inst_frame0_bit24.Q
+ VPWR VGND sg13g2_dlhq_1
XFILLER_62_6 VPWR VGND sg13g2_fill_1
X_1422_ Tile_X0Y1_FrameData[26] Tile_X0Y1_FrameStrobe[8] Tile_X0Y1_IHP_SRAM_bot.Inst_IHP_SRAM_bot_ConfigMem.Inst_frame8_bit26.Q
+ VPWR VGND sg13g2_dlhq_1
X_1353_ Tile_X0Y1_FrameData[31] Tile_X0Y1_FrameStrobe[6] Tile_X0Y1_IHP_SRAM_bot.Inst_IHP_SRAM_bot_ConfigMem.Inst_frame6_bit31.Q
+ VPWR VGND sg13g2_dlhq_1
X_1284_ Tile_X0Y1_FrameData[4] Tile_X0Y1_FrameStrobe[3] Tile_X0Y1_IHP_SRAM_bot.Inst_IHP_SRAM_bot_ConfigMem.Inst_frame3_bit4.Q
+ VPWR VGND sg13g2_dlhq_1
X_0304_ VPWR _0007_ Tile_X0Y1_E6END[3] VGND sg13g2_inv_1
X_0999_ Tile_X0Y0_FrameData[23] Tile_X0Y1_FrameStrobe[4] Tile_X0Y0_IHP_SRAM_top.Inst_IHP_SRAM_top_ConfigMem.Inst_frame4_bit23.Q
+ VPWR VGND sg13g2_dlhq_1
XFILLER_39_192 VPWR VGND sg13g2_fill_1
XFILLER_108_142 VPWR VGND sg13g2_decap_8
XFILLER_45_140 VPWR VGND sg13g2_fill_2
X_0922_ Tile_X0Y0_FrameData[4] Tile_X0Y1_FrameStrobe[1] Tile_X0Y0_IHP_SRAM_top.Inst_IHP_SRAM_top_ConfigMem.Inst_frame1_bit4.Q
+ VPWR VGND sg13g2_dlhq_1
X_0853_ _0037_ Tile_X0Y1_IHP_SRAM_bot.Inst_IHP_SRAM_bot_ConfigMem.Inst_frame1_bit6.Q
+ Tile_X0Y0_IHP_SRAM_top.Inst_IHP_SRAM_top_switch_matrix.S2BEG0 _0288_ VPWR VGND sg13g2_nor3_1
X_0784_ Tile_X0Y1_IHP_SRAM_bot.Inst_IHP_SRAM_bot_switch_matrix.J_NS4_BEG4 Tile_X0Y1_IHP_SRAM_bot.Inst_IHP_SRAM_bot_switch_matrix.J_NS4_BEG8
+ Tile_X0Y1_IHP_SRAM_bot.Inst_IHP_SRAM_bot_ConfigMem.Inst_frame7_bit6.Q _0224_ VPWR
+ VGND sg13g2_mux2_1
X_1405_ Tile_X0Y1_FrameData[11] Tile_X0Y1_FrameStrobe[7] Tile_X0Y1_IHP_SRAM_bot.Inst_IHP_SRAM_bot_ConfigMem.Inst_frame7_bit11.Q
+ VPWR VGND sg13g2_dlhq_1
XFILLER_39_0 VPWR VGND sg13g2_fill_1
X_1336_ Tile_X0Y1_FrameData[16] Tile_X0Y1_FrameStrobe[5] Tile_X0Y1_IHP_SRAM_bot.Inst_IHP_SRAM_bot_ConfigMem.Inst_frame5_bit16.Q
+ VPWR VGND sg13g2_dlhq_1
X_1267_ Tile_X0Y1_FrameData[21] Tile_X0Y1_FrameStrobe[3] Tile_X0Y1_IHP_SRAM_bot.Inst_IHP_SRAM_bot_ConfigMem.Inst_frame3_bit21.Q
+ VPWR VGND sg13g2_dlhq_1
XFILLER_28_129 VPWR VGND sg13g2_fill_1
X_1198_ Tile_X0Y1_FrameData[26] Tile_X0Y1_FrameStrobe[1] Tile_X0Y1_IHP_SRAM_bot.Inst_IHP_SRAM_bot_ConfigMem.Inst_frame1_bit26.Q
+ VPWR VGND sg13g2_dlhq_1
XFILLER_105_101 VPWR VGND sg13g2_fill_2
XFILLER_10_22 VPWR VGND sg13g2_fill_1
XFILLER_105_189 VPWR VGND sg13g2_decap_8
XFILLER_27_151 VPWR VGND sg13g2_fill_1
X_1121_ Tile_X0Y0_FrameData[29] Tile_X0Y1_FrameStrobe[8] Tile_X0Y0_IHP_SRAM_top.Inst_IHP_SRAM_top_ConfigMem.Inst_frame8_bit29.Q
+ VPWR VGND sg13g2_dlhq_1
X_1052_ Tile_X0Y0_FrameData[2] Tile_X0Y1_FrameStrobe[5] Tile_X0Y0_IHP_SRAM_top.Inst_IHP_SRAM_top_ConfigMem.Inst_frame5_bit2.Q
+ VPWR VGND sg13g2_dlhq_1
XFILLER_33_121 VPWR VGND sg13g2_fill_2
X_0905_ Tile_X0Y0_FrameData[21] Tile_X0Y1_FrameStrobe[1] Tile_X0Y0_IHP_SRAM_top.Inst_IHP_SRAM_top_ConfigMem.Inst_frame1_bit21.Q
+ VPWR VGND sg13g2_dlhq_1
X_0836_ Tile_X0Y1_E2END[4] Tile_X0Y1_IHP_SRAM_bot.Inst_IHP_SRAM_bot_ConfigMem.Inst_frame2_bit29.Q
+ Tile_X0Y1_IHP_SRAM_bot.Inst_IHP_SRAM_bot_ConfigMem.Inst_frame2_bit30.Q _0272_ VPWR
+ VGND sg13g2_or3_1
X_0767_ VPWR _0208_ _0207_ VGND sg13g2_inv_1
XFILLER_56_213 VPWR VGND sg13g2_fill_2
X_0698_ Tile_X0Y1_IHP_SRAM_bot.Inst_IHP_SRAM_bot_ConfigMem.Inst_frame4_bit26.Q Tile_X0Y1_E2MID[4]
+ _0175_ VPWR VGND sg13g2_nor2b_1
X_1319_ Tile_X0Y1_FrameData[1] Tile_X0Y1_FrameStrobe[4] Tile_X0Y1_IHP_SRAM_bot.Inst_IHP_SRAM_bot_ConfigMem.Inst_frame4_bit1.Q
+ VPWR VGND sg13g2_dlhq_1
XFILLER_24_132 VPWR VGND sg13g2_fill_2
XANTENNA_61 VPWR VGND Tile_X0Y1_FrameStrobe[13] sg13g2_antennanp
XFILLER_24_187 VPWR VGND sg13g2_fill_2
XANTENNA_50 VPWR VGND Tile_X0Y1_N2MID[2] sg13g2_antennanp
XFILLER_97_69 VPWR VGND sg13g2_decap_4
Xoutput190 net190 Tile_X0Y0_W6BEG[11] VPWR VGND sg13g2_buf_1
XFILLER_46_84 VPWR VGND sg13g2_fill_1
X_1670_ Tile_X0Y0_S4END[15] net281 VPWR VGND sg13g2_buf_1
XFILLER_7_23 VPWR VGND sg13g2_fill_1
X_0621_ Tile_X0Y1_IHP_SRAM_bot.Inst_IHP_SRAM_bot_ConfigMem.Inst_frame7_bit19.Q Tile_X0Y1_N1END[0]
+ A_DOUT_SRAM2 _0088_ A_DOUT_SRAM7 Tile_X0Y1_IHP_SRAM_bot.Inst_IHP_SRAM_bot_ConfigMem.Inst_frame7_bit18.Q
+ Tile_X0Y1_IHP_SRAM_bot.Inst_IHP_SRAM_bot_switch_matrix.W1BEG0 VPWR VGND sg13g2_mux4_1
X_0483_ Tile_X0Y0_IHP_SRAM_top.Inst_IHP_SRAM_top_ConfigMem.Inst_frame4_bit10.Q Tile_X0Y1_N4END[6]
+ Tile_X0Y0_S4END[2] Tile_X0Y0_IHP_SRAM_top.Inst_IHP_SRAM_top_switch_matrix.J_NS4_BEG9
+ Tile_X0Y0_IHP_SRAM_top.Inst_IHP_SRAM_top_switch_matrix.J_NS4_BEG13 Tile_X0Y0_IHP_SRAM_top.Inst_IHP_SRAM_top_ConfigMem.Inst_frame4_bit11.Q
+ Tile_X0Y0_IHP_SRAM_top.Inst_IHP_SRAM_top_switch_matrix.W6BEG2 VPWR VGND sg13g2_mux4_1
X_0552_ VGND VPWR _0012_ _0109_ _0113_ _0112_ sg13g2_a21oi_1
X_1104_ Tile_X0Y0_FrameData[14] Tile_X0Y1_FrameStrobe[7] Tile_X0Y0_IHP_SRAM_top.Inst_IHP_SRAM_top_ConfigMem.Inst_frame7_bit14.Q
+ VPWR VGND sg13g2_dlhq_1
X_1035_ Tile_X0Y0_FrameData[19] Tile_X0Y1_FrameStrobe[5] Tile_X0Y0_IHP_SRAM_top.Inst_IHP_SRAM_top_ConfigMem.Inst_frame5_bit19.Q
+ VPWR VGND sg13g2_dlhq_1
XFILLER_21_113 VPWR VGND sg13g2_fill_1
XFILLER_107_46 VPWR VGND sg13g2_decap_8
X_0819_ VGND VPWR _0034_ _0254_ _0256_ _0255_ sg13g2_a21oi_1
XFILLER_16_98 VPWR VGND sg13g2_decap_8
XFILLER_32_86 VPWR VGND sg13g2_decap_8
XFILLER_106_0 VPWR VGND sg13g2_decap_4
X_1584_ Tile_X0Y0_IHP_SRAM_top.Inst_IHP_SRAM_top_switch_matrix.W6BEG1 net191 VPWR
+ VGND sg13g2_buf_1
X_1722_ Tile_X0Y1_IHP_SRAM_bot.Inst_IHP_SRAM_bot_switch_matrix.WW4BEG11 net318 VPWR
+ VGND sg13g2_buf_1
X_0604_ Tile_X0Y1_IHP_SRAM_bot.Inst_IHP_SRAM_bot_ConfigMem.Inst_frame0_bit0.Q Tile_X0Y1_N1END[0]
+ Tile_X0Y1_N4END[0] _0088_ Tile_X0Y0_S4END[4] Tile_X0Y1_IHP_SRAM_bot.Inst_IHP_SRAM_bot_ConfigMem.Inst_frame0_bit1.Q
+ Tile_X0Y1_IHP_SRAM_bot.Inst_IHP_SRAM_bot_switch_matrix.J_NS4_BEG12 VPWR VGND sg13g2_mux4_1
X_1653_ Tile_X0Y1_IHP_SRAM_bot.Inst_IHP_SRAM_bot_switch_matrix.S2BEG6 net258 VPWR
+ VGND sg13g2_buf_1
X_0397_ Tile_X0Y0_IHP_SRAM_top.Inst_IHP_SRAM_top_ConfigMem.Inst_frame0_bit12.Q Tile_X0Y0_IHP_SRAM_top.Inst_IHP_SRAM_top_switch_matrix.N2BEGb2
+ Tile_X0Y1_N2MID[2] Tile_X0Y0_S2MID[2] Tile_X0Y0_S2END[2] Tile_X0Y0_IHP_SRAM_top.Inst_IHP_SRAM_top_ConfigMem.Inst_frame0_bit13.Q
+ Tile_X0Y0_IHP_SRAM_top.Inst_IHP_SRAM_top_switch_matrix.J_NS2_BEG2 VPWR VGND sg13g2_mux4_1
X_0535_ _0099_ Tile_X0Y0_E2END[3] Tile_X0Y0_IHP_SRAM_top.Inst_IHP_SRAM_top_ConfigMem.Inst_frame1_bit5.Q
+ VPWR VGND sg13g2_nand2b_1
XFILLER_85_127 VPWR VGND sg13g2_fill_2
X_0466_ Tile_X0Y0_IHP_SRAM_top.Inst_IHP_SRAM_top_ConfigMem.Inst_frame5_bit22.Q A_DOUT_SRAM20
+ A_DOUT_SRAM24 Tile_X0Y0_IHP_SRAM_top.Inst_IHP_SRAM_top_switch_matrix.J_NS4_BEG7
+ Tile_X0Y0_IHP_SRAM_top.Inst_IHP_SRAM_top_switch_matrix.J_NS2_BEG7 Tile_X0Y0_IHP_SRAM_top.Inst_IHP_SRAM_top_ConfigMem.Inst_frame5_bit23.Q
+ Tile_X0Y0_IHP_SRAM_top.Inst_IHP_SRAM_top_switch_matrix.WW4BEG8 VPWR VGND sg13g2_mux4_1
XFILLER_21_0 VPWR VGND sg13g2_fill_1
X_1018_ Tile_X0Y0_FrameData[4] Tile_X0Y1_FrameStrobe[4] Tile_X0Y0_IHP_SRAM_top.Inst_IHP_SRAM_top_ConfigMem.Inst_frame4_bit4.Q
+ VPWR VGND sg13g2_dlhq_1
XFILLER_76_149 VPWR VGND sg13g2_decap_8
XFILLER_76_127 VPWR VGND sg13g2_fill_1
XFILLER_4_46 VPWR VGND sg13g2_fill_1
X_0320_ VPWR _0023_ Tile_X0Y1_IHP_SRAM_bot.Inst_IHP_SRAM_bot_ConfigMem.Inst_frame8_bit8.Q
+ VGND sg13g2_inv_1
XFILLER_90_130 VPWR VGND sg13g2_decap_8
XFILLER_69_0 VPWR VGND sg13g2_fill_2
X_1705_ Tile_X0Y1_IHP_SRAM_bot.Inst_IHP_SRAM_bot_switch_matrix.W6BEG6 net312 VPWR
+ VGND sg13g2_buf_1
X_0518_ Tile_X0Y0_IHP_SRAM_top.Inst_IHP_SRAM_top_ConfigMem.Inst_frame2_bit16.Q Tile_X0Y0_EE4END[1]
+ Tile_X0Y0_EE4END[9] Tile_X0Y0_E6END[9] Tile_X0Y0_IHP_SRAM_top.Inst_IHP_SRAM_top_switch_matrix.J_NS4_BEG9
+ Tile_X0Y0_IHP_SRAM_top.Inst_IHP_SRAM_top_ConfigMem.Inst_frame2_bit17.Q net29 VPWR
+ VGND sg13g2_mux4_1
X_1636_ Tile_X0Y1_FrameData[25] net233 VPWR VGND sg13g2_buf_1
X_1567_ Tile_X0Y0_IHP_SRAM_top.Inst_IHP_SRAM_top_switch_matrix.W2BEG0 net172 VPWR
+ VGND sg13g2_buf_1
XFILLER_48_19 VPWR VGND sg13g2_fill_1
XFILLER_104_25 VPWR VGND sg13g2_decap_8
X_1498_ Tile_X0Y0_FrameData[24] net95 VPWR VGND sg13g2_buf_1
X_0449_ Tile_X0Y0_IHP_SRAM_top.Inst_IHP_SRAM_top_ConfigMem.Inst_frame5_bit0.Q A_DOUT_SRAM21
+ A_DOUT_SRAM29 Tile_X0Y0_IHP_SRAM_top.Inst_IHP_SRAM_top_switch_matrix.J_NS2_BEG2
+ Tile_X0Y0_IHP_SRAM_top.Inst_IHP_SRAM_top_switch_matrix.J_NS2_BEG5 Tile_X0Y0_IHP_SRAM_top.Inst_IHP_SRAM_top_ConfigMem.Inst_frame5_bit1.Q
+ Tile_X0Y0_IHP_SRAM_top.Inst_IHP_SRAM_top_switch_matrix.W2BEGb5 VPWR VGND sg13g2_mux4_1
XFILLER_54_73 VPWR VGND sg13g2_decap_8
X_1421_ Tile_X0Y1_FrameData[27] Tile_X0Y1_FrameStrobe[8] Tile_X0Y1_IHP_SRAM_bot.Inst_IHP_SRAM_bot_ConfigMem.Inst_frame8_bit27.Q
+ VPWR VGND sg13g2_dlhq_1
X_0303_ VPWR _0006_ Tile_X0Y0_E6END[0] VGND sg13g2_inv_1
X_1352_ Tile_X0Y1_FrameData[0] Tile_X0Y1_FrameStrobe[5] Tile_X0Y1_IHP_SRAM_bot.Inst_IHP_SRAM_bot_ConfigMem.Inst_frame5_bit0.Q
+ VPWR VGND sg13g2_dlhq_1
X_1283_ Tile_X0Y1_FrameData[5] Tile_X0Y1_FrameStrobe[3] Tile_X0Y1_IHP_SRAM_bot.Inst_IHP_SRAM_bot_ConfigMem.Inst_frame3_bit5.Q
+ VPWR VGND sg13g2_dlhq_1
X_0998_ Tile_X0Y0_FrameData[24] Tile_X0Y1_FrameStrobe[4] Tile_X0Y0_IHP_SRAM_top.Inst_IHP_SRAM_top_ConfigMem.Inst_frame4_bit24.Q
+ VPWR VGND sg13g2_dlhq_1
X_1619_ Tile_X0Y1_FrameData[8] net246 VPWR VGND sg13g2_buf_1
XFILLER_108_198 VPWR VGND sg13g2_fill_2
XFILLER_108_121 VPWR VGND sg13g2_decap_8
XFILLER_92_214 VPWR VGND sg13g2_fill_2
XFILLER_49_62 VPWR VGND sg13g2_fill_2
X_0921_ Tile_X0Y0_FrameData[5] Tile_X0Y1_FrameStrobe[1] Tile_X0Y0_IHP_SRAM_top.Inst_IHP_SRAM_top_ConfigMem.Inst_frame1_bit5.Q
+ VPWR VGND sg13g2_dlhq_1
XFILLER_65_83 VPWR VGND sg13g2_fill_1
XFILLER_45_130 VPWR VGND sg13g2_fill_2
X_0783_ Tile_X0Y1_IHP_SRAM_bot.Inst_IHP_SRAM_bot_ConfigMem.Inst_frame7_bit7.Q VPWR
+ _0223_ VGND Tile_X0Y1_IHP_SRAM_bot.Inst_IHP_SRAM_bot_ConfigMem.Inst_frame7_bit6.Q
+ Tile_X0Y1_IHP_SRAM_bot.Inst_IHP_SRAM_bot_switch_matrix.J_NS4_BEG12 sg13g2_o21ai_1
X_0852_ _0286_ VPWR _0287_ VGND _0037_ _0279_ sg13g2_o21ai_1
X_1335_ Tile_X0Y1_FrameData[17] Tile_X0Y1_FrameStrobe[5] Tile_X0Y1_IHP_SRAM_bot.Inst_IHP_SRAM_bot_ConfigMem.Inst_frame5_bit17.Q
+ VPWR VGND sg13g2_dlhq_1
X_1404_ Tile_X0Y1_FrameData[12] Tile_X0Y1_FrameStrobe[7] Tile_X0Y1_IHP_SRAM_bot.Inst_IHP_SRAM_bot_ConfigMem.Inst_frame7_bit12.Q
+ VPWR VGND sg13g2_dlhq_1
XFILLER_28_119 VPWR VGND sg13g2_fill_2
X_1266_ Tile_X0Y1_FrameData[22] Tile_X0Y1_FrameStrobe[3] Tile_X0Y1_IHP_SRAM_bot.Inst_IHP_SRAM_bot_ConfigMem.Inst_frame3_bit22.Q
+ VPWR VGND sg13g2_dlhq_1
X_1197_ Tile_X0Y1_FrameData[27] Tile_X0Y1_FrameStrobe[1] Tile_X0Y1_IHP_SRAM_bot.Inst_IHP_SRAM_bot_ConfigMem.Inst_frame1_bit27.Q
+ VPWR VGND sg13g2_dlhq_1
XFILLER_101_48 VPWR VGND sg13g2_decap_8
XFILLER_101_26 VPWR VGND sg13g2_fill_1
XFILLER_105_168 VPWR VGND sg13g2_decap_8
XFILLER_105_146 VPWR VGND sg13g2_fill_1
XFILLER_105_135 VPWR VGND sg13g2_decap_8
XFILLER_111_138 VPWR VGND sg13g2_decap_8
X_1120_ Tile_X0Y0_FrameData[30] Tile_X0Y1_FrameStrobe[8] Tile_X0Y0_IHP_SRAM_top.Inst_IHP_SRAM_top_ConfigMem.Inst_frame8_bit30.Q
+ VPWR VGND sg13g2_dlhq_1
X_1051_ Tile_X0Y0_FrameData[3] Tile_X0Y1_FrameStrobe[5] Tile_X0Y0_IHP_SRAM_top.Inst_IHP_SRAM_top_ConfigMem.Inst_frame5_bit3.Q
+ VPWR VGND sg13g2_dlhq_1
XFILLER_33_100 VPWR VGND sg13g2_decap_4
X_0904_ Tile_X0Y0_FrameData[22] Tile_X0Y1_FrameStrobe[1] Tile_X0Y0_IHP_SRAM_top.Inst_IHP_SRAM_top_ConfigMem.Inst_frame1_bit22.Q
+ VPWR VGND sg13g2_dlhq_1
X_0697_ Tile_X0Y1_IHP_SRAM_bot.Inst_IHP_SRAM_bot_ConfigMem.Inst_frame4_bit27.Q _0081_
+ _0174_ VPWR VGND Tile_X0Y1_IHP_SRAM_bot.Inst_IHP_SRAM_bot_ConfigMem.Inst_frame4_bit26.Q
+ sg13g2_nand3b_1
X_0835_ _0271_ _0257_ Tile_X0Y0_IHP_SRAM_top.Inst_IHP_SRAM_top_switch_matrix.S2BEG0
+ VPWR VGND sg13g2_nand2b_1
X_0766_ Tile_X0Y1_IHP_SRAM_bot.Inst_IHP_SRAM_bot_ConfigMem.Inst_frame8_bit12.Q VPWR
+ _0207_ VGND Tile_X0Y1_E6END[11] Tile_X0Y1_IHP_SRAM_bot.Inst_IHP_SRAM_bot_ConfigMem.Inst_frame8_bit11.Q
+ sg13g2_o21ai_1
XFILLER_51_0 VPWR VGND sg13g2_decap_8
XFILLER_102_127 VPWR VGND sg13g2_fill_2
X_1318_ Tile_X0Y1_FrameData[2] Tile_X0Y1_FrameStrobe[4] Tile_X0Y1_IHP_SRAM_bot.Inst_IHP_SRAM_bot_ConfigMem.Inst_frame4_bit2.Q
+ VPWR VGND sg13g2_dlhq_1
X_1249_ Tile_X0Y1_FrameData[7] Tile_X0Y1_FrameStrobe[2] Tile_X0Y1_IHP_SRAM_bot.Inst_IHP_SRAM_bot_ConfigMem.Inst_frame2_bit7.Q
+ VPWR VGND sg13g2_dlhq_1
XANTENNA_40 VPWR VGND Tile_X0Y1_FrameStrobe[17] sg13g2_antennanp
XANTENNA_51 VPWR VGND Tile_X0Y1_N2MID[2] sg13g2_antennanp
XFILLER_21_22 VPWR VGND sg13g2_fill_1
Xoutput191 net191 Tile_X0Y0_W6BEG[1] VPWR VGND sg13g2_buf_1
Xoutput180 net180 Tile_X0Y0_W2BEGb[0] VPWR VGND sg13g2_buf_1
XFILLER_46_30 VPWR VGND sg13g2_fill_1
XFILLER_46_52 VPWR VGND sg13g2_fill_2
XFILLER_47_214 VPWR VGND sg13g2_fill_2
XFILLER_30_114 VPWR VGND sg13g2_decap_4
X_0551_ Tile_X0Y0_IHP_SRAM_top.Inst_IHP_SRAM_top_ConfigMem.Inst_frame8_bit19.Q VPWR
+ _0112_ VGND _0110_ _0111_ sg13g2_o21ai_1
XFILLER_7_57 VPWR VGND sg13g2_fill_2
X_0620_ Tile_X0Y1_IHP_SRAM_bot.Inst_IHP_SRAM_bot_ConfigMem.Inst_frame7_bit5.Q Tile_X0Y1_E1END[3]
+ Tile_X0Y1_E2END[0] Tile_X0Y1_E2MID[0] _0084_ Tile_X0Y1_IHP_SRAM_bot.Inst_IHP_SRAM_bot_ConfigMem.Inst_frame7_bit4.Q
+ Tile_X0Y1_IHP_SRAM_bot.Inst_IHP_SRAM_bot_switch_matrix.S2BEG7 VPWR VGND sg13g2_mux4_1
X_0482_ Tile_X0Y0_IHP_SRAM_top.Inst_IHP_SRAM_top_ConfigMem.Inst_frame4_bit8.Q Tile_X0Y1_N4END[5]
+ Tile_X0Y0_S4END[1] Tile_X0Y0_IHP_SRAM_top.Inst_IHP_SRAM_top_switch_matrix.J_NS4_BEG10
+ Tile_X0Y0_IHP_SRAM_top.Inst_IHP_SRAM_top_switch_matrix.J_NS4_BEG14 Tile_X0Y0_IHP_SRAM_top.Inst_IHP_SRAM_top_ConfigMem.Inst_frame4_bit9.Q
+ Tile_X0Y0_IHP_SRAM_top.Inst_IHP_SRAM_top_switch_matrix.W6BEG1 VPWR VGND sg13g2_mux4_1
X_1103_ Tile_X0Y0_FrameData[15] Tile_X0Y1_FrameStrobe[7] Tile_X0Y0_IHP_SRAM_top.Inst_IHP_SRAM_top_ConfigMem.Inst_frame7_bit15.Q
+ VPWR VGND sg13g2_dlhq_1
X_1034_ Tile_X0Y0_FrameData[20] Tile_X0Y1_FrameStrobe[5] Tile_X0Y0_IHP_SRAM_top.Inst_IHP_SRAM_top_ConfigMem.Inst_frame5_bit20.Q
+ VPWR VGND sg13g2_dlhq_1
XFILLER_99_0 VPWR VGND sg13g2_fill_1
XFILLER_107_25 VPWR VGND sg13g2_decap_8
XFILLER_67_18 VPWR VGND sg13g2_fill_1
X_0818_ Tile_X0Y1_IHP_SRAM_bot.Inst_IHP_SRAM_bot_ConfigMem.Inst_frame7_bit17.Q VPWR
+ _0255_ VGND _0252_ _0253_ sg13g2_o21ai_1
X_0749_ _0021_ _0078_ _0192_ VPWR VGND sg13g2_nor2_1
XFILLER_32_54 VPWR VGND sg13g2_fill_1
X_1721_ Tile_X0Y1_IHP_SRAM_bot.Inst_IHP_SRAM_bot_switch_matrix.WW4BEG10 net317 VPWR
+ VGND sg13g2_buf_1
X_0603_ _0155_ _0157_ Tile_X0Y0_IHP_SRAM_top.Inst_IHP_SRAM_top_switch_matrix.S4BEG3
+ VPWR VGND sg13g2_nor2_1
X_0534_ Tile_X0Y0_E2MID[3] Tile_X0Y0_IHP_SRAM_top.Inst_IHP_SRAM_top_ConfigMem.Inst_frame1_bit4.Q
+ Tile_X0Y0_IHP_SRAM_top.Inst_IHP_SRAM_top_ConfigMem.Inst_frame1_bit5.Q _0098_ VPWR
+ VGND sg13g2_nor3_1
X_1583_ Tile_X0Y0_IHP_SRAM_top.Inst_IHP_SRAM_top_switch_matrix.W6BEG0 net188 VPWR
+ VGND sg13g2_buf_1
XFILLER_7_162 VPWR VGND sg13g2_fill_2
X_1652_ Tile_X0Y1_IHP_SRAM_bot.Inst_IHP_SRAM_bot_switch_matrix.S2BEG5 net257 VPWR
+ VGND sg13g2_buf_1
X_0465_ Tile_X0Y0_IHP_SRAM_top.Inst_IHP_SRAM_top_ConfigMem.Inst_frame1_bit22.Q Tile_X0Y0_IHP_SRAM_top.Inst_IHP_SRAM_top_switch_matrix.N1END3
+ Tile_X0Y1_N4END[7] Tile_X0Y0_S1END[3] Tile_X0Y0_S4END[3] Tile_X0Y0_IHP_SRAM_top.Inst_IHP_SRAM_top_ConfigMem.Inst_frame1_bit23.Q
+ Tile_X0Y0_IHP_SRAM_top.Inst_IHP_SRAM_top_switch_matrix.J_NS4_BEG7 VPWR VGND sg13g2_mux4_1
X_0396_ Tile_X0Y1_IHP_SRAM_bot.Inst_IHP_SRAM_bot_ConfigMem.Inst_frame9_bit23.Q Tile_X0Y1_E2MID[5]
+ Tile_X0Y1_E6END[5] Tile_X0Y1_E2END[5] _0079_ Tile_X0Y1_IHP_SRAM_bot.Inst_IHP_SRAM_bot_ConfigMem.Inst_frame9_bit22.Q
+ Tile_X0Y0_IHP_SRAM_top.Inst_IHP_SRAM_top_switch_matrix.N2BEGb2 VPWR VGND sg13g2_mux4_1
X_1017_ Tile_X0Y0_FrameData[5] Tile_X0Y1_FrameStrobe[4] Tile_X0Y0_IHP_SRAM_top.Inst_IHP_SRAM_top_ConfigMem.Inst_frame4_bit5.Q
+ VPWR VGND sg13g2_dlhq_1
XFILLER_84_161 VPWR VGND sg13g2_fill_1
XFILLER_43_31 VPWR VGND sg13g2_fill_1
XFILLER_90_186 VPWR VGND sg13g2_fill_1
XFILLER_75_183 VPWR VGND sg13g2_decap_8
X_1704_ Tile_X0Y1_IHP_SRAM_bot.Inst_IHP_SRAM_bot_switch_matrix.W6BEG5 net311 VPWR
+ VGND sg13g2_buf_1
X_1497_ Tile_X0Y0_FrameData[23] net94 VPWR VGND sg13g2_buf_1
XFILLER_100_203 VPWR VGND sg13g2_fill_1
X_0517_ Tile_X0Y0_IHP_SRAM_top.Inst_IHP_SRAM_top_ConfigMem.Inst_frame2_bit14.Q Tile_X0Y0_EE4END[0]
+ Tile_X0Y0_EE4END[8] Tile_X0Y0_E6END[8] Tile_X0Y0_IHP_SRAM_top.Inst_IHP_SRAM_top_switch_matrix.J_NS4_BEG8
+ Tile_X0Y0_IHP_SRAM_top.Inst_IHP_SRAM_top_ConfigMem.Inst_frame2_bit15.Q net28 VPWR
+ VGND sg13g2_mux4_1
X_1635_ Tile_X0Y1_FrameData[24] net232 VPWR VGND sg13g2_buf_1
X_1566_ Tile_X0Y0_IHP_SRAM_top.Inst_IHP_SRAM_top_switch_matrix.W1BEG3 net171 VPWR
+ VGND sg13g2_buf_1
X_0379_ Tile_X0Y0_IHP_SRAM_top.Inst_IHP_SRAM_top_ConfigMem.Inst_frame0_bit30.Q Tile_X0Y0_IHP_SRAM_top.Inst_IHP_SRAM_top_ConfigMem.Inst_frame0_bit31.Q
+ Tile_X0Y0_IHP_SRAM_top.Inst_IHP_SRAM_top_switch_matrix.N1END3 _0072_ VPWR VGND sg13g2_nor3_1
XFILLER_81_131 VPWR VGND sg13g2_decap_4
X_0448_ Tile_X0Y0_IHP_SRAM_top.Inst_IHP_SRAM_top_ConfigMem.Inst_frame6_bit30.Q A_DOUT_SRAM20
+ A_DOUT_SRAM28 Tile_X0Y0_IHP_SRAM_top.Inst_IHP_SRAM_top_switch_matrix.J_NS2_BEG3
+ Tile_X0Y0_IHP_SRAM_top.Inst_IHP_SRAM_top_switch_matrix.J_NS2_BEG4 Tile_X0Y0_IHP_SRAM_top.Inst_IHP_SRAM_top_ConfigMem.Inst_frame6_bit31.Q
+ Tile_X0Y0_IHP_SRAM_top.Inst_IHP_SRAM_top_switch_matrix.W2BEGb4 VPWR VGND sg13g2_mux4_1
XFILLER_64_109 VPWR VGND sg13g2_decap_4
XFILLER_57_183 VPWR VGND sg13g2_decap_8
XFILLER_110_91 VPWR VGND sg13g2_decap_4
XFILLER_70_73 VPWR VGND sg13g2_fill_2
X_0302_ VPWR _0005_ Tile_X0Y0_E6END[3] VGND sg13g2_inv_1
X_1351_ Tile_X0Y1_FrameData[1] Tile_X0Y1_FrameStrobe[5] Tile_X0Y1_IHP_SRAM_bot.Inst_IHP_SRAM_bot_ConfigMem.Inst_frame5_bit1.Q
+ VPWR VGND sg13g2_dlhq_1
X_1420_ Tile_X0Y1_FrameData[28] Tile_X0Y1_FrameStrobe[8] Tile_X0Y1_IHP_SRAM_bot.Inst_IHP_SRAM_bot_ConfigMem.Inst_frame8_bit28.Q
+ VPWR VGND sg13g2_dlhq_1
XFILLER_63_142 VPWR VGND sg13g2_fill_2
X_1282_ Tile_X0Y1_FrameData[6] Tile_X0Y1_FrameStrobe[3] Tile_X0Y1_IHP_SRAM_bot.Inst_IHP_SRAM_bot_ConfigMem.Inst_frame3_bit6.Q
+ VPWR VGND sg13g2_dlhq_1
XFILLER_63_186 VPWR VGND sg13g2_fill_2
X_0997_ Tile_X0Y0_FrameData[25] Tile_X0Y1_FrameStrobe[4] Tile_X0Y0_IHP_SRAM_top.Inst_IHP_SRAM_top_ConfigMem.Inst_frame4_bit25.Q
+ VPWR VGND sg13g2_dlhq_1
X_1618_ Tile_X0Y1_FrameData[7] net245 VPWR VGND sg13g2_buf_1
X_1549_ Tile_X0Y1_N4END[11] net160 VPWR VGND sg13g2_buf_1
XFILLER_108_100 VPWR VGND sg13g2_decap_8
XFILLER_108_177 VPWR VGND sg13g2_decap_4
XFILLER_105_80 VPWR VGND sg13g2_decap_8
X_0920_ Tile_X0Y0_FrameData[6] Tile_X0Y1_FrameStrobe[1] Tile_X0Y0_IHP_SRAM_top.Inst_IHP_SRAM_top_ConfigMem.Inst_frame1_bit6.Q
+ VPWR VGND sg13g2_dlhq_1
XFILLER_60_189 VPWR VGND sg13g2_fill_2
X_0782_ _0027_ _0081_ _0222_ VPWR VGND sg13g2_nor2_1
X_0851_ _0286_ _0284_ _0285_ _0282_ _0280_ VPWR VGND sg13g2_a22oi_1
XFILLER_83_215 VPWR VGND sg13g2_fill_1
X_1334_ Tile_X0Y1_FrameData[18] Tile_X0Y1_FrameStrobe[5] Tile_X0Y1_IHP_SRAM_bot.Inst_IHP_SRAM_bot_ConfigMem.Inst_frame5_bit18.Q
+ VPWR VGND sg13g2_dlhq_1
X_1265_ Tile_X0Y1_FrameData[23] Tile_X0Y1_FrameStrobe[3] Tile_X0Y1_IHP_SRAM_bot.Inst_IHP_SRAM_bot_ConfigMem.Inst_frame3_bit23.Q
+ VPWR VGND sg13g2_dlhq_1
X_1403_ Tile_X0Y1_FrameData[13] Tile_X0Y1_FrameStrobe[7] Tile_X0Y1_IHP_SRAM_bot.Inst_IHP_SRAM_bot_ConfigMem.Inst_frame7_bit13.Q
+ VPWR VGND sg13g2_dlhq_1
X_1196_ Tile_X0Y1_FrameData[28] Tile_X0Y1_FrameStrobe[1] Tile_X0Y1_IHP_SRAM_bot.Inst_IHP_SRAM_bot_ConfigMem.Inst_frame1_bit28.Q
+ VPWR VGND sg13g2_dlhq_1
XFILLER_51_112 VPWR VGND sg13g2_decap_8
XFILLER_51_123 VPWR VGND sg13g2_fill_2
XFILLER_105_103 VPWR VGND sg13g2_fill_1
XFILLER_3_208 VPWR VGND sg13g2_decap_8
XFILLER_19_77 VPWR VGND sg13g2_decap_8
XFILLER_19_109 VPWR VGND sg13g2_fill_1
XFILLER_27_186 VPWR VGND sg13g2_fill_2
XFILLER_111_117 VPWR VGND sg13g2_decap_8
XFILLER_80_207 VPWR VGND sg13g2_fill_1
X_1050_ Tile_X0Y0_FrameData[4] Tile_X0Y1_FrameStrobe[5] Tile_X0Y0_IHP_SRAM_top.Inst_IHP_SRAM_top_ConfigMem.Inst_frame5_bit4.Q
+ VPWR VGND sg13g2_dlhq_1
XFILLER_33_134 VPWR VGND sg13g2_decap_8
X_0903_ Tile_X0Y0_FrameData[23] Tile_X0Y1_FrameStrobe[1] Tile_X0Y0_IHP_SRAM_top.Inst_IHP_SRAM_top_ConfigMem.Inst_frame1_bit23.Q
+ VPWR VGND sg13g2_dlhq_1
X_0834_ _0266_ _0269_ _0264_ _0270_ VPWR VGND sg13g2_nand3_1
X_0765_ VGND VPWR _0199_ _0201_ Tile_X0Y0_IHP_SRAM_top.N4BEG_outbuf_10.A _0206_ sg13g2_a21oi_1
X_0696_ _0171_ VPWR net4 VGND Tile_X0Y1_IHP_SRAM_bot.Inst_IHP_SRAM_bot_ConfigMem.Inst_frame4_bit25.Q
+ _0173_ sg13g2_o21ai_1
XFILLER_44_0 VPWR VGND sg13g2_fill_1
XFILLER_110_194 VPWR VGND sg13g2_fill_1
XFILLER_56_215 VPWR VGND sg13g2_fill_1
X_1317_ Tile_X0Y1_FrameData[3] Tile_X0Y1_FrameStrobe[4] Tile_X0Y1_IHP_SRAM_bot.Inst_IHP_SRAM_bot_ConfigMem.Inst_frame4_bit3.Q
+ VPWR VGND sg13g2_dlhq_1
X_1248_ Tile_X0Y1_FrameData[8] Tile_X0Y1_FrameStrobe[2] Tile_X0Y1_IHP_SRAM_bot.Inst_IHP_SRAM_bot_ConfigMem.Inst_frame2_bit8.Q
+ VPWR VGND sg13g2_dlhq_1
XFILLER_24_189 VPWR VGND sg13g2_fill_1
X_1179_ Tile_X0Y1_FrameData[13] Tile_X0Y1_FrameStrobe[0] Tile_X0Y1_IHP_SRAM_bot.Inst_IHP_SRAM_bot_ConfigMem.Inst_frame0_bit13.Q
+ VPWR VGND sg13g2_dlhq_1
XANTENNA_41 VPWR VGND Tile_X0Y1_FrameStrobe[17] sg13g2_antennanp
XANTENNA_30 VPWR VGND Tile_X0Y0_S4END[10] sg13g2_antennanp
XFILLER_21_89 VPWR VGND sg13g2_decap_8
XANTENNA_52 VPWR VGND Tile_X0Y1_N2MID[2] sg13g2_antennanp
XFILLER_108_5 VPWR VGND sg13g2_decap_8
XFILLER_97_27 VPWR VGND sg13g2_fill_1
Xoutput192 net192 Tile_X0Y0_W6BEG[2] VPWR VGND sg13g2_buf_1
Xoutput181 net181 Tile_X0Y0_W2BEGb[1] VPWR VGND sg13g2_buf_1
Xoutput170 net170 Tile_X0Y0_W1BEG[2] VPWR VGND sg13g2_buf_1
X_0550_ Tile_X0Y0_IHP_SRAM_top.Inst_IHP_SRAM_top_ConfigMem.Inst_frame8_bit18.Q VPWR
+ _0111_ VGND Tile_X0Y0_IHP_SRAM_top.Inst_IHP_SRAM_top_ConfigMem.Inst_frame8_bit17.Q
+ Tile_X0Y0_IHP_SRAM_top.Inst_IHP_SRAM_top_switch_matrix.J_NS4_BEG13 sg13g2_o21ai_1
XFILLER_97_126 VPWR VGND sg13g2_fill_2
X_1102_ Tile_X0Y0_FrameData[16] Tile_X0Y1_FrameStrobe[7] Tile_X0Y0_IHP_SRAM_top.Inst_IHP_SRAM_top_ConfigMem.Inst_frame7_bit16.Q
+ VPWR VGND sg13g2_dlhq_1
X_0481_ Tile_X0Y0_IHP_SRAM_top.Inst_IHP_SRAM_top_ConfigMem.Inst_frame4_bit6.Q Tile_X0Y1_N4END[4]
+ Tile_X0Y0_S4END[0] Tile_X0Y0_IHP_SRAM_top.Inst_IHP_SRAM_top_switch_matrix.J_NS4_BEG11
+ Tile_X0Y0_IHP_SRAM_top.Inst_IHP_SRAM_top_switch_matrix.J_NS4_BEG15 Tile_X0Y0_IHP_SRAM_top.Inst_IHP_SRAM_top_ConfigMem.Inst_frame4_bit7.Q
+ Tile_X0Y0_IHP_SRAM_top.Inst_IHP_SRAM_top_switch_matrix.W6BEG0 VPWR VGND sg13g2_mux4_1
X_1033_ Tile_X0Y0_FrameData[21] Tile_X0Y1_FrameStrobe[5] Tile_X0Y0_IHP_SRAM_top.Inst_IHP_SRAM_top_ConfigMem.Inst_frame5_bit21.Q
+ VPWR VGND sg13g2_dlhq_1
X_0817_ Tile_X0Y1_IHP_SRAM_bot.Inst_IHP_SRAM_bot_switch_matrix.J_NS4_BEG7 Tile_X0Y1_IHP_SRAM_bot.Inst_IHP_SRAM_bot_switch_matrix.J_NS4_BEG11
+ Tile_X0Y1_IHP_SRAM_bot.Inst_IHP_SRAM_bot_ConfigMem.Inst_frame7_bit15.Q _0254_ VPWR
+ VGND sg13g2_mux2_1
XFILLER_88_104 VPWR VGND sg13g2_decap_8
X_0679_ Tile_X0Y1_IHP_SRAM_bot.Inst_IHP_SRAM_bot_ConfigMem.Inst_frame4_bit15.Q A_DOUT_SRAM2
+ Tile_X0Y1_IHP_SRAM_bot.Inst_IHP_SRAM_bot_switch_matrix.J_NS4_BEG5 _0160_ _0083_
+ Tile_X0Y1_IHP_SRAM_bot.Inst_IHP_SRAM_bot_ConfigMem.Inst_frame4_bit14.Q Tile_X0Y1_IHP_SRAM_bot.Inst_IHP_SRAM_bot_switch_matrix.W6BEG10
+ VPWR VGND sg13g2_mux4_1
X_0748_ VGND VPWR _0022_ _0190_ _0191_ Tile_X0Y1_IHP_SRAM_bot.Inst_IHP_SRAM_bot_ConfigMem.Inst_frame8_bit7.Q
+ sg13g2_a21oi_1
XFILLER_12_137 VPWR VGND sg13g2_fill_1
XFILLER_12_126 VPWR VGND sg13g2_decap_8
XFILLER_79_104 VPWR VGND sg13g2_decap_8
XFILLER_87_181 VPWR VGND sg13g2_fill_2
XFILLER_79_159 VPWR VGND sg13g2_decap_4
X_1720_ Tile_X0Y1_IHP_SRAM_bot.Inst_IHP_SRAM_bot_switch_matrix.WW4BEG9 net331 VPWR
+ VGND sg13g2_buf_1
X_1651_ Tile_X0Y1_IHP_SRAM_bot.Inst_IHP_SRAM_bot_switch_matrix.S2BEG4 net256 VPWR
+ VGND sg13g2_buf_1
X_0602_ Tile_X0Y0_IHP_SRAM_top.Inst_IHP_SRAM_top_ConfigMem.Inst_frame7_bit29.Q _0156_
+ _0157_ VPWR VGND sg13g2_nor2_1
X_0533_ VPWR VGND Tile_X0Y0_IHP_SRAM_top.Inst_IHP_SRAM_top_ConfigMem.Inst_frame1_bit2.Q
+ _0096_ _0097_ Tile_X0Y0_IHP_SRAM_top.Inst_IHP_SRAM_top_ConfigMem.Inst_frame1_bit3.Q
+ net8 _0040_ sg13g2_a221oi_1
X_0464_ Tile_X0Y0_IHP_SRAM_top.Inst_IHP_SRAM_top_ConfigMem.Inst_frame5_bit20.Q A_DOUT_SRAM23
+ A_DOUT_SRAM27 Tile_X0Y0_IHP_SRAM_top.Inst_IHP_SRAM_top_switch_matrix.J_NS4_BEG8
+ Tile_X0Y0_IHP_SRAM_top.Inst_IHP_SRAM_top_switch_matrix.J_NS2_BEG0 Tile_X0Y0_IHP_SRAM_top.Inst_IHP_SRAM_top_ConfigMem.Inst_frame5_bit21.Q
+ Tile_X0Y0_IHP_SRAM_top.Inst_IHP_SRAM_top_switch_matrix.WW4BEG7 VPWR VGND sg13g2_mux4_1
X_1582_ Tile_X0Y0_IHP_SRAM_top.Inst_IHP_SRAM_top_switch_matrix.W2BEGb7 net187 VPWR
+ VGND sg13g2_buf_1
X_0395_ Tile_X0Y1_IHP_SRAM_bot.Inst_IHP_SRAM_bot_ConfigMem.Inst_frame0_bit13.Q Tile_X0Y1_N2MID[2]
+ Tile_X0Y0_IHP_SRAM_top.Inst_IHP_SRAM_top_switch_matrix.S2BEG2 Tile_X0Y1_N2END[2]
+ Tile_X0Y0_S2MID[2] Tile_X0Y1_IHP_SRAM_bot.Inst_IHP_SRAM_bot_ConfigMem.Inst_frame0_bit12.Q
+ _0079_ VPWR VGND sg13g2_mux4_1
X_1016_ Tile_X0Y0_FrameData[6] Tile_X0Y1_FrameStrobe[4] Tile_X0Y0_IHP_SRAM_top.Inst_IHP_SRAM_top_ConfigMem.Inst_frame4_bit6.Q
+ VPWR VGND sg13g2_dlhq_1
XFILLER_84_140 VPWR VGND sg13g2_fill_2
XFILLER_27_22 VPWR VGND sg13g2_fill_2
XFILLER_40_210 VPWR VGND sg13g2_fill_2
XFILLER_111_0 VPWR VGND sg13g2_fill_2
X_1703_ Tile_X0Y1_IHP_SRAM_bot.Inst_IHP_SRAM_bot_switch_matrix.W6BEG4 net310 VPWR
+ VGND sg13g2_buf_1
X_1634_ Tile_X0Y1_FrameData[23] net231 VPWR VGND sg13g2_buf_1
X_1496_ Tile_X0Y0_FrameData[22] net93 VPWR VGND sg13g2_buf_1
X_0516_ Tile_X0Y0_IHP_SRAM_top.Inst_IHP_SRAM_top_ConfigMem.Inst_frame2_bit12.Q Tile_X0Y0_EE4END[7]
+ Tile_X0Y0_EE4END[15] Tile_X0Y0_E6END[7] Tile_X0Y0_IHP_SRAM_top.Inst_IHP_SRAM_top_switch_matrix.J_NS4_BEG7
+ Tile_X0Y0_IHP_SRAM_top.Inst_IHP_SRAM_top_ConfigMem.Inst_frame2_bit13.Q net27 VPWR
+ VGND sg13g2_mux4_1
X_0447_ Tile_X0Y0_IHP_SRAM_top.Inst_IHP_SRAM_top_ConfigMem.Inst_frame6_bit28.Q A_DOUT_SRAM19
+ A_DOUT_SRAM27 Tile_X0Y0_IHP_SRAM_top.Inst_IHP_SRAM_top_switch_matrix.J_NS2_BEG3
+ Tile_X0Y0_IHP_SRAM_top.Inst_IHP_SRAM_top_switch_matrix.J_NS2_BEG4 Tile_X0Y0_IHP_SRAM_top.Inst_IHP_SRAM_top_ConfigMem.Inst_frame6_bit29.Q
+ Tile_X0Y0_IHP_SRAM_top.Inst_IHP_SRAM_top_switch_matrix.W2BEGb3 VPWR VGND sg13g2_mux4_1
XFILLER_58_118 VPWR VGND sg13g2_fill_2
X_1565_ Tile_X0Y0_IHP_SRAM_top.Inst_IHP_SRAM_top_switch_matrix.W1BEG2 net170 VPWR
+ VGND sg13g2_buf_1
X_0378_ _0071_ Tile_X0Y0_S1END[3] Tile_X0Y0_IHP_SRAM_top.Inst_IHP_SRAM_top_ConfigMem.Inst_frame0_bit30.Q
+ VPWR VGND sg13g2_nand2b_1
XFILLER_81_176 VPWR VGND sg13g2_decap_8
XFILLER_89_39 VPWR VGND sg13g2_fill_1
XFILLER_38_65 VPWR VGND sg13g2_decap_8
XFILLER_95_213 VPWR VGND sg13g2_fill_2
X_0301_ VPWR _0004_ Tile_X0Y0_E6END[2] VGND sg13g2_inv_1
X_1350_ Tile_X0Y1_FrameData[2] Tile_X0Y1_FrameStrobe[5] Tile_X0Y1_IHP_SRAM_bot.Inst_IHP_SRAM_bot_ConfigMem.Inst_frame5_bit2.Q
+ VPWR VGND sg13g2_dlhq_1
X_1281_ Tile_X0Y1_FrameData[7] Tile_X0Y1_FrameStrobe[3] Tile_X0Y1_IHP_SRAM_bot.Inst_IHP_SRAM_bot_ConfigMem.Inst_frame3_bit7.Q
+ VPWR VGND sg13g2_dlhq_1
X_0996_ Tile_X0Y0_FrameData[26] Tile_X0Y1_FrameStrobe[4] Tile_X0Y0_IHP_SRAM_top.Inst_IHP_SRAM_top_ConfigMem.Inst_frame4_bit26.Q
+ VPWR VGND sg13g2_dlhq_1
X_1617_ Tile_X0Y1_FrameData[6] net244 VPWR VGND sg13g2_buf_1
X_1479_ Tile_X0Y0_FrameData[5] net106 VPWR VGND sg13g2_buf_1
X_1548_ Tile_X0Y1_N4END[10] net159 VPWR VGND sg13g2_buf_1
XFILLER_24_67 VPWR VGND sg13g2_fill_1
XFILLER_54_143 VPWR VGND sg13g2_decap_8
XFILLER_108_156 VPWR VGND sg13g2_decap_8
XFILLER_40_77 VPWR VGND sg13g2_fill_2
XFILLER_49_64 VPWR VGND sg13g2_fill_1
XFILLER_65_74 VPWR VGND sg13g2_decap_8
XFILLER_45_132 VPWR VGND sg13g2_fill_1
X_0850_ VGND VPWR Tile_X0Y1_E2MID[6] Tile_X0Y1_IHP_SRAM_bot.Inst_IHP_SRAM_bot_ConfigMem.Inst_frame1_bit4.Q
+ _0285_ _0283_ sg13g2_a21oi_1
X_0781_ VGND VPWR _0028_ _0220_ _0221_ Tile_X0Y1_IHP_SRAM_bot.Inst_IHP_SRAM_bot_ConfigMem.Inst_frame7_bit8.Q
+ sg13g2_a21oi_1
X_1402_ Tile_X0Y1_FrameData[14] Tile_X0Y1_FrameStrobe[7] Tile_X0Y1_IHP_SRAM_bot.Inst_IHP_SRAM_bot_ConfigMem.Inst_frame7_bit14.Q
+ VPWR VGND sg13g2_dlhq_1
X_1333_ Tile_X0Y1_FrameData[19] Tile_X0Y1_FrameStrobe[5] Tile_X0Y1_IHP_SRAM_bot.Inst_IHP_SRAM_bot_ConfigMem.Inst_frame5_bit19.Q
+ VPWR VGND sg13g2_dlhq_1
X_1264_ Tile_X0Y1_FrameData[24] Tile_X0Y1_FrameStrobe[3] Tile_X0Y1_IHP_SRAM_bot.Inst_IHP_SRAM_bot_ConfigMem.Inst_frame3_bit24.Q
+ VPWR VGND sg13g2_dlhq_1
XFILLER_36_187 VPWR VGND sg13g2_fill_1
X_1195_ Tile_X0Y1_FrameData[29] Tile_X0Y1_FrameStrobe[1] Tile_X0Y1_IHP_SRAM_bot.Inst_IHP_SRAM_bot_ConfigMem.Inst_frame1_bit29.Q
+ VPWR VGND sg13g2_dlhq_1
XFILLER_51_146 VPWR VGND sg13g2_fill_1
X_0979_ Tile_X0Y0_FrameData[11] Tile_X0Y1_FrameStrobe[3] Tile_X0Y0_IHP_SRAM_top.Inst_IHP_SRAM_top_ConfigMem.Inst_frame3_bit11.Q
+ VPWR VGND sg13g2_dlhq_1
Xoutput330 net330 Tile_X0Y1_WW4BEG[8] VPWR VGND sg13g2_buf_1
XFILLER_19_12 VPWR VGND sg13g2_fill_2
XFILLER_42_157 VPWR VGND sg13g2_fill_2
XFILLER_104_192 VPWR VGND sg13g2_decap_8
X_0902_ Tile_X0Y0_FrameData[24] Tile_X0Y1_FrameStrobe[1] Tile_X0Y0_IHP_SRAM_top.Inst_IHP_SRAM_top_ConfigMem.Inst_frame1_bit24.Q
+ VPWR VGND sg13g2_dlhq_1
X_0833_ _0269_ _0268_ _0257_ _0261_ _0259_ VPWR VGND sg13g2_a22oi_1
XFILLER_37_0 VPWR VGND sg13g2_fill_1
X_0764_ VGND VPWR _0024_ _0204_ _0206_ _0205_ sg13g2_a21oi_1
X_0695_ VGND VPWR Tile_X0Y1_E2END[3] Tile_X0Y1_IHP_SRAM_bot.Inst_IHP_SRAM_bot_ConfigMem.Inst_frame4_bit24.Q
+ _0173_ _0172_ sg13g2_a21oi_1
X_1316_ Tile_X0Y1_FrameData[4] Tile_X0Y1_FrameStrobe[4] Tile_X0Y1_IHP_SRAM_bot.Inst_IHP_SRAM_bot_ConfigMem.Inst_frame4_bit4.Q
+ VPWR VGND sg13g2_dlhq_1
XFILLER_24_102 VPWR VGND sg13g2_fill_2
X_1247_ Tile_X0Y1_FrameData[9] Tile_X0Y1_FrameStrobe[2] Tile_X0Y1_IHP_SRAM_bot.Inst_IHP_SRAM_bot_ConfigMem.Inst_frame2_bit9.Q
+ VPWR VGND sg13g2_dlhq_1
X_1178_ Tile_X0Y1_FrameData[14] Tile_X0Y1_FrameStrobe[0] Tile_X0Y1_IHP_SRAM_bot.Inst_IHP_SRAM_bot_ConfigMem.Inst_frame0_bit14.Q
+ VPWR VGND sg13g2_dlhq_1
XANTENNA_20 VPWR VGND net163 sg13g2_antennanp
XANTENNA_31 VPWR VGND Tile_X0Y0_S4END[8] sg13g2_antennanp
XFILLER_32_190 VPWR VGND sg13g2_decap_4
XANTENNA_42 VPWR VGND Tile_X0Y1_FrameStrobe[18] sg13g2_antennanp
XANTENNA_53 VPWR VGND Tile_X0Y1_N2MID[2] sg13g2_antennanp
Xoutput160 net160 Tile_X0Y0_N4BEG[3] VPWR VGND sg13g2_buf_1
Xoutput193 net193 Tile_X0Y0_W6BEG[3] VPWR VGND sg13g2_buf_1
Xoutput182 net182 Tile_X0Y0_W2BEGb[2] VPWR VGND sg13g2_buf_1
Xoutput171 net171 Tile_X0Y0_W1BEG[3] VPWR VGND sg13g2_buf_1
XFILLER_102_71 VPWR VGND sg13g2_decap_8
XFILLER_101_195 VPWR VGND sg13g2_decap_8
XFILLER_15_124 VPWR VGND sg13g2_fill_1
XFILLER_30_138 VPWR VGND sg13g2_decap_4
X_0480_ Tile_X0Y0_IHP_SRAM_top.Inst_IHP_SRAM_top_ConfigMem.Inst_frame4_bit4.Q A_DOUT_SRAM19
+ A_DOUT_SRAM31 Tile_X0Y0_IHP_SRAM_top.Inst_IHP_SRAM_top_switch_matrix.J_NS4_BEG0
+ Tile_X0Y0_IHP_SRAM_top.Inst_IHP_SRAM_top_switch_matrix.J_NS2_BEG0 Tile_X0Y0_IHP_SRAM_top.Inst_IHP_SRAM_top_ConfigMem.Inst_frame4_bit5.Q
+ Tile_X0Y0_IHP_SRAM_top.Inst_IHP_SRAM_top_switch_matrix.WW4BEG15 VPWR VGND sg13g2_mux4_1
X_1101_ Tile_X0Y0_FrameData[17] Tile_X0Y1_FrameStrobe[7] Tile_X0Y0_IHP_SRAM_top.Inst_IHP_SRAM_top_ConfigMem.Inst_frame7_bit17.Q
+ VPWR VGND sg13g2_dlhq_1
X_1032_ Tile_X0Y0_FrameData[22] Tile_X0Y1_FrameStrobe[5] Tile_X0Y0_IHP_SRAM_top.Inst_IHP_SRAM_top_ConfigMem.Inst_frame5_bit22.Q
+ VPWR VGND sg13g2_dlhq_1
X_0816_ Tile_X0Y1_IHP_SRAM_bot.Inst_IHP_SRAM_bot_ConfigMem.Inst_frame7_bit16.Q VPWR
+ _0253_ VGND Tile_X0Y1_IHP_SRAM_bot.Inst_IHP_SRAM_bot_ConfigMem.Inst_frame7_bit15.Q
+ Tile_X0Y1_IHP_SRAM_bot.Inst_IHP_SRAM_bot_switch_matrix.J_NS4_BEG15 sg13g2_o21ai_1
X_0747_ Tile_X0Y1_E1END[1] Tile_X0Y1_EE4END[1] Tile_X0Y1_IHP_SRAM_bot.Inst_IHP_SRAM_bot_ConfigMem.Inst_frame8_bit5.Q
+ _0190_ VPWR VGND sg13g2_mux2_1
X_0678_ Tile_X0Y1_IHP_SRAM_bot.Inst_IHP_SRAM_bot_ConfigMem.Inst_frame4_bit13.Q A_DOUT_SRAM1
+ Tile_X0Y1_IHP_SRAM_bot.Inst_IHP_SRAM_bot_switch_matrix.J_NS4_BEG6 _0159_ _0082_
+ Tile_X0Y1_IHP_SRAM_bot.Inst_IHP_SRAM_bot_ConfigMem.Inst_frame4_bit12.Q Tile_X0Y1_IHP_SRAM_bot.Inst_IHP_SRAM_bot_switch_matrix.W6BEG9
+ VPWR VGND sg13g2_mux4_1
XFILLER_79_149 VPWR VGND sg13g2_fill_2
X_0601_ Tile_X0Y0_IHP_SRAM_top.Inst_IHP_SRAM_top_ConfigMem.Inst_frame7_bit28.Q Tile_X0Y0_E1END[3]
+ Tile_X0Y0_E6END[7] Tile_X0Y0_EE4END[15] Tile_X0Y0_IHP_SRAM_top.Inst_IHP_SRAM_top_switch_matrix.J_NS4_BEG3
+ Tile_X0Y0_IHP_SRAM_top.Inst_IHP_SRAM_top_ConfigMem.Inst_frame7_bit27.Q _0156_ VPWR
+ VGND sg13g2_mux4_1
X_1581_ Tile_X0Y0_IHP_SRAM_top.Inst_IHP_SRAM_top_switch_matrix.W2BEGb6 net186 VPWR
+ VGND sg13g2_buf_1
X_1650_ Tile_X0Y1_IHP_SRAM_bot.Inst_IHP_SRAM_bot_switch_matrix.S2BEG3 net255 VPWR
+ VGND sg13g2_buf_1
X_0463_ Tile_X0Y0_IHP_SRAM_top.Inst_IHP_SRAM_top_ConfigMem.Inst_frame1_bit24.Q Tile_X0Y0_IHP_SRAM_top.Inst_IHP_SRAM_top_switch_matrix.N1END0
+ Tile_X0Y1_N4END[4] Tile_X0Y0_S1END[0] Tile_X0Y0_S4END[0] Tile_X0Y0_IHP_SRAM_top.Inst_IHP_SRAM_top_ConfigMem.Inst_frame1_bit25.Q
+ Tile_X0Y0_IHP_SRAM_top.Inst_IHP_SRAM_top_switch_matrix.J_NS4_BEG8 VPWR VGND sg13g2_mux4_1
X_0394_ Tile_X0Y0_IHP_SRAM_top.Inst_IHP_SRAM_top_ConfigMem.Inst_frame7_bit6.Q Tile_X0Y0_E2MID[5]
+ Tile_X0Y0_E2END[5] Tile_X0Y0_E6END[10] Tile_X0Y0_IHP_SRAM_top.Inst_IHP_SRAM_top_switch_matrix.J_NS2_BEG2
+ Tile_X0Y0_IHP_SRAM_top.Inst_IHP_SRAM_top_ConfigMem.Inst_frame7_bit7.Q Tile_X0Y0_IHP_SRAM_top.Inst_IHP_SRAM_top_switch_matrix.S2BEG2
+ VPWR VGND sg13g2_mux4_1
X_0532_ _0097_ Tile_X0Y0_E2END[2] Tile_X0Y0_IHP_SRAM_top.Inst_IHP_SRAM_top_ConfigMem.Inst_frame1_bit3.Q
+ VPWR VGND sg13g2_nand2b_1
XFILLER_78_160 VPWR VGND sg13g2_decap_4
X_1015_ Tile_X0Y0_FrameData[7] Tile_X0Y1_FrameStrobe[4] Tile_X0Y0_IHP_SRAM_top.Inst_IHP_SRAM_top_ConfigMem.Inst_frame4_bit7.Q
+ VPWR VGND sg13g2_dlhq_1
XFILLER_94_18 VPWR VGND sg13g2_fill_1
XFILLER_27_45 VPWR VGND sg13g2_fill_1
XFILLER_104_0 VPWR VGND sg13g2_decap_8
XFILLER_90_144 VPWR VGND sg13g2_fill_1
XFILLER_90_166 VPWR VGND sg13g2_fill_1
XFILLER_98_211 VPWR VGND sg13g2_fill_1
X_1564_ Tile_X0Y0_IHP_SRAM_top.Inst_IHP_SRAM_top_switch_matrix.W1BEG1 net169 VPWR
+ VGND sg13g2_buf_1
X_1702_ Tile_X0Y1_IHP_SRAM_bot.Inst_IHP_SRAM_bot_switch_matrix.W6BEG3 net309 VPWR
+ VGND sg13g2_buf_1
X_1633_ Tile_X0Y1_FrameData[22] net230 VPWR VGND sg13g2_buf_1
X_1495_ Tile_X0Y0_FrameData[21] net92 VPWR VGND sg13g2_buf_1
X_0377_ Tile_X0Y0_IHP_SRAM_top.Inst_IHP_SRAM_top_ConfigMem.Inst_frame9_bit26.Q Tile_X0Y0_E1END[2]
+ Tile_X0Y0_E6END[6] Tile_X0Y0_IHP_SRAM_top.Inst_IHP_SRAM_top_switch_matrix.J_NS4_BEG14
+ _0066_ Tile_X0Y0_IHP_SRAM_top.Inst_IHP_SRAM_top_ConfigMem.Inst_frame9_bit27.Q Tile_X0Y0_IHP_SRAM_top.Inst_IHP_SRAM_top_switch_matrix.N1BEG2
+ VPWR VGND sg13g2_mux4_1
X_0446_ Tile_X0Y0_IHP_SRAM_top.Inst_IHP_SRAM_top_ConfigMem.Inst_frame6_bit26.Q A_DOUT_SRAM18
+ A_DOUT_SRAM26 Tile_X0Y0_IHP_SRAM_top.Inst_IHP_SRAM_top_switch_matrix.J_NS2_BEG2
+ Tile_X0Y0_IHP_SRAM_top.Inst_IHP_SRAM_top_switch_matrix.J_NS2_BEG5 Tile_X0Y0_IHP_SRAM_top.Inst_IHP_SRAM_top_ConfigMem.Inst_frame6_bit27.Q
+ Tile_X0Y0_IHP_SRAM_top.Inst_IHP_SRAM_top_switch_matrix.W2BEGb2 VPWR VGND sg13g2_mux4_1
X_0515_ Tile_X0Y0_IHP_SRAM_top.Inst_IHP_SRAM_top_ConfigMem.Inst_frame2_bit10.Q Tile_X0Y0_EE4END[6]
+ Tile_X0Y0_EE4END[14] Tile_X0Y0_E6END[6] Tile_X0Y0_IHP_SRAM_top.Inst_IHP_SRAM_top_switch_matrix.J_NS4_BEG6
+ Tile_X0Y0_IHP_SRAM_top.Inst_IHP_SRAM_top_ConfigMem.Inst_frame2_bit11.Q net26 VPWR
+ VGND sg13g2_mux4_1
XFILLER_22_211 VPWR VGND sg13g2_fill_1
XFILLER_49_108 VPWR VGND sg13g2_fill_2
XFILLER_72_111 VPWR VGND sg13g2_decap_8
XFILLER_38_22 VPWR VGND sg13g2_fill_2
XFILLER_54_43 VPWR VGND sg13g2_decap_8
XFILLER_70_97 VPWR VGND sg13g2_decap_4
XFILLER_70_75 VPWR VGND sg13g2_fill_1
X_0300_ VPWR _0003_ Tile_X0Y0_E6END[1] VGND sg13g2_inv_1
X_1280_ Tile_X0Y1_FrameData[8] Tile_X0Y1_FrameStrobe[3] Tile_X0Y1_IHP_SRAM_bot.Inst_IHP_SRAM_bot_ConfigMem.Inst_frame3_bit8.Q
+ VPWR VGND sg13g2_dlhq_1
XFILLER_63_188 VPWR VGND sg13g2_fill_1
X_0995_ Tile_X0Y0_FrameData[27] Tile_X0Y1_FrameStrobe[4] Tile_X0Y0_IHP_SRAM_top.Inst_IHP_SRAM_top_ConfigMem.Inst_frame4_bit27.Q
+ VPWR VGND sg13g2_dlhq_1
X_1547_ Tile_X0Y1_N4END[9] net158 VPWR VGND sg13g2_buf_1
X_1616_ Tile_X0Y1_FrameData[5] net243 VPWR VGND sg13g2_buf_1
X_1478_ Tile_X0Y0_FrameData[4] net105 VPWR VGND sg13g2_buf_1
X_0429_ _0090_ _0088_ Tile_X0Y1_IHP_SRAM_bot.Inst_IHP_SRAM_bot_ConfigMem.Inst_frame0_bit24.Q
+ VPWR VGND sg13g2_nand2b_1
XFILLER_108_135 VPWR VGND sg13g2_decap_8
XFILLER_14_90 VPWR VGND sg13g2_decap_8
X_0780_ Tile_X0Y1_E1END[0] Tile_X0Y1_EE4END[12] Tile_X0Y1_IHP_SRAM_bot.Inst_IHP_SRAM_bot_ConfigMem.Inst_frame7_bit6.Q
+ _0220_ VPWR VGND sg13g2_mux2_1
X_1401_ Tile_X0Y1_FrameData[15] Tile_X0Y1_FrameStrobe[7] Tile_X0Y1_IHP_SRAM_bot.Inst_IHP_SRAM_bot_ConfigMem.Inst_frame7_bit15.Q
+ VPWR VGND sg13g2_dlhq_1
X_1332_ Tile_X0Y1_FrameData[20] Tile_X0Y1_FrameStrobe[5] Tile_X0Y1_IHP_SRAM_bot.Inst_IHP_SRAM_bot_ConfigMem.Inst_frame5_bit20.Q
+ VPWR VGND sg13g2_dlhq_1
X_1263_ Tile_X0Y1_FrameData[25] Tile_X0Y1_FrameStrobe[3] Tile_X0Y1_IHP_SRAM_bot.Inst_IHP_SRAM_bot_ConfigMem.Inst_frame3_bit25.Q
+ VPWR VGND sg13g2_dlhq_1
X_1194_ Tile_X0Y1_FrameData[30] Tile_X0Y1_FrameStrobe[1] Tile_X0Y1_IHP_SRAM_bot.Inst_IHP_SRAM_bot_ConfigMem.Inst_frame1_bit30.Q
+ VPWR VGND sg13g2_dlhq_1
X_0978_ Tile_X0Y0_FrameData[12] Tile_X0Y1_FrameStrobe[3] Tile_X0Y0_IHP_SRAM_top.Inst_IHP_SRAM_top_ConfigMem.Inst_frame3_bit12.Q
+ VPWR VGND sg13g2_dlhq_1
XFILLER_10_48 VPWR VGND sg13g2_fill_1
Xoutput331 net331 Tile_X0Y1_WW4BEG[9] VPWR VGND sg13g2_buf_1
Xoutput320 net320 Tile_X0Y1_WW4BEG[13] VPWR VGND sg13g2_buf_1
XFILLER_27_133 VPWR VGND sg13g2_fill_1
XFILLER_35_67 VPWR VGND sg13g2_fill_1
XFILLER_104_171 VPWR VGND sg13g2_decap_8
X_0901_ Tile_X0Y0_FrameData[25] Tile_X0Y1_FrameStrobe[1] Tile_X0Y0_IHP_SRAM_top.Inst_IHP_SRAM_top_ConfigMem.Inst_frame1_bit25.Q
+ VPWR VGND sg13g2_dlhq_1
X_0763_ Tile_X0Y1_IHP_SRAM_bot.Inst_IHP_SRAM_bot_ConfigMem.Inst_frame8_bit10.Q VPWR
+ _0205_ VGND _0202_ _0203_ sg13g2_o21ai_1
X_0832_ VGND VPWR Tile_X0Y1_N2END[3] _0035_ _0268_ _0267_ sg13g2_a21oi_1
X_1315_ Tile_X0Y1_FrameData[5] Tile_X0Y1_FrameStrobe[4] Tile_X0Y1_IHP_SRAM_bot.Inst_IHP_SRAM_bot_ConfigMem.Inst_frame4_bit5.Q
+ VPWR VGND sg13g2_dlhq_1
X_0694_ _0000_ Tile_X0Y1_IHP_SRAM_bot.Inst_IHP_SRAM_bot_ConfigMem.Inst_frame4_bit24.Q
+ _0172_ VPWR VGND sg13g2_nor2_1
XFILLER_110_163 VPWR VGND sg13g2_decap_4
X_1246_ Tile_X0Y1_FrameData[10] Tile_X0Y1_FrameStrobe[2] Tile_X0Y1_IHP_SRAM_bot.Inst_IHP_SRAM_bot_ConfigMem.Inst_frame2_bit10.Q
+ VPWR VGND sg13g2_dlhq_1
X_1177_ Tile_X0Y1_FrameData[15] Tile_X0Y1_FrameStrobe[0] Tile_X0Y1_IHP_SRAM_bot.Inst_IHP_SRAM_bot_ConfigMem.Inst_frame0_bit15.Q
+ VPWR VGND sg13g2_dlhq_1
XANTENNA_21 VPWR VGND Tile_X0Y0_S2MID[5] sg13g2_antennanp
XANTENNA_10 VPWR VGND A_DOUT_SRAM19 sg13g2_antennanp
XANTENNA_54 VPWR VGND Tile_X0Y1_N2MID[7] sg13g2_antennanp
XANTENNA_43 VPWR VGND Tile_X0Y1_IHP_SRAM_bot.Inst_IHP_SRAM_bot_switch_matrix.S1BEG1
+ sg13g2_antennanp
XANTENNA_32 VPWR VGND Tile_X0Y0_S4END[9] sg13g2_antennanp
Xoutput161 net161 Tile_X0Y0_N4BEG[4] VPWR VGND sg13g2_buf_1
Xoutput150 net150 Tile_X0Y0_N2BEGb[7] VPWR VGND sg13g2_buf_1
Xoutput194 net194 Tile_X0Y0_W6BEG[4] VPWR VGND sg13g2_buf_1
Xoutput183 net183 Tile_X0Y0_W2BEGb[3] VPWR VGND sg13g2_buf_1
Xoutput172 net172 Tile_X0Y0_W2BEG[0] VPWR VGND sg13g2_buf_1
XFILLER_46_11 VPWR VGND sg13g2_fill_2
XFILLER_62_76 VPWR VGND sg13g2_decap_4
X_1100_ Tile_X0Y0_FrameData[18] Tile_X0Y1_FrameStrobe[7] Tile_X0Y0_IHP_SRAM_top.Inst_IHP_SRAM_top_ConfigMem.Inst_frame7_bit18.Q
+ VPWR VGND sg13g2_dlhq_1
X_1031_ Tile_X0Y0_FrameData[23] Tile_X0Y1_FrameStrobe[5] Tile_X0Y0_IHP_SRAM_top.Inst_IHP_SRAM_top_ConfigMem.Inst_frame5_bit23.Q
+ VPWR VGND sg13g2_dlhq_1
XFILLER_107_39 VPWR VGND sg13g2_decap_8
X_0815_ _0033_ _0084_ _0252_ VPWR VGND sg13g2_nor2_1
X_0746_ _0188_ VPWR _0189_ VGND _0021_ _0160_ sg13g2_o21ai_1
X_0677_ Tile_X0Y1_IHP_SRAM_bot.Inst_IHP_SRAM_bot_ConfigMem.Inst_frame4_bit11.Q A_DOUT_SRAM0
+ Tile_X0Y1_IHP_SRAM_bot.Inst_IHP_SRAM_bot_switch_matrix.J_NS4_BEG7 _0158_ _0081_
+ Tile_X0Y1_IHP_SRAM_bot.Inst_IHP_SRAM_bot_ConfigMem.Inst_frame4_bit10.Q Tile_X0Y1_IHP_SRAM_bot.Inst_IHP_SRAM_bot_switch_matrix.W6BEG8
+ VPWR VGND sg13g2_mux4_1
X_1229_ Tile_X0Y1_FrameData[27] Tile_X0Y1_FrameStrobe[2] Tile_X0Y1_IHP_SRAM_bot.Inst_IHP_SRAM_bot_ConfigMem.Inst_frame2_bit27.Q
+ VPWR VGND sg13g2_dlhq_1
XFILLER_32_79 VPWR VGND sg13g2_decap_8
XFILLER_106_200 VPWR VGND sg13g2_decap_4
XFILLER_106_4 VPWR VGND sg13g2_fill_1
XFILLER_79_128 VPWR VGND sg13g2_fill_1
XFILLER_35_209 VPWR VGND sg13g2_fill_2
XFILLER_57_54 VPWR VGND sg13g2_fill_2
X_0600_ VGND VPWR _0018_ _0151_ _0155_ _0154_ sg13g2_a21oi_1
X_0531_ Tile_X0Y0_E2MID[2] Tile_X0Y0_IHP_SRAM_top.Inst_IHP_SRAM_top_ConfigMem.Inst_frame1_bit2.Q
+ Tile_X0Y0_IHP_SRAM_top.Inst_IHP_SRAM_top_ConfigMem.Inst_frame1_bit3.Q _0096_ VPWR
+ VGND sg13g2_nor3_1
X_1580_ Tile_X0Y0_IHP_SRAM_top.Inst_IHP_SRAM_top_switch_matrix.W2BEGb5 net185 VPWR
+ VGND sg13g2_buf_1
XFILLER_7_198 VPWR VGND sg13g2_fill_2
X_0393_ Tile_X0Y0_IHP_SRAM_top.Inst_IHP_SRAM_top_ConfigMem.Inst_frame8_bit0.Q Tile_X0Y0_E2MID[6]
+ Tile_X0Y0_E2END[6] Tile_X0Y0_E6END[6] Tile_X0Y0_IHP_SRAM_top.Inst_IHP_SRAM_top_switch_matrix.J_NS2_BEG1
+ Tile_X0Y0_IHP_SRAM_top.Inst_IHP_SRAM_top_ConfigMem.Inst_frame8_bit1.Q Tile_X0Y0_IHP_SRAM_top.Inst_IHP_SRAM_top_switch_matrix.N2BEG1
+ VPWR VGND sg13g2_mux4_1
X_0462_ Tile_X0Y0_IHP_SRAM_top.Inst_IHP_SRAM_top_ConfigMem.Inst_frame5_bit18.Q A_DOUT_SRAM22
+ A_DOUT_SRAM26 Tile_X0Y0_IHP_SRAM_top.Inst_IHP_SRAM_top_switch_matrix.J_NS4_BEG9
+ Tile_X0Y0_IHP_SRAM_top.Inst_IHP_SRAM_top_switch_matrix.J_NS2_BEG1 Tile_X0Y0_IHP_SRAM_top.Inst_IHP_SRAM_top_ConfigMem.Inst_frame5_bit19.Q
+ Tile_X0Y0_IHP_SRAM_top.Inst_IHP_SRAM_top_switch_matrix.WW4BEG6 VPWR VGND sg13g2_mux4_1
X_1014_ Tile_X0Y0_FrameData[8] Tile_X0Y1_FrameStrobe[4] Tile_X0Y0_IHP_SRAM_top.Inst_IHP_SRAM_top_ConfigMem.Inst_frame4_bit8.Q
+ VPWR VGND sg13g2_dlhq_1
XFILLER_97_0 VPWR VGND sg13g2_fill_2
XFILLER_103_203 VPWR VGND sg13g2_fill_1
X_0729_ Tile_X0Y1_IHP_SRAM_bot.Inst_IHP_SRAM_bot_ConfigMem.Inst_frame2_bit20.Q Tile_X0Y1_E1END[0]
+ Tile_X0Y1_EE4END[4] Tile_X0Y1_EE4END[12] Tile_X0Y1_IHP_SRAM_bot.Inst_IHP_SRAM_bot_switch_matrix.J_NS4_BEG12
+ Tile_X0Y1_IHP_SRAM_bot.Inst_IHP_SRAM_bot_ConfigMem.Inst_frame2_bit21.Q net15 VPWR
+ VGND sg13g2_mux4_1
XFILLER_84_142 VPWR VGND sg13g2_fill_1
XFILLER_108_93 VPWR VGND sg13g2_decap_8
X_1701_ Tile_X0Y1_IHP_SRAM_bot.Inst_IHP_SRAM_bot_switch_matrix.W6BEG2 net308 VPWR
+ VGND sg13g2_buf_1
X_1494_ Tile_X0Y0_FrameData[20] net91 VPWR VGND sg13g2_buf_1
X_0514_ Tile_X0Y0_IHP_SRAM_top.Inst_IHP_SRAM_top_ConfigMem.Inst_frame2_bit8.Q Tile_X0Y0_EE4END[5]
+ Tile_X0Y0_EE4END[13] Tile_X0Y0_E6END[5] Tile_X0Y0_IHP_SRAM_top.Inst_IHP_SRAM_top_switch_matrix.J_NS4_BEG5
+ Tile_X0Y0_IHP_SRAM_top.Inst_IHP_SRAM_top_ConfigMem.Inst_frame2_bit9.Q net25 VPWR
+ VGND sg13g2_mux4_1
X_1563_ Tile_X0Y0_IHP_SRAM_top.Inst_IHP_SRAM_top_switch_matrix.W1BEG0 net168 VPWR
+ VGND sg13g2_buf_1
X_1632_ Tile_X0Y1_FrameData[21] net229 VPWR VGND sg13g2_buf_1
X_0376_ Tile_X0Y0_IHP_SRAM_top.Inst_IHP_SRAM_top_ConfigMem.Inst_frame0_bit4.Q Tile_X0Y0_IHP_SRAM_top.Inst_IHP_SRAM_top_switch_matrix.N1END2
+ Tile_X0Y1_N4END[6] Tile_X0Y0_S1END[2] Tile_X0Y0_S4END[2] Tile_X0Y0_IHP_SRAM_top.Inst_IHP_SRAM_top_ConfigMem.Inst_frame0_bit5.Q
+ Tile_X0Y0_IHP_SRAM_top.Inst_IHP_SRAM_top_switch_matrix.J_NS4_BEG14 VPWR VGND sg13g2_mux4_1
XFILLER_66_142 VPWR VGND sg13g2_decap_4
X_0445_ Tile_X0Y0_IHP_SRAM_top.Inst_IHP_SRAM_top_ConfigMem.Inst_frame6_bit24.Q A_DOUT_SRAM17
+ A_DOUT_SRAM25 Tile_X0Y0_IHP_SRAM_top.Inst_IHP_SRAM_top_switch_matrix.J_NS2_BEG1
+ Tile_X0Y0_IHP_SRAM_top.Inst_IHP_SRAM_top_switch_matrix.J_NS2_BEG6 Tile_X0Y0_IHP_SRAM_top.Inst_IHP_SRAM_top_ConfigMem.Inst_frame6_bit25.Q
+ Tile_X0Y0_IHP_SRAM_top.Inst_IHP_SRAM_top_switch_matrix.W2BEGb1 VPWR VGND sg13g2_mux4_1
XFILLER_57_153 VPWR VGND sg13g2_fill_2
XFILLER_79_85 VPWR VGND sg13g2_fill_2
XFILLER_95_215 VPWR VGND sg13g2_fill_1
X_0994_ Tile_X0Y0_FrameData[28] Tile_X0Y1_FrameStrobe[4] Tile_X0Y0_IHP_SRAM_top.Inst_IHP_SRAM_top_ConfigMem.Inst_frame4_bit28.Q
+ VPWR VGND sg13g2_dlhq_1
XFILLER_86_215 VPWR VGND sg13g2_fill_1
X_1477_ Tile_X0Y0_FrameData[3] net104 VPWR VGND sg13g2_buf_1
XFILLER_5_82 VPWR VGND sg13g2_fill_2
X_1546_ Tile_X0Y1_N4END[8] net151 VPWR VGND sg13g2_buf_1
X_1615_ Tile_X0Y1_FrameData[4] net242 VPWR VGND sg13g2_buf_1
X_0359_ Tile_X0Y0_IHP_SRAM_top.Inst_IHP_SRAM_top_ConfigMem.Inst_frame0_bit26.Q Tile_X0Y0_IHP_SRAM_top.Inst_IHP_SRAM_top_ConfigMem.Inst_frame0_bit27.Q
+ Tile_X0Y0_IHP_SRAM_top.Inst_IHP_SRAM_top_switch_matrix.N1END1 _0058_ VPWR VGND sg13g2_nor3_1
X_0428_ Tile_X0Y1_N1END[0] Tile_X0Y1_IHP_SRAM_bot.Inst_IHP_SRAM_bot_ConfigMem.Inst_frame0_bit24.Q
+ Tile_X0Y1_IHP_SRAM_bot.Inst_IHP_SRAM_bot_ConfigMem.Inst_frame0_bit25.Q _0089_ VPWR
+ VGND sg13g2_nor3_1
XFILLER_54_123 VPWR VGND sg13g2_fill_2
XFILLER_108_114 VPWR VGND sg13g2_decap_8
XFILLER_105_94 VPWR VGND sg13g2_decap_8
XFILLER_60_148 VPWR VGND sg13g2_fill_2
XFILLER_81_75 VPWR VGND sg13g2_fill_2
XFILLER_68_215 VPWR VGND sg13g2_fill_1
X_1400_ Tile_X0Y1_FrameData[16] Tile_X0Y1_FrameStrobe[7] Tile_X0Y1_IHP_SRAM_bot.Inst_IHP_SRAM_bot_ConfigMem.Inst_frame7_bit16.Q
+ VPWR VGND sg13g2_dlhq_1
X_1331_ Tile_X0Y1_FrameData[21] Tile_X0Y1_FrameStrobe[5] Tile_X0Y1_IHP_SRAM_bot.Inst_IHP_SRAM_bot_ConfigMem.Inst_frame5_bit21.Q
+ VPWR VGND sg13g2_dlhq_1
X_1262_ Tile_X0Y1_FrameData[26] Tile_X0Y1_FrameStrobe[3] Tile_X0Y1_IHP_SRAM_bot.Inst_IHP_SRAM_bot_ConfigMem.Inst_frame3_bit26.Q
+ VPWR VGND sg13g2_dlhq_1
X_1193_ Tile_X0Y1_FrameData[31] Tile_X0Y1_FrameStrobe[1] Tile_X0Y1_IHP_SRAM_bot.Inst_IHP_SRAM_bot_ConfigMem.Inst_frame1_bit31.Q
+ VPWR VGND sg13g2_dlhq_1
XFILLER_101_19 VPWR VGND sg13g2_decap_8
XFILLER_105_128 VPWR VGND sg13g2_decap_8
X_0977_ Tile_X0Y0_FrameData[13] Tile_X0Y1_FrameStrobe[3] Tile_X0Y0_IHP_SRAM_top.Inst_IHP_SRAM_top_ConfigMem.Inst_frame3_bit13.Q
+ VPWR VGND sg13g2_dlhq_1
Xoutput321 net321 Tile_X0Y1_WW4BEG[14] VPWR VGND sg13g2_buf_1
Xoutput310 net310 Tile_X0Y1_W6BEG[4] VPWR VGND sg13g2_buf_1
X_1529_ Tile_X0Y0_IHP_SRAM_top.Inst_IHP_SRAM_top_switch_matrix.N1BEG3 net134 VPWR
+ VGND sg13g2_buf_1
XFILLER_104_150 VPWR VGND sg13g2_decap_8
XFILLER_92_41 VPWR VGND sg13g2_decap_4
X_0900_ Tile_X0Y0_FrameData[26] Tile_X0Y1_FrameStrobe[1] Tile_X0Y0_IHP_SRAM_top.Inst_IHP_SRAM_top_ConfigMem.Inst_frame1_bit26.Q
+ VPWR VGND sg13g2_dlhq_1
X_0762_ Tile_X0Y1_IHP_SRAM_bot.Inst_IHP_SRAM_bot_switch_matrix.J_NS4_BEG6 Tile_X0Y1_IHP_SRAM_bot.Inst_IHP_SRAM_bot_switch_matrix.J_NS4_BEG10
+ Tile_X0Y1_IHP_SRAM_bot.Inst_IHP_SRAM_bot_ConfigMem.Inst_frame8_bit8.Q _0204_ VPWR
+ VGND sg13g2_mux2_1
X_0831_ Tile_X0Y1_E2MID[0] Tile_X0Y1_IHP_SRAM_bot.Inst_IHP_SRAM_bot_ConfigMem.Inst_frame2_bit28.Q
+ _0267_ VPWR VGND sg13g2_and2_1
X_0693_ Tile_X0Y1_IHP_SRAM_bot.Inst_IHP_SRAM_bot_ConfigMem.Inst_frame4_bit25.Q _0080_
+ _0171_ VPWR VGND Tile_X0Y1_IHP_SRAM_bot.Inst_IHP_SRAM_bot_ConfigMem.Inst_frame4_bit24.Q
+ sg13g2_nand3b_1
X_1314_ Tile_X0Y1_FrameData[6] Tile_X0Y1_FrameStrobe[4] Tile_X0Y1_IHP_SRAM_bot.Inst_IHP_SRAM_bot_ConfigMem.Inst_frame4_bit6.Q
+ VPWR VGND sg13g2_dlhq_1
X_1245_ Tile_X0Y1_FrameData[11] Tile_X0Y1_FrameStrobe[2] Tile_X0Y1_IHP_SRAM_bot.Inst_IHP_SRAM_bot_ConfigMem.Inst_frame2_bit11.Q
+ VPWR VGND sg13g2_dlhq_1
XFILLER_24_104 VPWR VGND sg13g2_fill_1
X_1176_ Tile_X0Y1_FrameData[16] Tile_X0Y1_FrameStrobe[0] Tile_X0Y1_IHP_SRAM_bot.Inst_IHP_SRAM_bot_ConfigMem.Inst_frame0_bit16.Q
+ VPWR VGND sg13g2_dlhq_1
XANTENNA_33 VPWR VGND Tile_X0Y1_FrameStrobe[10] sg13g2_antennanp
XANTENNA_55 VPWR VGND Tile_X0Y1_N2MID[7] sg13g2_antennanp
XANTENNA_11 VPWR VGND A_DOUT_SRAM19 sg13g2_antennanp
XANTENNA_22 VPWR VGND Tile_X0Y0_S2MID[5] sg13g2_antennanp
XANTENNA_44 VPWR VGND Tile_X0Y1_N2END[1] sg13g2_antennanp
Xoutput162 net162 Tile_X0Y0_N4BEG[5] VPWR VGND sg13g2_buf_1
Xoutput151 net151 Tile_X0Y0_N4BEG[0] VPWR VGND sg13g2_buf_1
Xoutput140 net140 Tile_X0Y0_N2BEG[5] VPWR VGND sg13g2_buf_1
Xoutput195 net195 Tile_X0Y0_W6BEG[5] VPWR VGND sg13g2_buf_1
Xoutput184 net184 Tile_X0Y0_W2BEGb[4] VPWR VGND sg13g2_buf_1
Xoutput173 net173 Tile_X0Y0_W2BEG[1] VPWR VGND sg13g2_buf_1
XFILLER_23_170 VPWR VGND sg13g2_fill_2
XFILLER_30_118 VPWR VGND sg13g2_fill_2
XFILLER_62_99 VPWR VGND sg13g2_decap_8
X_1030_ Tile_X0Y0_FrameData[24] Tile_X0Y1_FrameStrobe[5] Tile_X0Y0_IHP_SRAM_top.Inst_IHP_SRAM_top_ConfigMem.Inst_frame5_bit24.Q
+ VPWR VGND sg13g2_dlhq_1
X_0814_ VGND VPWR _0034_ _0250_ _0251_ Tile_X0Y1_IHP_SRAM_bot.Inst_IHP_SRAM_bot_ConfigMem.Inst_frame7_bit17.Q
+ sg13g2_a21oi_1
XFILLER_107_18 VPWR VGND sg13g2_decap_8
X_0676_ Tile_X0Y1_IHP_SRAM_bot.Inst_IHP_SRAM_bot_ConfigMem.Inst_frame4_bit8.Q A_DOUT_SRAM7
+ Tile_X0Y1_IHP_SRAM_bot.Inst_IHP_SRAM_bot_switch_matrix.J_NS4_BEG4 Tile_X0Y1_IHP_SRAM_bot.Inst_IHP_SRAM_bot_switch_matrix.J_NS4_BEG8
+ _0080_ Tile_X0Y1_IHP_SRAM_bot.Inst_IHP_SRAM_bot_ConfigMem.Inst_frame4_bit9.Q Tile_X0Y1_IHP_SRAM_bot.Inst_IHP_SRAM_bot_switch_matrix.W6BEG7
+ VPWR VGND sg13g2_mux4_1
XFILLER_42_0 VPWR VGND sg13g2_decap_8
X_0745_ VPWR _0188_ _0187_ VGND sg13g2_inv_1
XFILLER_96_162 VPWR VGND sg13g2_fill_1
XFILLER_96_151 VPWR VGND sg13g2_fill_2
X_1228_ Tile_X0Y1_FrameData[28] Tile_X0Y1_FrameStrobe[2] Tile_X0Y1_IHP_SRAM_bot.Inst_IHP_SRAM_bot_ConfigMem.Inst_frame2_bit28.Q
+ VPWR VGND sg13g2_dlhq_1
X_1159_ Tile_X0Y0_FrameData[23] Tile_X0Y1_FrameStrobe[9] Tile_X0Y0_IHP_SRAM_top.Inst_IHP_SRAM_top_ConfigMem.Inst_frame9_bit23.Q
+ VPWR VGND sg13g2_dlhq_1
XFILLER_32_47 VPWR VGND sg13g2_decap_8
XFILLER_73_76 VPWR VGND sg13g2_fill_1
XFILLER_11_151 VPWR VGND sg13g2_decap_4
XFILLER_98_51 VPWR VGND sg13g2_decap_4
X_0530_ VPWR VGND Tile_X0Y0_IHP_SRAM_top.Inst_IHP_SRAM_top_ConfigMem.Inst_frame1_bit0.Q
+ _0094_ _0095_ Tile_X0Y0_IHP_SRAM_top.Inst_IHP_SRAM_top_ConfigMem.Inst_frame1_bit1.Q
+ net7 _0039_ sg13g2_a221oi_1
X_0392_ Tile_X0Y0_IHP_SRAM_top.Inst_IHP_SRAM_top_ConfigMem.Inst_frame0_bit11.Q Tile_X0Y0_IHP_SRAM_top.Inst_IHP_SRAM_top_switch_matrix.N2BEGb1
+ Tile_X0Y0_S2MID[1] Tile_X0Y1_N2MID[1] Tile_X0Y0_S2END[1] Tile_X0Y0_IHP_SRAM_top.Inst_IHP_SRAM_top_ConfigMem.Inst_frame0_bit10.Q
+ Tile_X0Y0_IHP_SRAM_top.Inst_IHP_SRAM_top_switch_matrix.J_NS2_BEG1 VPWR VGND sg13g2_mux4_1
X_0461_ Tile_X0Y0_IHP_SRAM_top.Inst_IHP_SRAM_top_ConfigMem.Inst_frame1_bit26.Q Tile_X0Y0_IHP_SRAM_top.Inst_IHP_SRAM_top_switch_matrix.N1END1
+ Tile_X0Y1_N4END[5] Tile_X0Y0_S1END[1] Tile_X0Y0_S4END[1] Tile_X0Y0_IHP_SRAM_top.Inst_IHP_SRAM_top_ConfigMem.Inst_frame1_bit27.Q
+ Tile_X0Y0_IHP_SRAM_top.Inst_IHP_SRAM_top_switch_matrix.J_NS4_BEG9 VPWR VGND sg13g2_mux4_1
X_1013_ Tile_X0Y0_FrameData[9] Tile_X0Y1_FrameStrobe[4] Tile_X0Y0_IHP_SRAM_top.Inst_IHP_SRAM_top_ConfigMem.Inst_frame4_bit9.Q
+ VPWR VGND sg13g2_dlhq_1
XFILLER_34_210 VPWR VGND sg13g2_fill_2
XFILLER_69_151 VPWR VGND sg13g2_fill_2
X_0659_ Tile_X0Y1_IHP_SRAM_bot.Inst_IHP_SRAM_bot_ConfigMem.Inst_frame1_bit16.Q Tile_X0Y1_N1END[0]
+ Tile_X0Y1_N4END[0] _0088_ Tile_X0Y0_S4END[4] Tile_X0Y1_IHP_SRAM_bot.Inst_IHP_SRAM_bot_ConfigMem.Inst_frame1_bit17.Q
+ Tile_X0Y1_IHP_SRAM_bot.Inst_IHP_SRAM_bot_switch_matrix.J_NS4_BEG4 VPWR VGND sg13g2_mux4_1
X_0728_ Tile_X0Y1_IHP_SRAM_bot.Inst_IHP_SRAM_bot_ConfigMem.Inst_frame2_bit18.Q Tile_X0Y1_EE4END[3]
+ Tile_X0Y1_EE4END[11] Tile_X0Y1_E6END[11] Tile_X0Y1_IHP_SRAM_bot.Inst_IHP_SRAM_bot_switch_matrix.J_NS4_BEG11
+ Tile_X0Y1_IHP_SRAM_bot.Inst_IHP_SRAM_bot_ConfigMem.Inst_frame2_bit19.Q net14 VPWR
+ VGND sg13g2_mux4_1
XFILLER_43_79 VPWR VGND sg13g2_fill_1
XFILLER_108_72 VPWR VGND sg13g2_decap_8
XFILLER_84_53 VPWR VGND sg13g2_fill_1
XFILLER_84_42 VPWR VGND sg13g2_fill_2
X_1700_ Tile_X0Y1_IHP_SRAM_bot.Inst_IHP_SRAM_bot_switch_matrix.W6BEG1 net307 VPWR
+ VGND sg13g2_buf_1
X_1631_ Tile_X0Y1_FrameData[20] net228 VPWR VGND sg13g2_buf_1
X_1562_ clknet_1_1__leaf_Tile_X0Y1_UserCLK net167 VPWR VGND sg13g2_buf_1
X_1493_ Tile_X0Y0_FrameData[19] net89 VPWR VGND sg13g2_buf_1
X_0513_ Tile_X0Y0_IHP_SRAM_top.Inst_IHP_SRAM_top_ConfigMem.Inst_frame2_bit6.Q Tile_X0Y0_EE4END[4]
+ Tile_X0Y0_EE4END[12] Tile_X0Y0_E6END[4] Tile_X0Y0_IHP_SRAM_top.Inst_IHP_SRAM_top_switch_matrix.J_NS4_BEG4
+ Tile_X0Y0_IHP_SRAM_top.Inst_IHP_SRAM_top_ConfigMem.Inst_frame2_bit7.Q net24 VPWR
+ VGND sg13g2_mux4_1
X_0444_ Tile_X0Y0_IHP_SRAM_top.Inst_IHP_SRAM_top_ConfigMem.Inst_frame6_bit22.Q A_DOUT_SRAM16
+ A_DOUT_SRAM24 Tile_X0Y0_IHP_SRAM_top.Inst_IHP_SRAM_top_switch_matrix.J_NS2_BEG0
+ Tile_X0Y0_IHP_SRAM_top.Inst_IHP_SRAM_top_switch_matrix.J_NS2_BEG7 Tile_X0Y0_IHP_SRAM_top.Inst_IHP_SRAM_top_ConfigMem.Inst_frame6_bit23.Q
+ Tile_X0Y0_IHP_SRAM_top.Inst_IHP_SRAM_top_switch_matrix.W2BEGb0 VPWR VGND sg13g2_mux4_1
XFILLER_3_180 VPWR VGND sg13g2_decap_8
XFILLER_81_135 VPWR VGND sg13g2_fill_2
XFILLER_81_113 VPWR VGND sg13g2_fill_1
X_0375_ Tile_X0Y1_IHP_SRAM_bot.Inst_IHP_SRAM_bot_ConfigMem.Inst_frame9_bit15.Q Tile_X0Y1_E1END[2]
+ Tile_X0Y1_IHP_SRAM_bot.Inst_IHP_SRAM_bot_switch_matrix.J_NS4_BEG14 Tile_X0Y1_E6END[6]
+ _0070_ Tile_X0Y1_IHP_SRAM_bot.Inst_IHP_SRAM_bot_ConfigMem.Inst_frame9_bit14.Q Tile_X0Y0_IHP_SRAM_top.Inst_IHP_SRAM_top_switch_matrix.N1END2
+ VPWR VGND sg13g2_mux4_1
XFILLER_57_176 VPWR VGND sg13g2_decap_8
XFILLER_54_12 VPWR VGND sg13g2_fill_2
XFILLER_110_95 VPWR VGND sg13g2_fill_2
XFILLER_70_33 VPWR VGND sg13g2_fill_2
XFILLER_95_74 VPWR VGND sg13g2_fill_1
X_0993_ Tile_X0Y0_FrameData[29] Tile_X0Y1_FrameStrobe[4] Tile_X0Y0_IHP_SRAM_top.Inst_IHP_SRAM_top_ConfigMem.Inst_frame4_bit29.Q
+ VPWR VGND sg13g2_dlhq_1
XFILLER_63_179 VPWR VGND sg13g2_decap_8
X_1614_ Tile_X0Y1_FrameData[3] net241 VPWR VGND sg13g2_buf_1
X_1545_ Tile_X0Y0_IHP_SRAM_top.Inst_IHP_SRAM_top_switch_matrix.N2BEGb7 net150 VPWR
+ VGND sg13g2_buf_1
X_0427_ Tile_X0Y0_IHP_SRAM_top.Inst_IHP_SRAM_top_ConfigMem.Inst_frame8_bit27.Q Tile_X0Y0_E1END[0]
+ Tile_X0Y0_IHP_SRAM_top.Inst_IHP_SRAM_top_switch_matrix.J_NS4_BEG12 Tile_X0Y0_E6END[8]
+ _0087_ Tile_X0Y0_IHP_SRAM_top.Inst_IHP_SRAM_top_ConfigMem.Inst_frame8_bit26.Q _0088_
+ VPWR VGND sg13g2_mux4_1
X_1476_ Tile_X0Y0_FrameData[2] net101 VPWR VGND sg13g2_buf_1
X_0358_ _0057_ Tile_X0Y0_S1END[1] Tile_X0Y0_IHP_SRAM_top.Inst_IHP_SRAM_top_ConfigMem.Inst_frame0_bit26.Q
+ VPWR VGND sg13g2_nand2b_1
XFILLER_40_36 VPWR VGND sg13g2_fill_2
XFILLER_105_73 VPWR VGND sg13g2_decap_8
XFILLER_49_89 VPWR VGND sg13g2_fill_2
X_1330_ Tile_X0Y1_FrameData[22] Tile_X0Y1_FrameStrobe[5] Tile_X0Y1_IHP_SRAM_bot.Inst_IHP_SRAM_bot_ConfigMem.Inst_frame5_bit22.Q
+ VPWR VGND sg13g2_dlhq_1
X_1261_ Tile_X0Y1_FrameData[27] Tile_X0Y1_FrameStrobe[3] Tile_X0Y1_IHP_SRAM_bot.Inst_IHP_SRAM_bot_ConfigMem.Inst_frame3_bit27.Q
+ VPWR VGND sg13g2_dlhq_1
XFILLER_46_7 VPWR VGND sg13g2_decap_4
X_1192_ Tile_X0Y1_FrameData[0] Tile_X0Y1_FrameStrobe[0] Tile_X0Y1_IHP_SRAM_bot.Inst_IHP_SRAM_bot_ConfigMem.Inst_frame0_bit0.Q
+ VPWR VGND sg13g2_dlhq_1
XFILLER_36_157 VPWR VGND sg13g2_fill_2
X_0976_ Tile_X0Y0_FrameData[14] Tile_X0Y1_FrameStrobe[3] Tile_X0Y0_IHP_SRAM_top.Inst_IHP_SRAM_top_ConfigMem.Inst_frame3_bit14.Q
+ VPWR VGND sg13g2_dlhq_1
XFILLER_72_0 VPWR VGND sg13g2_fill_1
Xoutput300 net300 Tile_X0Y1_W2BEGb[4] VPWR VGND sg13g2_buf_1
Xoutput311 net311 Tile_X0Y1_W6BEG[5] VPWR VGND sg13g2_buf_1
Xoutput322 net322 Tile_X0Y1_WW4BEG[15] VPWR VGND sg13g2_buf_1
X_1528_ Tile_X0Y0_IHP_SRAM_top.Inst_IHP_SRAM_top_switch_matrix.N1BEG2 net133 VPWR
+ VGND sg13g2_buf_1
X_1459_ Tile_X0Y1_FrameData[21] Tile_X0Y1_FrameStrobe[9] Tile_X0Y1_IHP_SRAM_bot.Inst_IHP_SRAM_bot_ConfigMem.Inst_frame9_bit21.Q
+ VPWR VGND sg13g2_dlhq_1
XFILLER_92_64 VPWR VGND sg13g2_decap_4
X_0830_ _0265_ VPWR _0266_ VGND _0000_ Tile_X0Y1_IHP_SRAM_bot.Inst_IHP_SRAM_bot_ConfigMem.Inst_frame2_bit28.Q
+ sg13g2_o21ai_1
X_0692_ _0168_ VPWR net3 VGND Tile_X0Y1_IHP_SRAM_bot.Inst_IHP_SRAM_bot_ConfigMem.Inst_frame4_bit23.Q
+ _0170_ sg13g2_o21ai_1
X_0761_ Tile_X0Y1_IHP_SRAM_bot.Inst_IHP_SRAM_bot_ConfigMem.Inst_frame8_bit9.Q VPWR
+ _0203_ VGND Tile_X0Y1_IHP_SRAM_bot.Inst_IHP_SRAM_bot_ConfigMem.Inst_frame8_bit8.Q
+ Tile_X0Y1_IHP_SRAM_bot.Inst_IHP_SRAM_bot_switch_matrix.J_NS4_BEG14 sg13g2_o21ai_1
X_1313_ Tile_X0Y1_FrameData[7] Tile_X0Y1_FrameStrobe[4] Tile_X0Y1_IHP_SRAM_bot.Inst_IHP_SRAM_bot_ConfigMem.Inst_frame4_bit7.Q
+ VPWR VGND sg13g2_dlhq_1
X_1244_ Tile_X0Y1_FrameData[12] Tile_X0Y1_FrameStrobe[2] Tile_X0Y1_IHP_SRAM_bot.Inst_IHP_SRAM_bot_ConfigMem.Inst_frame2_bit12.Q
+ VPWR VGND sg13g2_dlhq_1
X_1175_ Tile_X0Y1_FrameData[17] Tile_X0Y1_FrameStrobe[0] Tile_X0Y1_IHP_SRAM_bot.Inst_IHP_SRAM_bot_ConfigMem.Inst_frame0_bit17.Q
+ VPWR VGND sg13g2_dlhq_1
XANTENNA_34 VPWR VGND Tile_X0Y1_FrameStrobe[11] sg13g2_antennanp
X_0959_ Tile_X0Y0_FrameData[31] Tile_X0Y1_FrameStrobe[3] Tile_X0Y0_IHP_SRAM_top.Inst_IHP_SRAM_top_ConfigMem.Inst_frame3_bit31.Q
+ VPWR VGND sg13g2_dlhq_1
XANTENNA_23 VPWR VGND Tile_X0Y0_S2MID[5] sg13g2_antennanp
XANTENNA_12 VPWR VGND A_DOUT_SRAM19 sg13g2_antennanp
XANTENNA_56 VPWR VGND Tile_X0Y1_N2MID[7] sg13g2_antennanp
XANTENNA_45 VPWR VGND Tile_X0Y1_N2END[4] sg13g2_antennanp
Xoutput130 net130 Tile_X0Y0_FrameStrobe_O[9] VPWR VGND sg13g2_buf_1
Xoutput152 net152 Tile_X0Y0_N4BEG[10] VPWR VGND sg13g2_buf_1
Xoutput163 net163 Tile_X0Y0_N4BEG[6] VPWR VGND sg13g2_buf_1
Xoutput141 net141 Tile_X0Y0_N2BEG[6] VPWR VGND sg13g2_buf_1
Xoutput196 net196 Tile_X0Y0_W6BEG[6] VPWR VGND sg13g2_buf_1
Xoutput185 net185 Tile_X0Y0_W2BEGb[5] VPWR VGND sg13g2_buf_1
Xoutput174 net174 Tile_X0Y0_W2BEG[2] VPWR VGND sg13g2_buf_1
XFILLER_70_211 VPWR VGND sg13g2_fill_1
XFILLER_16_8 VPWR VGND sg13g2_fill_1
X_0813_ Tile_X0Y1_E1END[3] Tile_X0Y1_EE4END[15] Tile_X0Y1_IHP_SRAM_bot.Inst_IHP_SRAM_bot_ConfigMem.Inst_frame7_bit15.Q
+ _0250_ VPWR VGND sg13g2_mux2_1
X_0675_ Tile_X0Y1_IHP_SRAM_bot.Inst_IHP_SRAM_bot_ConfigMem.Inst_frame4_bit6.Q A_DOUT_SRAM6
+ Tile_X0Y1_IHP_SRAM_bot.Inst_IHP_SRAM_bot_switch_matrix.J_NS4_BEG5 Tile_X0Y1_IHP_SRAM_bot.Inst_IHP_SRAM_bot_switch_matrix.J_NS4_BEG9
+ _0079_ Tile_X0Y1_IHP_SRAM_bot.Inst_IHP_SRAM_bot_ConfigMem.Inst_frame4_bit7.Q Tile_X0Y1_IHP_SRAM_bot.Inst_IHP_SRAM_bot_switch_matrix.W6BEG6
+ VPWR VGND sg13g2_mux4_1
XFILLER_35_0 VPWR VGND sg13g2_fill_1
X_0744_ Tile_X0Y1_IHP_SRAM_bot.Inst_IHP_SRAM_bot_ConfigMem.Inst_frame8_bit6.Q VPWR
+ _0187_ VGND Tile_X0Y1_E6END[9] Tile_X0Y1_IHP_SRAM_bot.Inst_IHP_SRAM_bot_ConfigMem.Inst_frame8_bit5.Q
+ sg13g2_o21ai_1
XFILLER_96_185 VPWR VGND sg13g2_fill_2
X_1158_ Tile_X0Y0_FrameData[24] Tile_X0Y1_FrameStrobe[9] Tile_X0Y0_IHP_SRAM_top.Inst_IHP_SRAM_top_ConfigMem.Inst_frame9_bit24.Q
+ VPWR VGND sg13g2_dlhq_1
X_1227_ Tile_X0Y1_FrameData[29] Tile_X0Y1_FrameStrobe[2] Tile_X0Y1_IHP_SRAM_bot.Inst_IHP_SRAM_bot_ConfigMem.Inst_frame2_bit29.Q
+ VPWR VGND sg13g2_dlhq_1
X_1089_ Tile_X0Y0_FrameData[29] Tile_X0Y1_FrameStrobe[7] Tile_X0Y0_IHP_SRAM_top.Inst_IHP_SRAM_top_ConfigMem.Inst_frame7_bit29.Q
+ VPWR VGND sg13g2_dlhq_1
XFILLER_12_119 VPWR VGND sg13g2_decap_8
XFILLER_87_141 VPWR VGND sg13g2_fill_2
XFILLER_57_45 VPWR VGND sg13g2_decap_4
X_0460_ Tile_X0Y0_IHP_SRAM_top.Inst_IHP_SRAM_top_ConfigMem.Inst_frame5_bit16.Q A_DOUT_SRAM21
+ A_DOUT_SRAM24 Tile_X0Y0_IHP_SRAM_top.Inst_IHP_SRAM_top_switch_matrix.J_NS4_BEG10
+ Tile_X0Y0_IHP_SRAM_top.Inst_IHP_SRAM_top_switch_matrix.J_NS2_BEG2 Tile_X0Y0_IHP_SRAM_top.Inst_IHP_SRAM_top_ConfigMem.Inst_frame5_bit17.Q
+ Tile_X0Y0_IHP_SRAM_top.Inst_IHP_SRAM_top_switch_matrix.WW4BEG5 VPWR VGND sg13g2_mux4_1
XFILLER_78_130 VPWR VGND sg13g2_decap_4
X_1012_ Tile_X0Y0_FrameData[10] Tile_X0Y1_FrameStrobe[4] Tile_X0Y0_IHP_SRAM_top.Inst_IHP_SRAM_top_ConfigMem.Inst_frame4_bit10.Q
+ VPWR VGND sg13g2_dlhq_1
X_0391_ Tile_X0Y1_IHP_SRAM_bot.Inst_IHP_SRAM_bot_ConfigMem.Inst_frame9_bit20.Q Tile_X0Y1_E2MID[6]
+ Tile_X0Y1_E2END[6] Tile_X0Y1_E6END[6] _0078_ Tile_X0Y1_IHP_SRAM_bot.Inst_IHP_SRAM_bot_ConfigMem.Inst_frame9_bit21.Q
+ Tile_X0Y0_IHP_SRAM_top.Inst_IHP_SRAM_top_switch_matrix.N2BEGb1 VPWR VGND sg13g2_mux4_1
X_0727_ Tile_X0Y1_IHP_SRAM_bot.Inst_IHP_SRAM_bot_ConfigMem.Inst_frame2_bit16.Q Tile_X0Y1_EE4END[2]
+ Tile_X0Y1_EE4END[10] Tile_X0Y1_E6END[10] Tile_X0Y1_IHP_SRAM_bot.Inst_IHP_SRAM_bot_switch_matrix.J_NS4_BEG10
+ Tile_X0Y1_IHP_SRAM_bot.Inst_IHP_SRAM_bot_ConfigMem.Inst_frame2_bit17.Q net13 VPWR
+ VGND sg13g2_mux4_1
X_0658_ Tile_X0Y1_IHP_SRAM_bot.Inst_IHP_SRAM_bot_ConfigMem.Inst_frame5_bit14.Q A_DOUT_SRAM6
+ A_DOUT_SRAM10 Tile_X0Y1_IHP_SRAM_bot.Inst_IHP_SRAM_bot_switch_matrix.J_NS4_BEG5
+ _0082_ Tile_X0Y1_IHP_SRAM_bot.Inst_IHP_SRAM_bot_ConfigMem.Inst_frame5_bit15.Q Tile_X0Y1_IHP_SRAM_bot.Inst_IHP_SRAM_bot_switch_matrix.WW4BEG10
+ VPWR VGND sg13g2_mux4_1
X_0589_ Tile_X0Y0_IHP_SRAM_top.Inst_IHP_SRAM_top_switch_matrix.J_NS2_BEG6 Tile_X0Y0_IHP_SRAM_top.Inst_IHP_SRAM_top_ConfigMem.Inst_frame7_bit24.Q
+ _0145_ VPWR VGND sg13g2_nor2b_1
XFILLER_84_122 VPWR VGND sg13g2_fill_1
XFILLER_108_51 VPWR VGND sg13g2_decap_8
XFILLER_83_8 VPWR VGND sg13g2_fill_2
XFILLER_33_80 VPWR VGND sg13g2_fill_2
X_1630_ Tile_X0Y1_FrameData[19] net226 VPWR VGND sg13g2_buf_1
X_1561_ Tile_X0Y0_IHP_SRAM_top.Inst_IHP_SRAM_top_switch_matrix.N4BEG3 net157 VPWR
+ VGND sg13g2_buf_1
X_1492_ Tile_X0Y0_FrameData[18] net88 VPWR VGND sg13g2_buf_1
X_0512_ Tile_X0Y0_IHP_SRAM_top.Inst_IHP_SRAM_top_ConfigMem.Inst_frame2_bit4.Q Tile_X0Y0_EE4END[3]
+ Tile_X0Y0_EE4END[11] Tile_X0Y0_E6END[3] Tile_X0Y0_IHP_SRAM_top.Inst_IHP_SRAM_top_switch_matrix.J_NS4_BEG3
+ Tile_X0Y0_IHP_SRAM_top.Inst_IHP_SRAM_top_ConfigMem.Inst_frame2_bit5.Q net22 VPWR
+ VGND sg13g2_mux4_1
X_0443_ Tile_X0Y0_IHP_SRAM_top.Inst_IHP_SRAM_top_ConfigMem.Inst_frame6_bit20.Q A_DOUT_SRAM23
+ A_DOUT_SRAM31 Tile_X0Y0_IHP_SRAM_top.Inst_IHP_SRAM_top_switch_matrix.J_NS2_BEG0
+ Tile_X0Y0_IHP_SRAM_top.Inst_IHP_SRAM_top_switch_matrix.J_NS2_BEG7 Tile_X0Y0_IHP_SRAM_top.Inst_IHP_SRAM_top_ConfigMem.Inst_frame6_bit21.Q
+ Tile_X0Y0_IHP_SRAM_top.Inst_IHP_SRAM_top_switch_matrix.W2BEG7 VPWR VGND sg13g2_mux4_1
X_0374_ VPWR VGND _0069_ _0068_ Tile_X0Y1_IHP_SRAM_bot.Inst_IHP_SRAM_bot_ConfigMem.Inst_frame0_bit29.Q
+ _0008_ _0070_ Tile_X0Y1_IHP_SRAM_bot.Inst_IHP_SRAM_bot_ConfigMem.Inst_frame0_bit28.Q
+ sg13g2_a221oi_1
XFILLER_38_58 VPWR VGND sg13g2_decap_8
XFILLER_72_147 VPWR VGND sg13g2_decap_4
XFILLER_72_125 VPWR VGND sg13g2_fill_1
XFILLER_102_0 VPWR VGND sg13g2_decap_4
XFILLER_48_199 VPWR VGND sg13g2_fill_1
X_0992_ Tile_X0Y0_FrameData[30] Tile_X0Y1_FrameStrobe[4] Tile_X0Y0_IHP_SRAM_top.Inst_IHP_SRAM_top_ConfigMem.Inst_frame4_bit30.Q
+ VPWR VGND sg13g2_dlhq_1
X_1544_ Tile_X0Y0_IHP_SRAM_top.Inst_IHP_SRAM_top_switch_matrix.N2BEGb6 net149 VPWR
+ VGND sg13g2_buf_1
X_1613_ Tile_X0Y1_FrameData[2] net238 VPWR VGND sg13g2_buf_1
X_0426_ VPWR VGND _0085_ _0086_ Tile_X0Y0_IHP_SRAM_top.Inst_IHP_SRAM_top_ConfigMem.Inst_frame0_bit25.Q
+ _0006_ _0087_ Tile_X0Y0_IHP_SRAM_top.Inst_IHP_SRAM_top_ConfigMem.Inst_frame0_bit24.Q
+ sg13g2_a221oi_1
X_1475_ Tile_X0Y0_FrameData[1] net90 VPWR VGND sg13g2_buf_1
X_0357_ VGND VPWR Tile_X0Y1_IHP_SRAM_bot.Inst_IHP_SRAM_bot_ConfigMem.Inst_frame1_bit3.Q
+ _0052_ net76 _0056_ sg13g2_a21oi_1
XFILLER_54_125 VPWR VGND sg13g2_fill_1
XFILLER_108_149 VPWR VGND sg13g2_decap_8
XFILLER_105_52 VPWR VGND sg13g2_decap_8
XFILLER_45_136 VPWR VGND sg13g2_decap_4
XFILLER_81_99 VPWR VGND sg13g2_decap_8
XFILLER_81_77 VPWR VGND sg13g2_fill_1
X_1191_ Tile_X0Y1_FrameData[1] Tile_X0Y1_FrameStrobe[0] Tile_X0Y1_IHP_SRAM_bot.Inst_IHP_SRAM_bot_ConfigMem.Inst_frame0_bit1.Q
+ VPWR VGND sg13g2_dlhq_1
X_1260_ Tile_X0Y1_FrameData[28] Tile_X0Y1_FrameStrobe[3] Tile_X0Y1_IHP_SRAM_bot.Inst_IHP_SRAM_bot_ConfigMem.Inst_frame3_bit28.Q
+ VPWR VGND sg13g2_dlhq_1
X_0975_ Tile_X0Y0_FrameData[15] Tile_X0Y1_FrameStrobe[3] Tile_X0Y0_IHP_SRAM_top.Inst_IHP_SRAM_top_ConfigMem.Inst_frame3_bit15.Q
+ VPWR VGND sg13g2_dlhq_1
X_1527_ Tile_X0Y0_IHP_SRAM_top.Inst_IHP_SRAM_top_switch_matrix.N1BEG1 net132 VPWR
+ VGND sg13g2_buf_1
Xoutput301 net301 Tile_X0Y1_W2BEGb[5] VPWR VGND sg13g2_buf_1
Xoutput312 net312 Tile_X0Y1_W6BEG[6] VPWR VGND sg13g2_buf_1
Xoutput323 net323 Tile_X0Y1_WW4BEG[1] VPWR VGND sg13g2_buf_1
X_0409_ Tile_X0Y0_IHP_SRAM_top.Inst_IHP_SRAM_top_ConfigMem.Inst_frame7_bit12.Q Tile_X0Y0_E1END[1]
+ Tile_X0Y0_E2MID[2] Tile_X0Y0_E2END[2] Tile_X0Y0_IHP_SRAM_top.Inst_IHP_SRAM_top_switch_matrix.J_NS2_BEG5
+ Tile_X0Y0_IHP_SRAM_top.Inst_IHP_SRAM_top_ConfigMem.Inst_frame7_bit13.Q Tile_X0Y0_IHP_SRAM_top.Inst_IHP_SRAM_top_switch_matrix.S2BEG5
+ VPWR VGND sg13g2_mux4_1
X_1389_ Tile_X0Y1_FrameData[27] Tile_X0Y1_FrameStrobe[7] Tile_X0Y1_IHP_SRAM_bot.Inst_IHP_SRAM_bot_ConfigMem.Inst_frame7_bit27.Q
+ VPWR VGND sg13g2_dlhq_1
X_1458_ Tile_X0Y1_FrameData[22] Tile_X0Y1_FrameStrobe[9] Tile_X0Y1_IHP_SRAM_bot.Inst_IHP_SRAM_bot_ConfigMem.Inst_frame9_bit22.Q
+ VPWR VGND sg13g2_dlhq_1
XFILLER_42_128 VPWR VGND sg13g2_fill_2
XFILLER_51_36 VPWR VGND sg13g2_fill_1
XFILLER_2_202 VPWR VGND sg13g2_decap_8
XFILLER_51_58 VPWR VGND sg13g2_fill_2
XFILLER_104_185 VPWR VGND sg13g2_decap_8
XFILLER_76_66 VPWR VGND sg13g2_fill_2
XFILLER_4_4 VPWR VGND sg13g2_fill_2
XFILLER_25_70 VPWR VGND sg13g2_decap_4
X_0760_ _0023_ _0079_ _0202_ VPWR VGND sg13g2_nor2_1
X_0691_ VGND VPWR Tile_X0Y1_E2END[2] Tile_X0Y1_IHP_SRAM_bot.Inst_IHP_SRAM_bot_ConfigMem.Inst_frame4_bit22.Q
+ _0170_ _0169_ sg13g2_a21oi_1
XFILLER_41_80 VPWR VGND sg13g2_decap_8
XFILLER_41_91 VPWR VGND sg13g2_fill_2
XFILLER_110_133 VPWR VGND sg13g2_decap_4
X_1312_ Tile_X0Y1_FrameData[8] Tile_X0Y1_FrameStrobe[4] Tile_X0Y1_IHP_SRAM_bot.Inst_IHP_SRAM_bot_ConfigMem.Inst_frame4_bit8.Q
+ VPWR VGND sg13g2_dlhq_1
X_1174_ Tile_X0Y1_FrameData[18] Tile_X0Y1_FrameStrobe[0] Tile_X0Y1_IHP_SRAM_bot.Inst_IHP_SRAM_bot_ConfigMem.Inst_frame0_bit18.Q
+ VPWR VGND sg13g2_dlhq_1
X_1243_ Tile_X0Y1_FrameData[13] Tile_X0Y1_FrameStrobe[2] Tile_X0Y1_IHP_SRAM_bot.Inst_IHP_SRAM_bot_ConfigMem.Inst_frame2_bit13.Q
+ VPWR VGND sg13g2_dlhq_1
XANTENNA_13 VPWR VGND A_DOUT_SRAM19 sg13g2_antennanp
XFILLER_17_191 VPWR VGND sg13g2_fill_1
XFILLER_32_172 VPWR VGND sg13g2_fill_1
XANTENNA_35 VPWR VGND Tile_X0Y1_FrameStrobe[14] sg13g2_antennanp
XANTENNA_57 VPWR VGND Tile_X0Y1_N2MID[7] sg13g2_antennanp
X_0889_ Tile_X0Y0_FrameData[5] Tile_X0Y1_FrameStrobe[0] Tile_X0Y0_IHP_SRAM_top.Inst_IHP_SRAM_top_ConfigMem.Inst_frame0_bit5.Q
+ VPWR VGND sg13g2_dlhq_1
X_0958_ Tile_X0Y0_FrameData[0] Tile_X0Y1_FrameStrobe[2] Tile_X0Y0_IHP_SRAM_top.Inst_IHP_SRAM_top_ConfigMem.Inst_frame2_bit0.Q
+ VPWR VGND sg13g2_dlhq_1
XANTENNA_24 VPWR VGND Tile_X0Y0_S2MID[5] sg13g2_antennanp
XFILLER_32_194 VPWR VGND sg13g2_fill_1
XANTENNA_46 VPWR VGND Tile_X0Y1_N2END[6] sg13g2_antennanp
Xoutput153 net153 Tile_X0Y0_N4BEG[11] VPWR VGND sg13g2_buf_1
Xoutput142 net142 Tile_X0Y0_N2BEG[7] VPWR VGND sg13g2_buf_1
Xoutput120 net120 Tile_X0Y0_FrameStrobe_O[18] VPWR VGND sg13g2_buf_1
Xoutput164 net164 Tile_X0Y0_N4BEG[7] VPWR VGND sg13g2_buf_1
Xoutput131 net131 Tile_X0Y0_N1BEG[0] VPWR VGND sg13g2_buf_1
XFILLER_101_122 VPWR VGND sg13g2_fill_1
Xoutput197 net197 Tile_X0Y0_W6BEG[7] VPWR VGND sg13g2_buf_1
Xoutput186 net186 Tile_X0Y0_W2BEGb[6] VPWR VGND sg13g2_buf_1
Xoutput175 net175 Tile_X0Y0_W2BEG[3] VPWR VGND sg13g2_buf_1
XFILLER_101_188 VPWR VGND sg13g2_decap_8
XFILLER_23_172 VPWR VGND sg13g2_fill_1
XFILLER_23_194 VPWR VGND sg13g2_fill_1
X_0812_ _0248_ VPWR _0249_ VGND _0033_ _0158_ sg13g2_o21ai_1
X_0743_ VGND VPWR _0179_ _0181_ Tile_X0Y0_IHP_SRAM_top.N4BEG_outbuf_8.A _0186_ sg13g2_a21oi_1
X_0674_ Tile_X0Y1_IHP_SRAM_bot.Inst_IHP_SRAM_bot_ConfigMem.Inst_frame4_bit5.Q A_DOUT_SRAM5
+ Tile_X0Y1_IHP_SRAM_bot.Inst_IHP_SRAM_bot_switch_matrix.J_NS4_BEG10 Tile_X0Y1_IHP_SRAM_bot.Inst_IHP_SRAM_bot_switch_matrix.J_NS4_BEG6
+ _0078_ Tile_X0Y1_IHP_SRAM_bot.Inst_IHP_SRAM_bot_ConfigMem.Inst_frame4_bit4.Q Tile_X0Y1_IHP_SRAM_bot.Inst_IHP_SRAM_bot_switch_matrix.W6BEG5
+ VPWR VGND sg13g2_mux4_1
XFILLER_28_0 VPWR VGND sg13g2_decap_8
X_1157_ Tile_X0Y0_FrameData[25] Tile_X0Y1_FrameStrobe[9] Tile_X0Y0_IHP_SRAM_top.Inst_IHP_SRAM_top_ConfigMem.Inst_frame9_bit25.Q
+ VPWR VGND sg13g2_dlhq_1
X_1226_ Tile_X0Y1_FrameData[30] Tile_X0Y1_FrameStrobe[2] Tile_X0Y1_IHP_SRAM_bot.Inst_IHP_SRAM_bot_ConfigMem.Inst_frame2_bit30.Q
+ VPWR VGND sg13g2_dlhq_1
X_1088_ Tile_X0Y0_FrameData[30] Tile_X0Y1_FrameStrobe[7] Tile_X0Y0_IHP_SRAM_top.Inst_IHP_SRAM_top_ConfigMem.Inst_frame7_bit30.Q
+ VPWR VGND sg13g2_dlhq_1
XFILLER_11_120 VPWR VGND sg13g2_decap_8
X_0390_ Tile_X0Y1_IHP_SRAM_bot.Inst_IHP_SRAM_bot_ConfigMem.Inst_frame0_bit10.Q Tile_X0Y1_N2MID[1]
+ Tile_X0Y1_N2END[1] Tile_X0Y0_IHP_SRAM_top.Inst_IHP_SRAM_top_switch_matrix.S2BEG1
+ Tile_X0Y0_S2MID[1] Tile_X0Y1_IHP_SRAM_bot.Inst_IHP_SRAM_bot_ConfigMem.Inst_frame0_bit11.Q
+ _0078_ VPWR VGND sg13g2_mux4_1
XFILLER_78_164 VPWR VGND sg13g2_fill_1
X_1011_ Tile_X0Y0_FrameData[11] Tile_X0Y1_FrameStrobe[4] Tile_X0Y0_IHP_SRAM_top.Inst_IHP_SRAM_top_ConfigMem.Inst_frame4_bit11.Q
+ VPWR VGND sg13g2_dlhq_1
X_0726_ Tile_X0Y1_IHP_SRAM_bot.Inst_IHP_SRAM_bot_ConfigMem.Inst_frame2_bit14.Q Tile_X0Y1_EE4END[1]
+ Tile_X0Y1_EE4END[9] Tile_X0Y1_E6END[9] Tile_X0Y1_IHP_SRAM_bot.Inst_IHP_SRAM_bot_switch_matrix.J_NS4_BEG9
+ Tile_X0Y1_IHP_SRAM_bot.Inst_IHP_SRAM_bot_ConfigMem.Inst_frame2_bit15.Q net42 VPWR
+ VGND sg13g2_mux4_1
XFILLER_69_175 VPWR VGND sg13g2_fill_1
X_0588_ Tile_X0Y0_IHP_SRAM_top.Inst_IHP_SRAM_top_switch_matrix.J_NS4_BEG6 Tile_X0Y0_IHP_SRAM_top.Inst_IHP_SRAM_top_switch_matrix.J_NS4_BEG10
+ Tile_X0Y0_IHP_SRAM_top.Inst_IHP_SRAM_top_ConfigMem.Inst_frame7_bit24.Q _0144_ VPWR
+ VGND sg13g2_mux2_1
X_0657_ Tile_X0Y1_IHP_SRAM_bot.Inst_IHP_SRAM_bot_ConfigMem.Inst_frame1_bit18.Q Tile_X0Y1_N1END[1]
+ Tile_X0Y1_N4END[1] _0060_ Tile_X0Y0_S4END[5] Tile_X0Y1_IHP_SRAM_bot.Inst_IHP_SRAM_bot_ConfigMem.Inst_frame1_bit19.Q
+ Tile_X0Y1_IHP_SRAM_bot.Inst_IHP_SRAM_bot_switch_matrix.J_NS4_BEG5 VPWR VGND sg13g2_mux4_1
X_1209_ Tile_X0Y1_FrameData[15] Tile_X0Y1_FrameStrobe[1] Tile_X0Y1_IHP_SRAM_bot.Inst_IHP_SRAM_bot_ConfigMem.Inst_frame1_bit15.Q
+ VPWR VGND sg13g2_dlhq_1
XFILLER_90_137 VPWR VGND sg13g2_decap_8
XFILLER_84_99 VPWR VGND sg13g2_fill_1
XFILLER_84_44 VPWR VGND sg13g2_fill_1
X_1560_ Tile_X0Y0_IHP_SRAM_top.Inst_IHP_SRAM_top_switch_matrix.N4BEG2 net156 VPWR
+ VGND sg13g2_buf_1
X_0511_ Tile_X0Y0_IHP_SRAM_top.Inst_IHP_SRAM_top_ConfigMem.Inst_frame2_bit2.Q Tile_X0Y0_EE4END[2]
+ Tile_X0Y0_EE4END[10] Tile_X0Y0_E6END[2] Tile_X0Y0_IHP_SRAM_top.Inst_IHP_SRAM_top_switch_matrix.J_NS4_BEG2
+ Tile_X0Y0_IHP_SRAM_top.Inst_IHP_SRAM_top_ConfigMem.Inst_frame2_bit3.Q net21 VPWR
+ VGND sg13g2_mux4_1
X_1491_ Tile_X0Y0_FrameData[17] net87 VPWR VGND sg13g2_buf_1
X_0442_ Tile_X0Y0_IHP_SRAM_top.Inst_IHP_SRAM_top_ConfigMem.Inst_frame6_bit18.Q A_DOUT_SRAM22
+ A_DOUT_SRAM30 Tile_X0Y0_IHP_SRAM_top.Inst_IHP_SRAM_top_switch_matrix.J_NS2_BEG1
+ Tile_X0Y0_IHP_SRAM_top.Inst_IHP_SRAM_top_switch_matrix.J_NS2_BEG6 Tile_X0Y0_IHP_SRAM_top.Inst_IHP_SRAM_top_ConfigMem.Inst_frame6_bit19.Q
+ Tile_X0Y0_IHP_SRAM_top.Inst_IHP_SRAM_top_switch_matrix.W2BEG6 VPWR VGND sg13g2_mux4_1
X_0373_ _0069_ _0067_ Tile_X0Y1_IHP_SRAM_bot.Inst_IHP_SRAM_bot_ConfigMem.Inst_frame0_bit28.Q
+ VPWR VGND sg13g2_nand2b_1
XFILLER_95_0 VPWR VGND sg13g2_fill_1
XFILLER_13_18 VPWR VGND sg13g2_fill_2
XFILLER_89_215 VPWR VGND sg13g2_fill_1
X_1689_ Tile_X0Y1_IHP_SRAM_bot.Inst_IHP_SRAM_bot_switch_matrix.W2BEG6 net294 VPWR
+ VGND sg13g2_buf_1
X_0709_ Tile_X0Y1_IHP_SRAM_bot.Inst_IHP_SRAM_bot_ConfigMem.Inst_frame3_bit12.Q Tile_X0Y1_EE4END[0]
+ Tile_X0Y1_EE4END[8] Tile_X0Y1_E6END[8] Tile_X0Y1_IHP_SRAM_bot.Inst_IHP_SRAM_bot_switch_matrix.J_NS4_BEG8
+ Tile_X0Y1_IHP_SRAM_bot.Inst_IHP_SRAM_bot_ConfigMem.Inst_frame3_bit13.Q net74 VPWR
+ VGND sg13g2_mux4_1
XFILLER_54_14 VPWR VGND sg13g2_fill_1
XFILLER_57_112 VPWR VGND sg13g2_fill_1
XFILLER_70_35 VPWR VGND sg13g2_fill_1
XFILLER_54_36 VPWR VGND sg13g2_decap_8
XFILLER_79_33 VPWR VGND sg13g2_fill_2
XFILLER_48_112 VPWR VGND sg13g2_fill_1
X_0991_ Tile_X0Y0_FrameData[31] Tile_X0Y1_FrameStrobe[4] Tile_X0Y0_IHP_SRAM_top.Inst_IHP_SRAM_top_ConfigMem.Inst_frame4_bit31.Q
+ VPWR VGND sg13g2_dlhq_1
X_1543_ Tile_X0Y0_IHP_SRAM_top.Inst_IHP_SRAM_top_switch_matrix.N2BEGb5 net148 VPWR
+ VGND sg13g2_buf_1
X_1474_ Tile_X0Y0_FrameData[0] net79 VPWR VGND sg13g2_buf_1
X_1612_ Tile_X0Y1_FrameData[1] net227 VPWR VGND sg13g2_buf_1
X_0425_ Tile_X0Y0_IHP_SRAM_top.Inst_IHP_SRAM_top_ConfigMem.Inst_frame0_bit24.Q Tile_X0Y0_IHP_SRAM_top.Inst_IHP_SRAM_top_ConfigMem.Inst_frame0_bit25.Q
+ Tile_X0Y0_IHP_SRAM_top.Inst_IHP_SRAM_top_switch_matrix.N1END0 _0086_ VPWR VGND sg13g2_nor3_1
XFILLER_10_0 VPWR VGND sg13g2_fill_1
X_0356_ CONFIGURED_top VPWR _0056_ VGND Tile_X0Y1_IHP_SRAM_bot.Inst_IHP_SRAM_bot_ConfigMem.Inst_frame1_bit3.Q
+ _0055_ sg13g2_o21ai_1
XFILLER_108_128 VPWR VGND sg13g2_decap_8
XFILLER_40_38 VPWR VGND sg13g2_fill_1
XFILLER_107_172 VPWR VGND sg13g2_decap_8
X_1190_ Tile_X0Y1_FrameData[2] Tile_X0Y1_FrameStrobe[0] Tile_X0Y1_IHP_SRAM_bot.Inst_IHP_SRAM_bot_ConfigMem.Inst_frame0_bit2.Q
+ VPWR VGND sg13g2_dlhq_1
X_0974_ Tile_X0Y0_FrameData[16] Tile_X0Y1_FrameStrobe[3] Tile_X0Y0_IHP_SRAM_top.Inst_IHP_SRAM_top_ConfigMem.Inst_frame3_bit16.Q
+ VPWR VGND sg13g2_dlhq_1
X_1526_ Tile_X0Y0_IHP_SRAM_top.Inst_IHP_SRAM_top_switch_matrix.N1BEG0 net131 VPWR
+ VGND sg13g2_buf_1
XFILLER_58_0 VPWR VGND sg13g2_fill_2
Xoutput324 net324 Tile_X0Y1_WW4BEG[2] VPWR VGND sg13g2_buf_1
Xoutput302 net302 Tile_X0Y1_W2BEGb[6] VPWR VGND sg13g2_buf_1
Xoutput313 net313 Tile_X0Y1_W6BEG[7] VPWR VGND sg13g2_buf_1
X_1457_ Tile_X0Y1_FrameData[23] Tile_X0Y1_FrameStrobe[9] Tile_X0Y1_IHP_SRAM_bot.Inst_IHP_SRAM_bot_ConfigMem.Inst_frame9_bit23.Q
+ VPWR VGND sg13g2_dlhq_1
X_0408_ Tile_X0Y0_IHP_SRAM_top.Inst_IHP_SRAM_top_ConfigMem.Inst_frame8_bit6.Q Tile_X0Y0_E2MID[3]
+ Tile_X0Y0_E2END[3] Tile_X0Y0_E6END[3] Tile_X0Y0_IHP_SRAM_top.Inst_IHP_SRAM_top_switch_matrix.J_NS2_BEG4
+ Tile_X0Y0_IHP_SRAM_top.Inst_IHP_SRAM_top_ConfigMem.Inst_frame8_bit7.Q Tile_X0Y0_IHP_SRAM_top.Inst_IHP_SRAM_top_switch_matrix.N2BEG4
+ VPWR VGND sg13g2_mux4_1
X_0339_ VPWR _0042_ Tile_X0Y0_IHP_SRAM_top.Inst_IHP_SRAM_top_switch_matrix.J_NS2_BEG4
+ VGND sg13g2_inv_1
XFILLER_82_210 VPWR VGND sg13g2_fill_2
X_1388_ Tile_X0Y1_FrameData[28] Tile_X0Y1_FrameStrobe[7] Tile_X0Y1_IHP_SRAM_bot.Inst_IHP_SRAM_bot_ConfigMem.Inst_frame7_bit28.Q
+ VPWR VGND sg13g2_dlhq_1
XFILLER_104_164 VPWR VGND sg13g2_decap_8
XFILLER_92_22 VPWR VGND sg13g2_fill_2
X_0690_ Tile_X0Y1_IHP_SRAM_bot.Inst_IHP_SRAM_bot_ConfigMem.Inst_frame4_bit22.Q Tile_X0Y1_E2MID[2]
+ _0169_ VPWR VGND sg13g2_nor2b_1
XFILLER_110_101 VPWR VGND sg13g2_decap_8
X_1311_ Tile_X0Y1_FrameData[9] Tile_X0Y1_FrameStrobe[4] Tile_X0Y1_IHP_SRAM_bot.Inst_IHP_SRAM_bot_ConfigMem.Inst_frame4_bit9.Q
+ VPWR VGND sg13g2_dlhq_1
XFILLER_51_7 VPWR VGND sg13g2_fill_1
X_1173_ Tile_X0Y1_FrameData[19] Tile_X0Y1_FrameStrobe[0] Tile_X0Y1_IHP_SRAM_bot.Inst_IHP_SRAM_bot_ConfigMem.Inst_frame0_bit19.Q
+ VPWR VGND sg13g2_dlhq_1
X_1242_ Tile_X0Y1_FrameData[14] Tile_X0Y1_FrameStrobe[2] Tile_X0Y1_IHP_SRAM_bot.Inst_IHP_SRAM_bot_ConfigMem.Inst_frame2_bit14.Q
+ VPWR VGND sg13g2_dlhq_1
XANTENNA_36 VPWR VGND Tile_X0Y1_FrameStrobe[15] sg13g2_antennanp
XANTENNA_47 VPWR VGND Tile_X0Y1_N2MID[0] sg13g2_antennanp
XANTENNA_25 VPWR VGND Tile_X0Y0_S2MID[5] sg13g2_antennanp
XANTENNA_14 VPWR VGND A_DOUT_SRAM28 sg13g2_antennanp
XFILLER_17_170 VPWR VGND sg13g2_fill_2
Xoutput143 net143 Tile_X0Y0_N2BEGb[0] VPWR VGND sg13g2_buf_1
Xoutput132 net132 Tile_X0Y0_N1BEG[1] VPWR VGND sg13g2_buf_1
Xoutput121 net121 Tile_X0Y0_FrameStrobe_O[19] VPWR VGND sg13g2_buf_1
X_0888_ Tile_X0Y0_FrameData[6] Tile_X0Y1_FrameStrobe[0] Tile_X0Y0_IHP_SRAM_top.Inst_IHP_SRAM_top_ConfigMem.Inst_frame0_bit6.Q
+ VPWR VGND sg13g2_dlhq_1
Xoutput110 net110 Tile_X0Y0_FrameData_O[9] VPWR VGND sg13g2_buf_1
X_0957_ Tile_X0Y0_FrameData[1] Tile_X0Y1_FrameStrobe[2] Tile_X0Y0_IHP_SRAM_top.Inst_IHP_SRAM_top_ConfigMem.Inst_frame2_bit1.Q
+ VPWR VGND sg13g2_dlhq_1
XANTENNA_58 VPWR VGND Tile_X0Y1_UserCLK sg13g2_antennanp
Xoutput154 net154 Tile_X0Y0_N4BEG[12] VPWR VGND sg13g2_buf_1
Xoutput165 net165 Tile_X0Y0_N4BEG[8] VPWR VGND sg13g2_buf_1
XFILLER_99_162 VPWR VGND sg13g2_fill_2
X_1509_ Tile_X0Y1_FrameStrobe[3] net124 VPWR VGND sg13g2_buf_1
Xoutput198 net198 Tile_X0Y0_W6BEG[8] VPWR VGND sg13g2_buf_1
Xoutput187 net187 Tile_X0Y0_W2BEGb[7] VPWR VGND sg13g2_buf_1
Xoutput176 net176 Tile_X0Y0_W2BEG[4] VPWR VGND sg13g2_buf_1
XFILLER_62_36 VPWR VGND sg13g2_fill_2
X_0673_ Tile_X0Y1_IHP_SRAM_bot.Inst_IHP_SRAM_bot_ConfigMem.Inst_frame4_bit3.Q A_DOUT_SRAM4
+ Tile_X0Y1_IHP_SRAM_bot.Inst_IHP_SRAM_bot_switch_matrix.J_NS4_BEG11 Tile_X0Y1_IHP_SRAM_bot.Inst_IHP_SRAM_bot_switch_matrix.J_NS4_BEG7
+ _0043_ Tile_X0Y1_IHP_SRAM_bot.Inst_IHP_SRAM_bot_ConfigMem.Inst_frame4_bit2.Q Tile_X0Y1_IHP_SRAM_bot.Inst_IHP_SRAM_bot_switch_matrix.W6BEG4
+ VPWR VGND sg13g2_mux4_1
X_0811_ VPWR _0248_ _0247_ VGND sg13g2_inv_1
X_0742_ VGND VPWR _0020_ _0184_ _0186_ _0185_ sg13g2_a21oi_1
XFILLER_96_187 VPWR VGND sg13g2_fill_1
X_1156_ Tile_X0Y0_FrameData[26] Tile_X0Y1_FrameStrobe[9] Tile_X0Y0_IHP_SRAM_top.Inst_IHP_SRAM_top_ConfigMem.Inst_frame9_bit26.Q
+ VPWR VGND sg13g2_dlhq_1
X_1087_ Tile_X0Y0_FrameData[31] Tile_X0Y1_FrameStrobe[7] Tile_X0Y0_IHP_SRAM_top.Inst_IHP_SRAM_top_ConfigMem.Inst_frame7_bit31.Q
+ VPWR VGND sg13g2_dlhq_1
X_1225_ Tile_X0Y1_FrameData[31] Tile_X0Y1_FrameStrobe[2] Tile_X0Y1_IHP_SRAM_bot.Inst_IHP_SRAM_bot_ConfigMem.Inst_frame2_bit31.Q
+ VPWR VGND sg13g2_dlhq_1
XFILLER_73_46 VPWR VGND sg13g2_fill_2
X_1010_ Tile_X0Y0_FrameData[12] Tile_X0Y1_FrameStrobe[4] Tile_X0Y0_IHP_SRAM_top.Inst_IHP_SRAM_top_ConfigMem.Inst_frame4_bit12.Q
+ VPWR VGND sg13g2_dlhq_1
XFILLER_93_135 VPWR VGND sg13g2_fill_2
X_0656_ Tile_X0Y1_IHP_SRAM_bot.Inst_IHP_SRAM_bot_ConfigMem.Inst_frame5_bit12.Q A_DOUT_SRAM5
+ A_DOUT_SRAM9 Tile_X0Y1_IHP_SRAM_bot.Inst_IHP_SRAM_bot_switch_matrix.J_NS4_BEG6 _0083_
+ Tile_X0Y1_IHP_SRAM_bot.Inst_IHP_SRAM_bot_ConfigMem.Inst_frame5_bit13.Q Tile_X0Y1_IHP_SRAM_bot.Inst_IHP_SRAM_bot_switch_matrix.WW4BEG9
+ VPWR VGND sg13g2_mux4_1
X_0725_ Tile_X0Y1_IHP_SRAM_bot.Inst_IHP_SRAM_bot_ConfigMem.Inst_frame2_bit12.Q Tile_X0Y1_EE4END[0]
+ Tile_X0Y1_EE4END[8] Tile_X0Y1_E6END[8] Tile_X0Y1_IHP_SRAM_bot.Inst_IHP_SRAM_bot_switch_matrix.J_NS4_BEG8
+ Tile_X0Y1_IHP_SRAM_bot.Inst_IHP_SRAM_bot_ConfigMem.Inst_frame2_bit13.Q net41 VPWR
+ VGND sg13g2_mux4_1
XFILLER_40_0 VPWR VGND sg13g2_decap_4
X_0587_ _0141_ _0143_ Tile_X0Y0_IHP_SRAM_top.Inst_IHP_SRAM_top_switch_matrix.S4BEG1
+ VPWR VGND sg13g2_nor2_1
X_1208_ Tile_X0Y1_FrameData[16] Tile_X0Y1_FrameStrobe[1] Tile_X0Y1_IHP_SRAM_bot.Inst_IHP_SRAM_bot_ConfigMem.Inst_frame1_bit16.Q
+ VPWR VGND sg13g2_dlhq_1
X_1139_ Tile_X0Y0_FrameData[11] Tile_X0Y1_FrameStrobe[8] Tile_X0Y0_IHP_SRAM_top.Inst_IHP_SRAM_top_ConfigMem.Inst_frame8_bit11.Q
+ VPWR VGND sg13g2_dlhq_1
XFILLER_108_86 VPWR VGND sg13g2_decap_8
XFILLER_75_102 VPWR VGND sg13g2_decap_4
XFILLER_17_72 VPWR VGND sg13g2_decap_8
XFILLER_33_82 VPWR VGND sg13g2_fill_1
X_1490_ Tile_X0Y0_FrameData[16] net86 VPWR VGND sg13g2_buf_1
X_0510_ Tile_X0Y0_IHP_SRAM_top.Inst_IHP_SRAM_top_ConfigMem.Inst_frame2_bit0.Q Tile_X0Y0_EE4END[1]
+ Tile_X0Y0_EE4END[9] Tile_X0Y0_E6END[1] Tile_X0Y0_IHP_SRAM_top.Inst_IHP_SRAM_top_switch_matrix.J_NS4_BEG1
+ Tile_X0Y0_IHP_SRAM_top.Inst_IHP_SRAM_top_ConfigMem.Inst_frame2_bit1.Q net20 VPWR
+ VGND sg13g2_mux4_1
XFILLER_66_168 VPWR VGND sg13g2_fill_1
XFILLER_66_146 VPWR VGND sg13g2_fill_1
X_0441_ Tile_X0Y0_IHP_SRAM_top.Inst_IHP_SRAM_top_ConfigMem.Inst_frame6_bit16.Q A_DOUT_SRAM21
+ A_DOUT_SRAM29 Tile_X0Y0_IHP_SRAM_top.Inst_IHP_SRAM_top_switch_matrix.J_NS2_BEG2
+ Tile_X0Y0_IHP_SRAM_top.Inst_IHP_SRAM_top_switch_matrix.J_NS2_BEG5 Tile_X0Y0_IHP_SRAM_top.Inst_IHP_SRAM_top_ConfigMem.Inst_frame6_bit17.Q
+ Tile_X0Y0_IHP_SRAM_top.Inst_IHP_SRAM_top_switch_matrix.W2BEG5 VPWR VGND sg13g2_mux4_1
XFILLER_3_194 VPWR VGND sg13g2_decap_8
X_0372_ Tile_X0Y1_N1END[2] Tile_X0Y1_IHP_SRAM_bot.Inst_IHP_SRAM_bot_ConfigMem.Inst_frame0_bit28.Q
+ Tile_X0Y1_IHP_SRAM_bot.Inst_IHP_SRAM_bot_ConfigMem.Inst_frame0_bit29.Q _0068_ VPWR
+ VGND sg13g2_nor3_1
XFILLER_74_190 VPWR VGND sg13g2_fill_1
XFILLER_88_0 VPWR VGND sg13g2_decap_4
X_1688_ Tile_X0Y1_IHP_SRAM_bot.Inst_IHP_SRAM_bot_switch_matrix.W2BEG5 net293 VPWR
+ VGND sg13g2_buf_1
X_0639_ Tile_X0Y1_IHP_SRAM_bot.Inst_IHP_SRAM_bot_ConfigMem.Inst_frame6_bit22.Q A_DOUT_SRAM6
+ A_DOUT_SRAM14 _0078_ _0083_ Tile_X0Y1_IHP_SRAM_bot.Inst_IHP_SRAM_bot_ConfigMem.Inst_frame6_bit23.Q
+ Tile_X0Y1_IHP_SRAM_bot.Inst_IHP_SRAM_bot_switch_matrix.W2BEGb6 VPWR VGND sg13g2_mux4_1
X_0708_ Tile_X0Y1_IHP_SRAM_bot.Inst_IHP_SRAM_bot_ConfigMem.Inst_frame3_bit10.Q Tile_X0Y1_EE4END[7]
+ Tile_X0Y1_EE4END[15] Tile_X0Y1_E6END[7] Tile_X0Y1_IHP_SRAM_bot.Inst_IHP_SRAM_bot_switch_matrix.J_NS4_BEG7
+ Tile_X0Y1_IHP_SRAM_bot.Inst_IHP_SRAM_bot_ConfigMem.Inst_frame3_bit11.Q net73 VPWR
+ VGND sg13g2_mux4_1
XFILLER_65_190 VPWR VGND sg13g2_fill_1
XFILLER_57_146 VPWR VGND sg13g2_decap_8
XFILLER_79_78 VPWR VGND sg13g2_decap_8
XFILLER_48_168 VPWR VGND sg13g2_fill_1
XFILLER_63_138 VPWR VGND sg13g2_decap_4
XFILLER_56_190 VPWR VGND sg13g2_fill_2
X_0990_ Tile_X0Y0_FrameData[0] Tile_X0Y1_FrameStrobe[3] Tile_X0Y0_IHP_SRAM_top.Inst_IHP_SRAM_top_ConfigMem.Inst_frame3_bit0.Q
+ VPWR VGND sg13g2_dlhq_1
X_1611_ Tile_X0Y1_FrameData[0] net216 VPWR VGND sg13g2_buf_1
X_1542_ Tile_X0Y0_IHP_SRAM_top.Inst_IHP_SRAM_top_switch_matrix.N2BEGb4 net147 VPWR
+ VGND sg13g2_buf_1
X_0424_ _0085_ Tile_X0Y0_S1END[0] Tile_X0Y0_IHP_SRAM_top.Inst_IHP_SRAM_top_ConfigMem.Inst_frame0_bit24.Q
+ VPWR VGND sg13g2_nand2b_1
X_1473_ clknet_1_0__leaf_Tile_X0Y1_UserCLK net43 VPWR VGND sg13g2_buf_1
XFILLER_39_168 VPWR VGND sg13g2_fill_1
X_0355_ _0054_ _0053_ Tile_X0Y1_IHP_SRAM_bot.Inst_IHP_SRAM_bot_ConfigMem.Inst_frame1_bit2.Q
+ _0055_ VPWR VGND sg13g2_mux2_1
XFILLER_54_116 VPWR VGND sg13g2_decap_8
XFILLER_108_107 VPWR VGND sg13g2_decap_8
XFILLER_105_87 VPWR VGND sg13g2_decap_8
XFILLER_107_151 VPWR VGND sg13g2_decap_8
XFILLER_30_83 VPWR VGND sg13g2_decap_4
XFILLER_51_119 VPWR VGND sg13g2_decap_4
X_0973_ Tile_X0Y0_FrameData[17] Tile_X0Y1_FrameStrobe[3] Tile_X0Y0_IHP_SRAM_top.Inst_IHP_SRAM_top_ConfigMem.Inst_frame3_bit17.Q
+ VPWR VGND sg13g2_dlhq_1
Xoutput303 net303 Tile_X0Y1_W2BEGb[7] VPWR VGND sg13g2_buf_1
Xoutput314 net314 Tile_X0Y1_W6BEG[8] VPWR VGND sg13g2_buf_1
Xoutput325 net325 Tile_X0Y1_WW4BEG[3] VPWR VGND sg13g2_buf_1
X_1525_ Tile_X0Y1_FrameStrobe[19] net121 VPWR VGND sg13g2_buf_1
X_0407_ Tile_X0Y0_IHP_SRAM_top.Inst_IHP_SRAM_top_ConfigMem.Inst_frame0_bit17.Q Tile_X0Y0_IHP_SRAM_top.Inst_IHP_SRAM_top_switch_matrix.N2BEGb4
+ Tile_X0Y0_S2MID[4] Tile_X0Y1_N2MID[4] Tile_X0Y0_S2END[4] Tile_X0Y0_IHP_SRAM_top.Inst_IHP_SRAM_top_ConfigMem.Inst_frame0_bit16.Q
+ Tile_X0Y0_IHP_SRAM_top.Inst_IHP_SRAM_top_switch_matrix.J_NS2_BEG4 VPWR VGND sg13g2_mux4_1
X_1387_ Tile_X0Y1_FrameData[29] Tile_X0Y1_FrameStrobe[7] Tile_X0Y1_IHP_SRAM_bot.Inst_IHP_SRAM_bot_ConfigMem.Inst_frame7_bit29.Q
+ VPWR VGND sg13g2_dlhq_1
X_1456_ Tile_X0Y1_FrameData[24] Tile_X0Y1_FrameStrobe[9] Tile_X0Y1_IHP_SRAM_bot.Inst_IHP_SRAM_bot_ConfigMem.Inst_frame9_bit24.Q
+ VPWR VGND sg13g2_dlhq_1
X_0338_ VPWR _0041_ Tile_X0Y0_IHP_SRAM_top.Inst_IHP_SRAM_top_switch_matrix.J_NS2_BEG3
+ VGND sg13g2_inv_1
XFILLER_104_143 VPWR VGND sg13g2_decap_8
XFILLER_73_211 VPWR VGND sg13g2_fill_1
XFILLER_92_45 VPWR VGND sg13g2_fill_2
XFILLER_25_94 VPWR VGND sg13g2_decap_4
XFILLER_26_171 VPWR VGND sg13g2_fill_1
XFILLER_41_141 VPWR VGND sg13g2_decap_4
XFILLER_41_60 VPWR VGND sg13g2_decap_8
X_1310_ Tile_X0Y1_FrameData[10] Tile_X0Y1_FrameStrobe[4] Tile_X0Y1_IHP_SRAM_bot.Inst_IHP_SRAM_bot_ConfigMem.Inst_frame4_bit10.Q
+ VPWR VGND sg13g2_dlhq_1
X_1241_ Tile_X0Y1_FrameData[15] Tile_X0Y1_FrameStrobe[2] Tile_X0Y1_IHP_SRAM_bot.Inst_IHP_SRAM_bot_ConfigMem.Inst_frame2_bit15.Q
+ VPWR VGND sg13g2_dlhq_1
X_1172_ Tile_X0Y1_FrameData[20] Tile_X0Y1_FrameStrobe[0] Tile_X0Y1_IHP_SRAM_bot.Inst_IHP_SRAM_bot_ConfigMem.Inst_frame0_bit20.Q
+ VPWR VGND sg13g2_dlhq_1
XANTENNA_37 VPWR VGND Tile_X0Y1_FrameStrobe[16] sg13g2_antennanp
XANTENNA_59 VPWR VGND net164 sg13g2_antennanp
XANTENNA_15 VPWR VGND A_DOUT_SRAM28 sg13g2_antennanp
X_0956_ Tile_X0Y0_FrameData[2] Tile_X0Y1_FrameStrobe[2] Tile_X0Y0_IHP_SRAM_top.Inst_IHP_SRAM_top_ConfigMem.Inst_frame2_bit2.Q
+ VPWR VGND sg13g2_dlhq_1
XANTENNA_26 VPWR VGND Tile_X0Y0_S2MID[7] sg13g2_antennanp
XANTENNA_48 VPWR VGND Tile_X0Y1_N2MID[0] sg13g2_antennanp
Xoutput122 net122 Tile_X0Y0_FrameStrobe_O[1] VPWR VGND sg13g2_buf_1
Xoutput111 net111 Tile_X0Y0_FrameStrobe_O[0] VPWR VGND sg13g2_buf_1
Xoutput155 net155 Tile_X0Y0_N4BEG[13] VPWR VGND sg13g2_buf_1
Xoutput166 net166 Tile_X0Y0_N4BEG[9] VPWR VGND sg13g2_buf_1
Xoutput144 net144 Tile_X0Y0_N2BEGb[1] VPWR VGND sg13g2_buf_1
Xoutput100 net100 Tile_X0Y0_FrameData_O[29] VPWR VGND sg13g2_buf_1
Xoutput133 net133 Tile_X0Y0_N1BEG[2] VPWR VGND sg13g2_buf_1
X_0887_ Tile_X0Y0_FrameData[7] Tile_X0Y1_FrameStrobe[0] Tile_X0Y0_IHP_SRAM_top.Inst_IHP_SRAM_top_ConfigMem.Inst_frame0_bit7.Q
+ VPWR VGND sg13g2_dlhq_1
Xoutput177 net177 Tile_X0Y0_W2BEG[5] VPWR VGND sg13g2_buf_1
XFILLER_101_102 VPWR VGND sg13g2_fill_2
XFILLER_99_196 VPWR VGND sg13g2_decap_4
X_1508_ Tile_X0Y1_FrameStrobe[2] net123 VPWR VGND sg13g2_buf_1
Xoutput199 net199 Tile_X0Y0_W6BEG[9] VPWR VGND sg13g2_buf_1
Xoutput188 net188 Tile_X0Y0_W6BEG[0] VPWR VGND sg13g2_buf_1
X_1439_ Tile_X0Y1_FrameData[9] Tile_X0Y1_FrameStrobe[8] Tile_X0Y1_IHP_SRAM_bot.Inst_IHP_SRAM_bot_ConfigMem.Inst_frame8_bit9.Q
+ VPWR VGND sg13g2_dlhq_1
XFILLER_102_44 VPWR VGND sg13g2_decap_4
XFILLER_87_12 VPWR VGND sg13g2_fill_2
X_0810_ Tile_X0Y1_IHP_SRAM_bot.Inst_IHP_SRAM_bot_ConfigMem.Inst_frame7_bit16.Q VPWR
+ _0247_ VGND Tile_X0Y1_E6END[7] Tile_X0Y1_IHP_SRAM_bot.Inst_IHP_SRAM_bot_ConfigMem.Inst_frame7_bit15.Q
+ sg13g2_o21ai_1
X_0672_ Tile_X0Y1_IHP_SRAM_bot.Inst_IHP_SRAM_bot_ConfigMem.Inst_frame4_bit0.Q Tile_X0Y1_N4END[3]
+ Tile_X0Y0_S4END[7] Tile_X0Y1_IHP_SRAM_bot.Inst_IHP_SRAM_bot_switch_matrix.J_NS4_BEG8
+ Tile_X0Y1_IHP_SRAM_bot.Inst_IHP_SRAM_bot_switch_matrix.J_NS4_BEG12 Tile_X0Y1_IHP_SRAM_bot.Inst_IHP_SRAM_bot_ConfigMem.Inst_frame4_bit1.Q
+ Tile_X0Y1_IHP_SRAM_bot.Inst_IHP_SRAM_bot_switch_matrix.W6BEG3 VPWR VGND sg13g2_mux4_1
X_0741_ Tile_X0Y1_IHP_SRAM_bot.Inst_IHP_SRAM_bot_ConfigMem.Inst_frame8_bit4.Q VPWR
+ _0185_ VGND _0182_ _0183_ sg13g2_o21ai_1
XFILLER_96_144 VPWR VGND sg13g2_decap_8
XFILLER_37_211 VPWR VGND sg13g2_fill_1
X_1224_ Tile_X0Y1_FrameData[0] Tile_X0Y1_FrameStrobe[1] Tile_X0Y1_IHP_SRAM_bot.Inst_IHP_SRAM_bot_ConfigMem.Inst_frame1_bit0.Q
+ VPWR VGND sg13g2_dlhq_1
X_1155_ Tile_X0Y0_FrameData[27] Tile_X0Y1_FrameStrobe[9] Tile_X0Y0_IHP_SRAM_top.Inst_IHP_SRAM_top_ConfigMem.Inst_frame9_bit27.Q
+ VPWR VGND sg13g2_dlhq_1
X_1086_ Tile_X0Y0_FrameData[0] Tile_X0Y1_FrameStrobe[6] Tile_X0Y0_IHP_SRAM_top.Inst_IHP_SRAM_top_ConfigMem.Inst_frame6_bit0.Q
+ VPWR VGND sg13g2_dlhq_1
X_0939_ Tile_X0Y0_FrameData[19] Tile_X0Y1_FrameStrobe[2] Tile_X0Y0_IHP_SRAM_top.Inst_IHP_SRAM_top_ConfigMem.Inst_frame2_bit19.Q
+ VPWR VGND sg13g2_dlhq_1
XFILLER_98_55 VPWR VGND sg13g2_fill_1
XFILLER_98_44 VPWR VGND sg13g2_decap_8
XFILLER_98_99 VPWR VGND sg13g2_fill_2
XFILLER_103_208 VPWR VGND sg13g2_decap_4
X_0586_ Tile_X0Y0_IHP_SRAM_top.Inst_IHP_SRAM_top_ConfigMem.Inst_frame7_bit23.Q _0142_
+ _0143_ VPWR VGND sg13g2_nor2_1
XFILLER_6_192 VPWR VGND sg13g2_decap_4
X_0724_ Tile_X0Y1_IHP_SRAM_bot.Inst_IHP_SRAM_bot_ConfigMem.Inst_frame2_bit10.Q Tile_X0Y1_EE4END[7]
+ Tile_X0Y1_EE4END[15] Tile_X0Y1_E6END[7] Tile_X0Y1_IHP_SRAM_bot.Inst_IHP_SRAM_bot_switch_matrix.J_NS4_BEG7
+ Tile_X0Y1_IHP_SRAM_bot.Inst_IHP_SRAM_bot_ConfigMem.Inst_frame2_bit11.Q net40 VPWR
+ VGND sg13g2_mux4_1
XFILLER_33_0 VPWR VGND sg13g2_fill_1
X_0655_ Tile_X0Y1_IHP_SRAM_bot.Inst_IHP_SRAM_bot_ConfigMem.Inst_frame1_bit20.Q Tile_X0Y1_N1END[2]
+ Tile_X0Y1_N4END[2] _0067_ Tile_X0Y0_S4END[6] Tile_X0Y1_IHP_SRAM_bot.Inst_IHP_SRAM_bot_ConfigMem.Inst_frame1_bit21.Q
+ Tile_X0Y1_IHP_SRAM_bot.Inst_IHP_SRAM_bot_switch_matrix.J_NS4_BEG6 VPWR VGND sg13g2_mux4_1
X_1207_ Tile_X0Y1_FrameData[17] Tile_X0Y1_FrameStrobe[1] Tile_X0Y1_IHP_SRAM_bot.Inst_IHP_SRAM_bot_ConfigMem.Inst_frame1_bit17.Q
+ VPWR VGND sg13g2_dlhq_1
X_1138_ Tile_X0Y0_FrameData[12] Tile_X0Y1_FrameStrobe[8] Tile_X0Y0_IHP_SRAM_top.Inst_IHP_SRAM_top_ConfigMem.Inst_frame8_bit12.Q
+ VPWR VGND sg13g2_dlhq_1
X_1069_ Tile_X0Y0_FrameData[17] Tile_X0Y1_FrameStrobe[6] Tile_X0Y0_IHP_SRAM_top.Inst_IHP_SRAM_top_ConfigMem.Inst_frame6_bit17.Q
+ VPWR VGND sg13g2_dlhq_1
XFILLER_108_65 VPWR VGND sg13g2_decap_4
XFILLER_16_214 VPWR VGND sg13g2_fill_2
X_0440_ Tile_X0Y0_IHP_SRAM_top.Inst_IHP_SRAM_top_ConfigMem.Inst_frame6_bit14.Q A_DOUT_SRAM20
+ A_DOUT_SRAM28 Tile_X0Y0_IHP_SRAM_top.Inst_IHP_SRAM_top_switch_matrix.J_NS2_BEG3
+ Tile_X0Y0_IHP_SRAM_top.Inst_IHP_SRAM_top_switch_matrix.J_NS2_BEG4 Tile_X0Y0_IHP_SRAM_top.Inst_IHP_SRAM_top_ConfigMem.Inst_frame6_bit15.Q
+ Tile_X0Y0_IHP_SRAM_top.Inst_IHP_SRAM_top_switch_matrix.W2BEG4 VPWR VGND sg13g2_mux4_1
XFILLER_3_173 VPWR VGND sg13g2_decap_8
XFILLER_81_106 VPWR VGND sg13g2_decap_8
X_0371_ Tile_X0Y0_IHP_SRAM_top.Inst_IHP_SRAM_top_ConfigMem.Inst_frame8_bit30.Q Tile_X0Y0_E1END[2]
+ Tile_X0Y0_E6END[10] Tile_X0Y0_IHP_SRAM_top.Inst_IHP_SRAM_top_switch_matrix.J_NS4_BEG14
+ _0066_ Tile_X0Y0_IHP_SRAM_top.Inst_IHP_SRAM_top_ConfigMem.Inst_frame8_bit31.Q _0067_
+ VPWR VGND sg13g2_mux4_1
XFILLER_66_103 VPWR VGND sg13g2_fill_1
X_0707_ Tile_X0Y1_IHP_SRAM_bot.Inst_IHP_SRAM_bot_ConfigMem.Inst_frame3_bit8.Q Tile_X0Y1_EE4END[6]
+ Tile_X0Y1_EE4END[14] Tile_X0Y1_E6END[6] Tile_X0Y1_IHP_SRAM_bot.Inst_IHP_SRAM_bot_switch_matrix.J_NS4_BEG6
+ Tile_X0Y1_IHP_SRAM_bot.Inst_IHP_SRAM_bot_ConfigMem.Inst_frame3_bit9.Q net72 VPWR
+ VGND sg13g2_mux4_1
X_0569_ Tile_X0Y0_IHP_SRAM_top.Inst_IHP_SRAM_top_ConfigMem.Inst_frame8_bit24.Q Tile_X0Y0_E1END[3]
+ Tile_X0Y0_E6END[11] Tile_X0Y0_EE4END[3] Tile_X0Y0_IHP_SRAM_top.Inst_IHP_SRAM_top_switch_matrix.J_NS4_BEG3
+ Tile_X0Y0_IHP_SRAM_top.Inst_IHP_SRAM_top_ConfigMem.Inst_frame8_bit23.Q _0128_ VPWR
+ VGND sg13g2_mux4_1
X_0638_ Tile_X0Y1_IHP_SRAM_bot.Inst_IHP_SRAM_bot_ConfigMem.Inst_frame6_bit20.Q A_DOUT_SRAM5
+ A_DOUT_SRAM13 _0079_ _0082_ Tile_X0Y1_IHP_SRAM_bot.Inst_IHP_SRAM_bot_ConfigMem.Inst_frame6_bit21.Q
+ Tile_X0Y1_IHP_SRAM_bot.Inst_IHP_SRAM_bot_switch_matrix.W2BEGb5 VPWR VGND sg13g2_mux4_1
X_1687_ Tile_X0Y1_IHP_SRAM_bot.Inst_IHP_SRAM_bot_switch_matrix.W2BEG4 net292 VPWR
+ VGND sg13g2_buf_1
XFILLER_57_103 VPWR VGND sg13g2_decap_4
XFILLER_80_172 VPWR VGND sg13g2_fill_1
XFILLER_79_35 VPWR VGND sg13g2_fill_1
X_1610_ Tile_X0Y0_IHP_SRAM_top.Inst_IHP_SRAM_top_switch_matrix.WW4BEG15 net206 VPWR
+ VGND sg13g2_buf_1
X_1541_ Tile_X0Y0_IHP_SRAM_top.Inst_IHP_SRAM_top_switch_matrix.N2BEGb3 net146 VPWR
+ VGND sg13g2_buf_1
X_0423_ Tile_X0Y0_IHP_SRAM_top.Inst_IHP_SRAM_top_ConfigMem.Inst_frame8_bit12.Q Tile_X0Y0_E2MID[0]
+ Tile_X0Y0_E2END[0] Tile_X0Y0_E6END[0] Tile_X0Y0_IHP_SRAM_top.Inst_IHP_SRAM_top_switch_matrix.J_NS2_BEG7
+ Tile_X0Y0_IHP_SRAM_top.Inst_IHP_SRAM_top_ConfigMem.Inst_frame8_bit13.Q Tile_X0Y0_IHP_SRAM_top.Inst_IHP_SRAM_top_switch_matrix.N2BEG7
+ VPWR VGND sg13g2_mux4_1
X_1472_ VPWR VGND A_TIE_LOW_SRAM sg13g2_tielo
X_0354_ Tile_X0Y1_IHP_SRAM_bot.Inst_IHP_SRAM_bot_ConfigMem.Inst_frame1_bit0.Q Tile_X0Y1_N2MID[6]
+ Tile_X0Y1_N2END[2] Tile_X0Y1_N2END[3] Tile_X0Y1_E2MID[0] Tile_X0Y1_IHP_SRAM_bot.Inst_IHP_SRAM_bot_ConfigMem.Inst_frame1_bit1.Q
+ _0054_ VPWR VGND sg13g2_mux4_1
XFILLER_105_66 VPWR VGND sg13g2_decap_8
XFILLER_53_150 VPWR VGND sg13g2_fill_1
XFILLER_107_130 VPWR VGND sg13g2_decap_8
XFILLER_100_0 VPWR VGND sg13g2_decap_4
XFILLER_39_93 VPWR VGND sg13g2_fill_1
X_0972_ Tile_X0Y0_FrameData[18] Tile_X0Y1_FrameStrobe[3] Tile_X0Y0_IHP_SRAM_top.Inst_IHP_SRAM_top_ConfigMem.Inst_frame3_bit18.Q
+ VPWR VGND sg13g2_dlhq_1
X_1524_ Tile_X0Y1_FrameStrobe[18] net120 VPWR VGND sg13g2_buf_1
Xoutput326 net326 Tile_X0Y1_WW4BEG[4] VPWR VGND sg13g2_buf_1
Xoutput304 net304 Tile_X0Y1_W6BEG[0] VPWR VGND sg13g2_buf_1
Xoutput315 net315 Tile_X0Y1_W6BEG[9] VPWR VGND sg13g2_buf_1
X_0337_ VPWR _0040_ Tile_X0Y0_IHP_SRAM_top.Inst_IHP_SRAM_top_switch_matrix.J_NS2_BEG2
+ VGND sg13g2_inv_1
X_1386_ Tile_X0Y1_FrameData[30] Tile_X0Y1_FrameStrobe[7] Tile_X0Y1_IHP_SRAM_bot.Inst_IHP_SRAM_bot_ConfigMem.Inst_frame7_bit30.Q
+ VPWR VGND sg13g2_dlhq_1
X_1455_ Tile_X0Y1_FrameData[25] Tile_X0Y1_FrameStrobe[9] Tile_X0Y1_IHP_SRAM_bot.Inst_IHP_SRAM_bot_ConfigMem.Inst_frame9_bit25.Q
+ VPWR VGND sg13g2_dlhq_1
X_0406_ Tile_X0Y1_IHP_SRAM_bot.Inst_IHP_SRAM_bot_ConfigMem.Inst_frame9_bit26.Q Tile_X0Y1_E2MID[3]
+ Tile_X0Y1_E2END[3] Tile_X0Y1_E6END[3] _0081_ Tile_X0Y1_IHP_SRAM_bot.Inst_IHP_SRAM_bot_ConfigMem.Inst_frame9_bit27.Q
+ Tile_X0Y0_IHP_SRAM_top.Inst_IHP_SRAM_top_switch_matrix.N2BEGb4 VPWR VGND sg13g2_mux4_1
XFILLER_35_18 VPWR VGND sg13g2_fill_1
XFILLER_104_122 VPWR VGND sg13g2_decap_8
XFILLER_104_199 VPWR VGND sg13g2_decap_4
XFILLER_2_44 VPWR VGND sg13g2_fill_1
X_1240_ Tile_X0Y1_FrameData[16] Tile_X0Y1_FrameStrobe[2] Tile_X0Y1_IHP_SRAM_bot.Inst_IHP_SRAM_bot_ConfigMem.Inst_frame2_bit16.Q
+ VPWR VGND sg13g2_dlhq_1
X_1171_ Tile_X0Y1_FrameData[21] Tile_X0Y1_FrameStrobe[0] Tile_X0Y1_IHP_SRAM_bot.Inst_IHP_SRAM_bot_ConfigMem.Inst_frame0_bit21.Q
+ VPWR VGND sg13g2_dlhq_1
XANTENNA_38 VPWR VGND Tile_X0Y1_FrameStrobe[16] sg13g2_antennanp
XANTENNA_27 VPWR VGND Tile_X0Y0_S2MID[7] sg13g2_antennanp
XANTENNA_49 VPWR VGND Tile_X0Y1_N2MID[0] sg13g2_antennanp
X_0886_ Tile_X0Y0_FrameData[8] Tile_X0Y1_FrameStrobe[0] Tile_X0Y0_IHP_SRAM_top.Inst_IHP_SRAM_top_ConfigMem.Inst_frame0_bit8.Q
+ VPWR VGND sg13g2_dlhq_1
X_0955_ Tile_X0Y0_FrameData[3] Tile_X0Y1_FrameStrobe[2] Tile_X0Y0_IHP_SRAM_top.Inst_IHP_SRAM_top_ConfigMem.Inst_frame2_bit3.Q
+ VPWR VGND sg13g2_dlhq_1
XANTENNA_16 VPWR VGND A_DOUT_SRAM28 sg13g2_antennanp
Xoutput112 net112 Tile_X0Y0_FrameStrobe_O[10] VPWR VGND sg13g2_buf_1
Xoutput123 net123 Tile_X0Y0_FrameStrobe_O[2] VPWR VGND sg13g2_buf_1
Xoutput167 net167 Tile_X0Y0_UserCLKo VPWR VGND sg13g2_buf_1
Xoutput156 net156 Tile_X0Y0_N4BEG[14] VPWR VGND sg13g2_buf_1
Xoutput134 net134 Tile_X0Y0_N1BEG[3] VPWR VGND sg13g2_buf_1
Xoutput145 net145 Tile_X0Y0_N2BEGb[2] VPWR VGND sg13g2_buf_1
X_1507_ Tile_X0Y1_FrameStrobe[1] net122 VPWR VGND sg13g2_buf_1
XFILLER_99_120 VPWR VGND sg13g2_fill_1
Xoutput189 net189 Tile_X0Y0_W6BEG[10] VPWR VGND sg13g2_buf_1
Xoutput101 net101 Tile_X0Y0_FrameData_O[2] VPWR VGND sg13g2_buf_1
Xoutput178 net178 Tile_X0Y0_W2BEG[6] VPWR VGND sg13g2_buf_1
XFILLER_63_0 VPWR VGND sg13g2_fill_2
X_1369_ Tile_X0Y1_FrameData[15] Tile_X0Y1_FrameStrobe[6] Tile_X0Y1_IHP_SRAM_bot.Inst_IHP_SRAM_bot_ConfigMem.Inst_frame6_bit15.Q
+ VPWR VGND sg13g2_dlhq_1
X_1438_ Tile_X0Y1_FrameData[10] Tile_X0Y1_FrameStrobe[8] Tile_X0Y1_IHP_SRAM_bot.Inst_IHP_SRAM_bot_ConfigMem.Inst_frame8_bit10.Q
+ VPWR VGND sg13g2_dlhq_1
XFILLER_102_78 VPWR VGND sg13g2_decap_4
XFILLER_102_23 VPWR VGND sg13g2_decap_4
XFILLER_23_131 VPWR VGND sg13g2_fill_1
XFILLER_109_214 VPWR VGND sg13g2_fill_2
XFILLER_11_42 VPWR VGND sg13g2_fill_2
XFILLER_11_20 VPWR VGND sg13g2_fill_1
XFILLER_87_68 VPWR VGND sg13g2_decap_4
X_0740_ Tile_X0Y1_IHP_SRAM_bot.Inst_IHP_SRAM_bot_switch_matrix.J_NS4_BEG4 Tile_X0Y1_IHP_SRAM_bot.Inst_IHP_SRAM_bot_switch_matrix.J_NS4_BEG8
+ Tile_X0Y1_IHP_SRAM_bot.Inst_IHP_SRAM_bot_ConfigMem.Inst_frame8_bit2.Q _0184_ VPWR
+ VGND sg13g2_mux2_1
XFILLER_52_82 VPWR VGND sg13g2_decap_8
X_0671_ Tile_X0Y1_IHP_SRAM_bot.Inst_IHP_SRAM_bot_ConfigMem.Inst_frame5_bit30.Q Tile_X0Y1_N4END[2]
+ Tile_X0Y0_S4END[6] Tile_X0Y1_IHP_SRAM_bot.Inst_IHP_SRAM_bot_switch_matrix.J_NS4_BEG9
+ Tile_X0Y1_IHP_SRAM_bot.Inst_IHP_SRAM_bot_switch_matrix.J_NS4_BEG13 Tile_X0Y1_IHP_SRAM_bot.Inst_IHP_SRAM_bot_ConfigMem.Inst_frame5_bit31.Q
+ Tile_X0Y1_IHP_SRAM_bot.Inst_IHP_SRAM_bot_switch_matrix.W6BEG2 VPWR VGND sg13g2_mux4_1
X_1154_ Tile_X0Y0_FrameData[28] Tile_X0Y1_FrameStrobe[9] Tile_X0Y0_IHP_SRAM_top.Inst_IHP_SRAM_top_ConfigMem.Inst_frame9_bit28.Q
+ VPWR VGND sg13g2_dlhq_1
X_1223_ Tile_X0Y1_FrameData[1] Tile_X0Y1_FrameStrobe[1] Tile_X0Y1_IHP_SRAM_bot.Inst_IHP_SRAM_bot_ConfigMem.Inst_frame1_bit1.Q
+ VPWR VGND sg13g2_dlhq_1
X_1085_ Tile_X0Y0_FrameData[1] Tile_X0Y1_FrameStrobe[6] Tile_X0Y0_IHP_SRAM_top.Inst_IHP_SRAM_top_ConfigMem.Inst_frame6_bit1.Q
+ VPWR VGND sg13g2_dlhq_1
XFILLER_20_112 VPWR VGND sg13g2_fill_2
X_0869_ Tile_X0Y0_FrameData[25] Tile_X0Y1_FrameStrobe[0] Tile_X0Y0_IHP_SRAM_top.Inst_IHP_SRAM_top_ConfigMem.Inst_frame0_bit25.Q
+ VPWR VGND sg13g2_dlhq_1
X_0938_ Tile_X0Y0_FrameData[20] Tile_X0Y1_FrameStrobe[2] Tile_X0Y0_IHP_SRAM_top.Inst_IHP_SRAM_top_ConfigMem.Inst_frame2_bit20.Q
+ VPWR VGND sg13g2_dlhq_1
XFILLER_57_38 VPWR VGND sg13g2_decap_8
XFILLER_57_49 VPWR VGND sg13g2_fill_2
XFILLER_7_127 VPWR VGND sg13g2_fill_1
XFILLER_78_134 VPWR VGND sg13g2_fill_1
XFILLER_8_98 VPWR VGND sg13g2_fill_2
XFILLER_8_21 VPWR VGND sg13g2_fill_2
X_0723_ Tile_X0Y1_IHP_SRAM_bot.Inst_IHP_SRAM_bot_ConfigMem.Inst_frame2_bit8.Q Tile_X0Y1_EE4END[6]
+ Tile_X0Y1_EE4END[14] Tile_X0Y1_E6END[6] Tile_X0Y1_IHP_SRAM_bot.Inst_IHP_SRAM_bot_switch_matrix.J_NS4_BEG6
+ Tile_X0Y1_IHP_SRAM_bot.Inst_IHP_SRAM_bot_ConfigMem.Inst_frame2_bit9.Q net39 VPWR
+ VGND sg13g2_mux4_1
X_0585_ Tile_X0Y0_IHP_SRAM_top.Inst_IHP_SRAM_top_ConfigMem.Inst_frame7_bit22.Q Tile_X0Y0_E1END[1]
+ Tile_X0Y0_E6END[5] Tile_X0Y0_EE4END[13] Tile_X0Y0_IHP_SRAM_top.Inst_IHP_SRAM_top_switch_matrix.J_NS4_BEG1
+ Tile_X0Y0_IHP_SRAM_top.Inst_IHP_SRAM_top_ConfigMem.Inst_frame7_bit21.Q _0142_ VPWR
+ VGND sg13g2_mux4_1
X_0654_ Tile_X0Y1_IHP_SRAM_bot.Inst_IHP_SRAM_bot_ConfigMem.Inst_frame5_bit10.Q A_DOUT_SRAM4
+ A_DOUT_SRAM8 Tile_X0Y1_IHP_SRAM_bot.Inst_IHP_SRAM_bot_switch_matrix.J_NS4_BEG7 _0084_
+ Tile_X0Y1_IHP_SRAM_bot.Inst_IHP_SRAM_bot_ConfigMem.Inst_frame5_bit11.Q Tile_X0Y1_IHP_SRAM_bot.Inst_IHP_SRAM_bot_switch_matrix.WW4BEG8
+ VPWR VGND sg13g2_mux4_1
XFILLER_26_0 VPWR VGND sg13g2_decap_8
XFILLER_92_170 VPWR VGND sg13g2_fill_1
X_1137_ Tile_X0Y0_FrameData[13] Tile_X0Y1_FrameStrobe[8] Tile_X0Y0_IHP_SRAM_top.Inst_IHP_SRAM_top_ConfigMem.Inst_frame8_bit13.Q
+ VPWR VGND sg13g2_dlhq_1
X_1206_ Tile_X0Y1_FrameData[18] Tile_X0Y1_FrameStrobe[1] Tile_X0Y1_IHP_SRAM_bot.Inst_IHP_SRAM_bot_ConfigMem.Inst_frame1_bit18.Q
+ VPWR VGND sg13g2_dlhq_1
X_1068_ Tile_X0Y0_FrameData[18] Tile_X0Y1_FrameStrobe[6] Tile_X0Y0_IHP_SRAM_top.Inst_IHP_SRAM_top_ConfigMem.Inst_frame6_bit18.Q
+ VPWR VGND sg13g2_dlhq_1
XFILLER_43_29 VPWR VGND sg13g2_fill_2
XFILLER_108_44 VPWR VGND sg13g2_decap_8
XFILLER_104_7 VPWR VGND sg13g2_fill_1
XFILLER_31_207 VPWR VGND sg13g2_fill_1
XFILLER_33_73 VPWR VGND sg13g2_decap_8
X_0370_ VPWR VGND _0064_ _0065_ Tile_X0Y0_IHP_SRAM_top.Inst_IHP_SRAM_top_ConfigMem.Inst_frame0_bit29.Q
+ _0004_ _0066_ Tile_X0Y0_IHP_SRAM_top.Inst_IHP_SRAM_top_ConfigMem.Inst_frame0_bit28.Q
+ sg13g2_a221oi_1
XFILLER_90_90 VPWR VGND sg13g2_fill_2
X_1686_ Tile_X0Y1_IHP_SRAM_bot.Inst_IHP_SRAM_bot_switch_matrix.W2BEG3 net291 VPWR
+ VGND sg13g2_buf_1
X_0706_ Tile_X0Y1_IHP_SRAM_bot.Inst_IHP_SRAM_bot_ConfigMem.Inst_frame3_bit6.Q Tile_X0Y1_EE4END[5]
+ Tile_X0Y1_EE4END[13] Tile_X0Y1_E6END[5] Tile_X0Y1_IHP_SRAM_bot.Inst_IHP_SRAM_bot_switch_matrix.J_NS4_BEG5
+ Tile_X0Y1_IHP_SRAM_bot.Inst_IHP_SRAM_bot_ConfigMem.Inst_frame3_bit7.Q net71 VPWR
+ VGND sg13g2_mux4_1
X_0568_ VGND VPWR _0014_ _0123_ _0127_ _0126_ sg13g2_a21oi_1
X_0637_ Tile_X0Y1_IHP_SRAM_bot.Inst_IHP_SRAM_bot_ConfigMem.Inst_frame6_bit18.Q A_DOUT_SRAM4
+ A_DOUT_SRAM12 _0080_ _0081_ Tile_X0Y1_IHP_SRAM_bot.Inst_IHP_SRAM_bot_ConfigMem.Inst_frame6_bit19.Q
+ Tile_X0Y1_IHP_SRAM_bot.Inst_IHP_SRAM_bot_switch_matrix.W2BEGb4 VPWR VGND sg13g2_mux4_1
X_0499_ Tile_X0Y0_IHP_SRAM_top.Inst_IHP_SRAM_top_ConfigMem.Inst_frame3_bit10.Q Tile_X0Y0_EE4END[6]
+ Tile_X0Y0_EE4END[14] Tile_X0Y0_E6END[6] Tile_X0Y0_IHP_SRAM_top.Inst_IHP_SRAM_top_switch_matrix.J_NS4_BEG6
+ Tile_X0Y0_IHP_SRAM_top.Inst_IHP_SRAM_top_ConfigMem.Inst_frame3_bit11.Q net59 VPWR
+ VGND sg13g2_mux4_1
XFILLER_72_118 VPWR VGND sg13g2_decap_8
XFILLER_110_56 VPWR VGND sg13g2_fill_2
XFILLER_102_4 VPWR VGND sg13g2_fill_2
XFILLER_0_122 VPWR VGND sg13g2_fill_2
XFILLER_0_144 VPWR VGND sg13g2_fill_1
XFILLER_44_94 VPWR VGND sg13g2_fill_1
X_1540_ Tile_X0Y0_IHP_SRAM_top.Inst_IHP_SRAM_top_switch_matrix.N2BEGb2 net145 VPWR
+ VGND sg13g2_buf_1
XFILLER_60_82 VPWR VGND sg13g2_fill_1
X_0422_ Tile_X0Y0_IHP_SRAM_top.Inst_IHP_SRAM_top_ConfigMem.Inst_frame0_bit23.Q Tile_X0Y0_IHP_SRAM_top.Inst_IHP_SRAM_top_switch_matrix.N2BEGb7
+ Tile_X0Y0_S2MID[7] Tile_X0Y1_N2MID[7] Tile_X0Y0_S2END[7] Tile_X0Y0_IHP_SRAM_top.Inst_IHP_SRAM_top_ConfigMem.Inst_frame0_bit22.Q
+ Tile_X0Y0_IHP_SRAM_top.Inst_IHP_SRAM_top_switch_matrix.J_NS2_BEG7 VPWR VGND sg13g2_mux4_1
X_1471_ VPWR VGND A_TIE_HIGH_SRAM sg13g2_tiehi
X_0353_ Tile_X0Y1_IHP_SRAM_bot.Inst_IHP_SRAM_bot_ConfigMem.Inst_frame1_bit0.Q Tile_X0Y1_E2MID[3]
+ Tile_X0Y1_E2MID[6] Tile_X0Y1_E2END[1] Tile_X0Y1_E2END[2] Tile_X0Y1_IHP_SRAM_bot.Inst_IHP_SRAM_bot_ConfigMem.Inst_frame1_bit1.Q
+ _0053_ VPWR VGND sg13g2_mux4_1
XFILLER_39_126 VPWR VGND sg13g2_fill_2
XFILLER_93_0 VPWR VGND sg13g2_decap_8
X_1669_ Tile_X0Y0_S4END[14] net280 VPWR VGND sg13g2_buf_1
XFILLER_65_16 VPWR VGND sg13g2_fill_2
XFILLER_38_192 VPWR VGND sg13g2_fill_1
XFILLER_14_97 VPWR VGND sg13g2_decap_4
XFILLER_107_186 VPWR VGND sg13g2_decap_8
XFILLER_36_107 VPWR VGND sg13g2_fill_1
XFILLER_44_140 VPWR VGND sg13g2_decap_4
XFILLER_44_162 VPWR VGND sg13g2_fill_2
X_0971_ Tile_X0Y0_FrameData[19] Tile_X0Y1_FrameStrobe[3] Tile_X0Y0_IHP_SRAM_top.Inst_IHP_SRAM_top_ConfigMem.Inst_frame3_bit19.Q
+ VPWR VGND sg13g2_dlhq_1
X_1523_ Tile_X0Y1_FrameStrobe[17] net119 VPWR VGND sg13g2_buf_1
Xoutput327 net327 Tile_X0Y1_WW4BEG[5] VPWR VGND sg13g2_buf_1
Xoutput316 net316 Tile_X0Y1_WW4BEG[0] VPWR VGND sg13g2_buf_1
Xoutput305 net305 Tile_X0Y1_W6BEG[10] VPWR VGND sg13g2_buf_1
X_1454_ Tile_X0Y1_FrameData[26] Tile_X0Y1_FrameStrobe[9] Tile_X0Y1_IHP_SRAM_bot.Inst_IHP_SRAM_bot_ConfigMem.Inst_frame9_bit26.Q
+ VPWR VGND sg13g2_dlhq_1
X_0336_ VPWR _0039_ Tile_X0Y0_IHP_SRAM_top.Inst_IHP_SRAM_top_switch_matrix.J_NS2_BEG1
+ VGND sg13g2_inv_1
X_1385_ Tile_X0Y1_FrameData[31] Tile_X0Y1_FrameStrobe[7] Tile_X0Y1_IHP_SRAM_bot.Inst_IHP_SRAM_bot_ConfigMem.Inst_frame7_bit31.Q
+ VPWR VGND sg13g2_dlhq_1
X_0405_ Tile_X0Y1_IHP_SRAM_bot.Inst_IHP_SRAM_bot_ConfigMem.Inst_frame0_bit16.Q Tile_X0Y1_N2MID[4]
+ Tile_X0Y1_N2END[4] Tile_X0Y0_IHP_SRAM_top.Inst_IHP_SRAM_top_switch_matrix.S2BEG4
+ Tile_X0Y0_S2MID[4] Tile_X0Y1_IHP_SRAM_bot.Inst_IHP_SRAM_bot_ConfigMem.Inst_frame0_bit17.Q
+ _0081_ VPWR VGND sg13g2_mux4_1
XFILLER_35_184 VPWR VGND sg13g2_decap_4
XFILLER_50_132 VPWR VGND sg13g2_fill_2
XFILLER_51_29 VPWR VGND sg13g2_decap_8
XFILLER_104_178 VPWR VGND sg13g2_decap_8
XFILLER_25_74 VPWR VGND sg13g2_fill_1
XFILLER_41_110 VPWR VGND sg13g2_fill_1
XFILLER_110_137 VPWR VGND sg13g2_fill_2
XFILLER_110_126 VPWR VGND sg13g2_decap_8
XFILLER_110_115 VPWR VGND sg13g2_decap_8
X_1170_ Tile_X0Y1_FrameData[22] Tile_X0Y1_FrameStrobe[0] Tile_X0Y1_IHP_SRAM_bot.Inst_IHP_SRAM_bot_ConfigMem.Inst_frame0_bit22.Q
+ VPWR VGND sg13g2_dlhq_1
XFILLER_32_143 VPWR VGND sg13g2_decap_4
XANTENNA_39 VPWR VGND Tile_X0Y1_FrameStrobe[16] sg13g2_antennanp
X_0885_ Tile_X0Y0_FrameData[9] Tile_X0Y1_FrameStrobe[0] Tile_X0Y0_IHP_SRAM_top.Inst_IHP_SRAM_top_ConfigMem.Inst_frame0_bit9.Q
+ VPWR VGND sg13g2_dlhq_1
X_0954_ Tile_X0Y0_FrameData[4] Tile_X0Y1_FrameStrobe[2] Tile_X0Y0_IHP_SRAM_top.Inst_IHP_SRAM_top_ConfigMem.Inst_frame2_bit4.Q
+ VPWR VGND sg13g2_dlhq_1
XANTENNA_17 VPWR VGND A_DOUT_SRAM28 sg13g2_antennanp
XANTENNA_28 VPWR VGND Tile_X0Y0_S4END[10] sg13g2_antennanp
Xoutput157 net157 Tile_X0Y0_N4BEG[15] VPWR VGND sg13g2_buf_1
Xoutput146 net146 Tile_X0Y0_N2BEGb[3] VPWR VGND sg13g2_buf_1
Xoutput124 net124 Tile_X0Y0_FrameStrobe_O[3] VPWR VGND sg13g2_buf_1
Xoutput102 net102 Tile_X0Y0_FrameData_O[30] VPWR VGND sg13g2_buf_1
Xoutput113 net113 Tile_X0Y0_FrameStrobe_O[11] VPWR VGND sg13g2_buf_1
Xoutput135 net135 Tile_X0Y0_N2BEG[0] VPWR VGND sg13g2_buf_1
X_1506_ Tile_X0Y1_FrameStrobe[0] net111 VPWR VGND sg13g2_buf_1
XFILLER_101_104 VPWR VGND sg13g2_fill_1
XFILLER_99_143 VPWR VGND sg13g2_fill_2
Xoutput179 net179 Tile_X0Y0_W2BEG[7] VPWR VGND sg13g2_buf_1
X_1437_ Tile_X0Y1_FrameData[11] Tile_X0Y1_FrameStrobe[8] Tile_X0Y1_IHP_SRAM_bot.Inst_IHP_SRAM_bot_ConfigMem.Inst_frame8_bit11.Q
+ VPWR VGND sg13g2_dlhq_1
Xoutput168 net168 Tile_X0Y0_W1BEG[0] VPWR VGND sg13g2_buf_1
XFILLER_101_148 VPWR VGND sg13g2_fill_2
X_1368_ Tile_X0Y1_FrameData[16] Tile_X0Y1_FrameStrobe[6] Tile_X0Y1_IHP_SRAM_bot.Inst_IHP_SRAM_bot_ConfigMem.Inst_frame6_bit16.Q
+ VPWR VGND sg13g2_dlhq_1
X_1299_ Tile_X0Y1_FrameData[21] Tile_X0Y1_FrameStrobe[4] Tile_X0Y1_IHP_SRAM_bot.Inst_IHP_SRAM_bot_ConfigMem.Inst_frame4_bit21.Q
+ VPWR VGND sg13g2_dlhq_1
X_0319_ VPWR _0022_ Tile_X0Y1_IHP_SRAM_bot.Inst_IHP_SRAM_bot_ConfigMem.Inst_frame8_bit6.Q
+ VGND sg13g2_inv_1
XFILLER_23_121 VPWR VGND sg13g2_fill_1
XFILLER_87_14 VPWR VGND sg13g2_fill_1
XFILLER_87_36 VPWR VGND sg13g2_decap_4
XFILLER_46_213 VPWR VGND sg13g2_fill_2
XFILLER_36_84 VPWR VGND sg13g2_fill_1
X_0670_ Tile_X0Y1_IHP_SRAM_bot.Inst_IHP_SRAM_bot_ConfigMem.Inst_frame5_bit28.Q Tile_X0Y1_N4END[1]
+ Tile_X0Y0_S4END[5] Tile_X0Y1_IHP_SRAM_bot.Inst_IHP_SRAM_bot_switch_matrix.J_NS4_BEG10
+ Tile_X0Y1_IHP_SRAM_bot.Inst_IHP_SRAM_bot_switch_matrix.J_NS4_BEG14 Tile_X0Y1_IHP_SRAM_bot.Inst_IHP_SRAM_bot_ConfigMem.Inst_frame5_bit29.Q
+ Tile_X0Y1_IHP_SRAM_bot.Inst_IHP_SRAM_bot_switch_matrix.W6BEG1 VPWR VGND sg13g2_mux4_1
XFILLER_96_102 VPWR VGND sg13g2_decap_4
X_1153_ Tile_X0Y0_FrameData[29] Tile_X0Y1_FrameStrobe[9] Tile_X0Y0_IHP_SRAM_top.Inst_IHP_SRAM_top_ConfigMem.Inst_frame9_bit29.Q
+ VPWR VGND sg13g2_dlhq_1
X_1084_ Tile_X0Y0_FrameData[2] Tile_X0Y1_FrameStrobe[6] Tile_X0Y0_IHP_SRAM_top.Inst_IHP_SRAM_top_ConfigMem.Inst_frame6_bit2.Q
+ VPWR VGND sg13g2_dlhq_1
X_1222_ Tile_X0Y1_FrameData[2] Tile_X0Y1_FrameStrobe[1] Tile_X0Y1_IHP_SRAM_bot.Inst_IHP_SRAM_bot_ConfigMem.Inst_frame1_bit2.Q
+ VPWR VGND sg13g2_dlhq_1
X_0937_ Tile_X0Y0_FrameData[21] Tile_X0Y1_FrameStrobe[2] Tile_X0Y0_IHP_SRAM_top.Inst_IHP_SRAM_top_ConfigMem.Inst_frame2_bit21.Q
+ VPWR VGND sg13g2_dlhq_1
X_0868_ Tile_X0Y0_FrameData[26] Tile_X0Y1_FrameStrobe[0] Tile_X0Y0_IHP_SRAM_top.Inst_IHP_SRAM_top_ConfigMem.Inst_frame0_bit26.Q
+ VPWR VGND sg13g2_dlhq_1
X_0799_ Tile_X0Y1_IHP_SRAM_bot.Inst_IHP_SRAM_bot_ConfigMem.Inst_frame7_bit13.Q VPWR
+ _0237_ VGND Tile_X0Y1_E6END[6] Tile_X0Y1_IHP_SRAM_bot.Inst_IHP_SRAM_bot_ConfigMem.Inst_frame7_bit12.Q
+ sg13g2_o21ai_1
XFILLER_87_102 VPWR VGND sg13g2_fill_1
XFILLER_22_64 VPWR VGND sg13g2_decap_4
XFILLER_93_105 VPWR VGND sg13g2_fill_2
X_0722_ Tile_X0Y1_IHP_SRAM_bot.Inst_IHP_SRAM_bot_ConfigMem.Inst_frame2_bit6.Q Tile_X0Y1_EE4END[5]
+ Tile_X0Y1_EE4END[13] Tile_X0Y1_E6END[5] Tile_X0Y1_IHP_SRAM_bot.Inst_IHP_SRAM_bot_switch_matrix.J_NS4_BEG5
+ Tile_X0Y1_IHP_SRAM_bot.Inst_IHP_SRAM_bot_ConfigMem.Inst_frame2_bit7.Q net38 VPWR
+ VGND sg13g2_mux4_1
X_0653_ Tile_X0Y1_IHP_SRAM_bot.Inst_IHP_SRAM_bot_ConfigMem.Inst_frame1_bit22.Q Tile_X0Y1_N1END[3]
+ Tile_X0Y1_N4END[3] _0074_ Tile_X0Y0_S4END[7] Tile_X0Y1_IHP_SRAM_bot.Inst_IHP_SRAM_bot_ConfigMem.Inst_frame1_bit23.Q
+ Tile_X0Y1_IHP_SRAM_bot.Inst_IHP_SRAM_bot_switch_matrix.J_NS4_BEG7 VPWR VGND sg13g2_mux4_1
X_0584_ VGND VPWR _0016_ _0137_ _0141_ _0140_ sg13g2_a21oi_1
X_1136_ Tile_X0Y0_FrameData[14] Tile_X0Y1_FrameStrobe[8] Tile_X0Y0_IHP_SRAM_top.Inst_IHP_SRAM_top_ConfigMem.Inst_frame8_bit14.Q
+ VPWR VGND sg13g2_dlhq_1
X_1067_ Tile_X0Y0_FrameData[19] Tile_X0Y1_FrameStrobe[6] Tile_X0Y0_IHP_SRAM_top.Inst_IHP_SRAM_top_ConfigMem.Inst_frame6_bit19.Q
+ VPWR VGND sg13g2_dlhq_1
X_1205_ Tile_X0Y1_FrameData[19] Tile_X0Y1_FrameStrobe[1] Tile_X0Y1_IHP_SRAM_bot.Inst_IHP_SRAM_bot_ConfigMem.Inst_frame1_bit19.Q
+ VPWR VGND sg13g2_dlhq_1
XFILLER_108_23 VPWR VGND sg13g2_fill_2
XFILLER_108_12 VPWR VGND sg13g2_decap_8
XFILLER_83_193 VPWR VGND sg13g2_fill_1
X_0636_ Tile_X0Y1_IHP_SRAM_bot.Inst_IHP_SRAM_bot_ConfigMem.Inst_frame6_bit16.Q A_DOUT_SRAM3
+ A_DOUT_SRAM11 _0080_ _0081_ Tile_X0Y1_IHP_SRAM_bot.Inst_IHP_SRAM_bot_ConfigMem.Inst_frame6_bit17.Q
+ Tile_X0Y1_IHP_SRAM_bot.Inst_IHP_SRAM_bot_switch_matrix.W2BEGb3 VPWR VGND sg13g2_mux4_1
X_1685_ Tile_X0Y1_IHP_SRAM_bot.Inst_IHP_SRAM_bot_switch_matrix.W2BEG2 net290 VPWR
+ VGND sg13g2_buf_1
X_0705_ Tile_X0Y1_IHP_SRAM_bot.Inst_IHP_SRAM_bot_ConfigMem.Inst_frame3_bit4.Q Tile_X0Y1_EE4END[4]
+ Tile_X0Y1_EE4END[12] Tile_X0Y1_E6END[4] Tile_X0Y1_IHP_SRAM_bot.Inst_IHP_SRAM_bot_switch_matrix.J_NS4_BEG4
+ Tile_X0Y1_IHP_SRAM_bot.Inst_IHP_SRAM_bot_ConfigMem.Inst_frame3_bit5.Q net70 VPWR
+ VGND sg13g2_mux4_1
X_0567_ Tile_X0Y0_IHP_SRAM_top.Inst_IHP_SRAM_top_ConfigMem.Inst_frame8_bit25.Q VPWR
+ _0126_ VGND _0124_ _0125_ sg13g2_o21ai_1
X_0498_ Tile_X0Y0_IHP_SRAM_top.Inst_IHP_SRAM_top_ConfigMem.Inst_frame3_bit8.Q Tile_X0Y0_EE4END[5]
+ Tile_X0Y0_EE4END[13] Tile_X0Y0_E6END[5] Tile_X0Y0_IHP_SRAM_top.Inst_IHP_SRAM_top_switch_matrix.J_NS4_BEG5
+ Tile_X0Y0_IHP_SRAM_top.Inst_IHP_SRAM_top_ConfigMem.Inst_frame3_bit9.Q net58 VPWR
+ VGND sg13g2_mux4_1
X_1119_ Tile_X0Y0_FrameData[31] Tile_X0Y1_FrameStrobe[8] Tile_X0Y0_IHP_SRAM_top.Inst_IHP_SRAM_top_ConfigMem.Inst_frame8_bit31.Q
+ VPWR VGND sg13g2_dlhq_1
XFILLER_28_52 VPWR VGND sg13g2_decap_8
X_1470_ Tile_X0Y1_FrameData[10] Tile_X0Y1_FrameStrobe[9] Tile_X0Y1_IHP_SRAM_bot.Inst_IHP_SRAM_bot_ConfigMem.Inst_frame9_bit10.Q
+ VPWR VGND sg13g2_dlhq_1
X_0421_ Tile_X0Y1_IHP_SRAM_bot.Inst_IHP_SRAM_bot_ConfigMem.Inst_frame8_bit0.Q Tile_X0Y1_E2MID[0]
+ Tile_X0Y1_E2END[0] Tile_X0Y1_E6END[0] _0084_ Tile_X0Y1_IHP_SRAM_bot.Inst_IHP_SRAM_bot_ConfigMem.Inst_frame8_bit1.Q
+ Tile_X0Y0_IHP_SRAM_top.Inst_IHP_SRAM_top_switch_matrix.N2BEGb7 VPWR VGND sg13g2_mux4_1
X_0352_ _0047_ VPWR _0052_ VGND Tile_X0Y1_IHP_SRAM_bot.Inst_IHP_SRAM_bot_ConfigMem.Inst_frame1_bit0.Q
+ _0051_ sg13g2_o21ai_1
X_1668_ Tile_X0Y0_S4END[13] net279 VPWR VGND sg13g2_buf_1
XFILLER_85_200 VPWR VGND sg13g2_decap_4
X_1599_ Tile_X0Y0_IHP_SRAM_top.Inst_IHP_SRAM_top_switch_matrix.WW4BEG4 net210 VPWR
+ VGND sg13g2_buf_1
X_0619_ Tile_X0Y1_IHP_SRAM_bot.Inst_IHP_SRAM_bot_ConfigMem.Inst_frame7_bit2.Q Tile_X0Y1_E1END[2]
+ Tile_X0Y1_E2MID[1] Tile_X0Y1_E2END[1] _0083_ Tile_X0Y1_IHP_SRAM_bot.Inst_IHP_SRAM_bot_ConfigMem.Inst_frame7_bit3.Q
+ Tile_X0Y1_IHP_SRAM_bot.Inst_IHP_SRAM_bot_switch_matrix.S2BEG6 VPWR VGND sg13g2_mux4_1
XFILLER_107_165 VPWR VGND sg13g2_decap_8
X_0970_ Tile_X0Y0_FrameData[20] Tile_X0Y1_FrameStrobe[3] Tile_X0Y0_IHP_SRAM_top.Inst_IHP_SRAM_top_ConfigMem.Inst_frame3_bit20.Q
+ VPWR VGND sg13g2_dlhq_1
X_1522_ Tile_X0Y1_FrameStrobe[16] net118 VPWR VGND sg13g2_buf_1
X_0404_ Tile_X0Y0_IHP_SRAM_top.Inst_IHP_SRAM_top_ConfigMem.Inst_frame7_bit11.Q Tile_X0Y0_E1END[0]
+ Tile_X0Y0_E2END[3] Tile_X0Y0_E2MID[3] Tile_X0Y0_IHP_SRAM_top.Inst_IHP_SRAM_top_switch_matrix.J_NS2_BEG4
+ Tile_X0Y0_IHP_SRAM_top.Inst_IHP_SRAM_top_ConfigMem.Inst_frame7_bit10.Q Tile_X0Y0_IHP_SRAM_top.Inst_IHP_SRAM_top_switch_matrix.S2BEG4
+ VPWR VGND sg13g2_mux4_1
Xoutput328 net328 Tile_X0Y1_WW4BEG[6] VPWR VGND sg13g2_buf_1
Xoutput317 net317 Tile_X0Y1_WW4BEG[10] VPWR VGND sg13g2_buf_1
Xoutput306 net306 Tile_X0Y1_W6BEG[11] VPWR VGND sg13g2_buf_1
X_1453_ Tile_X0Y1_FrameData[27] Tile_X0Y1_FrameStrobe[9] Tile_X0Y1_IHP_SRAM_bot.Inst_IHP_SRAM_bot_ConfigMem.Inst_frame9_bit27.Q
+ VPWR VGND sg13g2_dlhq_1
X_0335_ VPWR _0038_ Tile_X0Y0_IHP_SRAM_top.Inst_IHP_SRAM_top_switch_matrix.J_NS2_BEG0
+ VGND sg13g2_inv_1
XFILLER_67_211 VPWR VGND sg13g2_fill_1
X_1384_ Tile_X0Y1_FrameData[0] Tile_X0Y1_FrameStrobe[6] Tile_X0Y1_IHP_SRAM_bot.Inst_IHP_SRAM_bot_ConfigMem.Inst_frame6_bit0.Q
+ VPWR VGND sg13g2_dlhq_1
XFILLER_104_157 VPWR VGND sg13g2_decap_8
XFILLER_64_214 VPWR VGND sg13g2_fill_2
XFILLER_17_130 VPWR VGND sg13g2_fill_1
XANTENNA_18 VPWR VGND A_DOUT_SRAM28 sg13g2_antennanp
XANTENNA_29 VPWR VGND Tile_X0Y0_S4END[10] sg13g2_antennanp
Xoutput114 net114 Tile_X0Y0_FrameStrobe_O[12] VPWR VGND sg13g2_buf_1
Xoutput125 net125 Tile_X0Y0_FrameStrobe_O[4] VPWR VGND sg13g2_buf_1
Xoutput103 net103 Tile_X0Y0_FrameData_O[31] VPWR VGND sg13g2_buf_1
X_0884_ Tile_X0Y0_FrameData[10] Tile_X0Y1_FrameStrobe[0] Tile_X0Y0_IHP_SRAM_top.Inst_IHP_SRAM_top_ConfigMem.Inst_frame0_bit10.Q
+ VPWR VGND sg13g2_dlhq_1
X_0953_ Tile_X0Y0_FrameData[5] Tile_X0Y1_FrameStrobe[2] Tile_X0Y0_IHP_SRAM_top.Inst_IHP_SRAM_top_ConfigMem.Inst_frame2_bit5.Q
+ VPWR VGND sg13g2_dlhq_1
XFILLER_63_2 VPWR VGND sg13g2_fill_1
X_1505_ Tile_X0Y0_FrameData[31] net103 VPWR VGND sg13g2_buf_1
Xoutput158 net158 Tile_X0Y0_N4BEG[1] VPWR VGND sg13g2_buf_1
Xoutput147 net147 Tile_X0Y0_N2BEGb[4] VPWR VGND sg13g2_buf_1
Xoutput136 net136 Tile_X0Y0_N2BEG[1] VPWR VGND sg13g2_buf_1
Xoutput169 net169 Tile_X0Y0_W1BEG[1] VPWR VGND sg13g2_buf_1
X_1367_ Tile_X0Y1_FrameData[17] Tile_X0Y1_FrameStrobe[6] Tile_X0Y1_IHP_SRAM_bot.Inst_IHP_SRAM_bot_ConfigMem.Inst_frame6_bit17.Q
+ VPWR VGND sg13g2_dlhq_1
XFILLER_49_0 VPWR VGND sg13g2_fill_2
X_1436_ Tile_X0Y1_FrameData[12] Tile_X0Y1_FrameStrobe[8] Tile_X0Y1_IHP_SRAM_bot.Inst_IHP_SRAM_bot_ConfigMem.Inst_frame8_bit12.Q
+ VPWR VGND sg13g2_dlhq_1
X_1298_ Tile_X0Y1_FrameData[22] Tile_X0Y1_FrameStrobe[4] Tile_X0Y1_IHP_SRAM_bot.Inst_IHP_SRAM_bot_ConfigMem.Inst_frame4_bit22.Q
+ VPWR VGND sg13g2_dlhq_1
X_0318_ VPWR _0021_ Tile_X0Y1_IHP_SRAM_bot.Inst_IHP_SRAM_bot_ConfigMem.Inst_frame8_bit5.Q
+ VGND sg13g2_inv_1
XFILLER_77_70 VPWR VGND sg13g2_fill_1
X_1221_ Tile_X0Y1_FrameData[3] Tile_X0Y1_FrameStrobe[1] Tile_X0Y1_IHP_SRAM_bot.Inst_IHP_SRAM_bot_ConfigMem.Inst_frame1_bit3.Q
+ VPWR VGND sg13g2_dlhq_1
XFILLER_42_7 VPWR VGND sg13g2_decap_8
X_1152_ Tile_X0Y0_FrameData[30] Tile_X0Y1_FrameStrobe[9] Tile_X0Y0_IHP_SRAM_top.Inst_IHP_SRAM_top_ConfigMem.Inst_frame9_bit30.Q
+ VPWR VGND sg13g2_dlhq_1
X_1083_ Tile_X0Y0_FrameData[3] Tile_X0Y1_FrameStrobe[6] Tile_X0Y0_IHP_SRAM_top.Inst_IHP_SRAM_top_ConfigMem.Inst_frame6_bit3.Q
+ VPWR VGND sg13g2_dlhq_1
X_0936_ Tile_X0Y0_FrameData[22] Tile_X0Y1_FrameStrobe[2] Tile_X0Y0_IHP_SRAM_top.Inst_IHP_SRAM_top_ConfigMem.Inst_frame2_bit22.Q
+ VPWR VGND sg13g2_dlhq_1
XFILLER_20_114 VPWR VGND sg13g2_fill_1
XFILLER_20_136 VPWR VGND sg13g2_fill_2
X_0867_ Tile_X0Y0_FrameData[27] Tile_X0Y1_FrameStrobe[0] Tile_X0Y0_IHP_SRAM_top.Inst_IHP_SRAM_top_ConfigMem.Inst_frame0_bit27.Q
+ VPWR VGND sg13g2_dlhq_1
X_0798_ VGND VPWR _0229_ _0231_ Tile_X0Y1_IHP_SRAM_bot.Inst_IHP_SRAM_bot_switch_matrix.S4BEG1
+ _0236_ sg13g2_a21oi_1
XFILLER_95_191 VPWR VGND sg13g2_fill_1
X_1419_ Tile_X0Y1_FrameData[29] Tile_X0Y1_FrameStrobe[8] Tile_X0Y1_IHP_SRAM_bot.Inst_IHP_SRAM_bot_ConfigMem.Inst_frame8_bit29.Q
+ VPWR VGND sg13g2_dlhq_1
XFILLER_78_103 VPWR VGND sg13g2_decap_4
XFILLER_93_128 VPWR VGND sg13g2_decap_8
XFILLER_19_203 VPWR VGND sg13g2_fill_1
XFILLER_47_51 VPWR VGND sg13g2_fill_2
XFILLER_47_95 VPWR VGND sg13g2_decap_8
XFILLER_63_50 VPWR VGND sg13g2_decap_8
XFILLER_8_23 VPWR VGND sg13g2_fill_1
X_0583_ Tile_X0Y0_IHP_SRAM_top.Inst_IHP_SRAM_top_ConfigMem.Inst_frame7_bit23.Q VPWR
+ _0140_ VGND _0138_ _0139_ sg13g2_o21ai_1
XFILLER_6_151 VPWR VGND sg13g2_fill_2
X_0652_ Tile_X0Y1_IHP_SRAM_bot.Inst_IHP_SRAM_bot_ConfigMem.Inst_frame5_bit8.Q A_DOUT_SRAM7
+ A_DOUT_SRAM11 Tile_X0Y1_IHP_SRAM_bot.Inst_IHP_SRAM_bot_switch_matrix.J_NS4_BEG8
+ _0043_ Tile_X0Y1_IHP_SRAM_bot.Inst_IHP_SRAM_bot_ConfigMem.Inst_frame5_bit9.Q Tile_X0Y1_IHP_SRAM_bot.Inst_IHP_SRAM_bot_switch_matrix.WW4BEG7
+ VPWR VGND sg13g2_mux4_1
X_0721_ Tile_X0Y1_IHP_SRAM_bot.Inst_IHP_SRAM_bot_ConfigMem.Inst_frame2_bit4.Q Tile_X0Y1_EE4END[4]
+ Tile_X0Y1_EE4END[12] Tile_X0Y1_E6END[4] Tile_X0Y1_IHP_SRAM_bot.Inst_IHP_SRAM_bot_switch_matrix.J_NS4_BEG4
+ Tile_X0Y1_IHP_SRAM_bot.Inst_IHP_SRAM_bot_ConfigMem.Inst_frame2_bit5.Q net37 VPWR
+ VGND sg13g2_mux4_1
XFILLER_40_4 VPWR VGND sg13g2_fill_2
X_1204_ Tile_X0Y1_FrameData[20] Tile_X0Y1_FrameStrobe[1] Tile_X0Y1_IHP_SRAM_bot.Inst_IHP_SRAM_bot_ConfigMem.Inst_frame1_bit20.Q
+ VPWR VGND sg13g2_dlhq_1
XFILLER_92_150 VPWR VGND sg13g2_fill_2
X_1135_ Tile_X0Y0_FrameData[15] Tile_X0Y1_FrameStrobe[8] Tile_X0Y0_IHP_SRAM_top.Inst_IHP_SRAM_top_ConfigMem.Inst_frame8_bit15.Q
+ VPWR VGND sg13g2_dlhq_1
X_1066_ Tile_X0Y0_FrameData[20] Tile_X0Y1_FrameStrobe[6] Tile_X0Y0_IHP_SRAM_top.Inst_IHP_SRAM_top_ConfigMem.Inst_frame6_bit20.Q
+ VPWR VGND sg13g2_dlhq_1
X_0919_ Tile_X0Y0_FrameData[7] Tile_X0Y1_FrameStrobe[1] Tile_X0Y0_IHP_SRAM_top.Inst_IHP_SRAM_top_ConfigMem.Inst_frame1_bit7.Q
+ VPWR VGND sg13g2_dlhq_1
XFILLER_108_79 VPWR VGND sg13g2_decap_8
XFILLER_102_200 VPWR VGND sg13g2_decap_4
XFILLER_84_49 VPWR VGND sg13g2_decap_4
XFILLER_75_106 VPWR VGND sg13g2_fill_1
XFILLER_98_209 VPWR VGND sg13g2_fill_2
XFILLER_58_83 VPWR VGND sg13g2_fill_1
XFILLER_58_72 VPWR VGND sg13g2_decap_8
XFILLER_3_187 VPWR VGND sg13g2_decap_8
XFILLER_22_209 VPWR VGND sg13g2_fill_2
XFILLER_90_70 VPWR VGND sg13g2_decap_8
XFILLER_88_4 VPWR VGND sg13g2_fill_1
X_0566_ Tile_X0Y0_IHP_SRAM_top.Inst_IHP_SRAM_top_ConfigMem.Inst_frame8_bit24.Q VPWR
+ _0125_ VGND Tile_X0Y0_IHP_SRAM_top.Inst_IHP_SRAM_top_ConfigMem.Inst_frame8_bit23.Q
+ Tile_X0Y0_IHP_SRAM_top.Inst_IHP_SRAM_top_switch_matrix.J_NS4_BEG15 sg13g2_o21ai_1
X_0635_ Tile_X0Y1_IHP_SRAM_bot.Inst_IHP_SRAM_bot_ConfigMem.Inst_frame6_bit14.Q A_DOUT_SRAM2
+ A_DOUT_SRAM10 _0079_ _0082_ Tile_X0Y1_IHP_SRAM_bot.Inst_IHP_SRAM_bot_ConfigMem.Inst_frame6_bit15.Q
+ Tile_X0Y1_IHP_SRAM_bot.Inst_IHP_SRAM_bot_switch_matrix.W2BEGb2 VPWR VGND sg13g2_mux4_1
X_1684_ Tile_X0Y1_IHP_SRAM_bot.Inst_IHP_SRAM_bot_switch_matrix.W2BEG1 net289 VPWR
+ VGND sg13g2_buf_1
XFILLER_31_0 VPWR VGND sg13g2_fill_1
X_0704_ Tile_X0Y1_IHP_SRAM_bot.Inst_IHP_SRAM_bot_ConfigMem.Inst_frame3_bit2.Q Tile_X0Y1_EE4END[3]
+ Tile_X0Y1_EE4END[11] Tile_X0Y1_E6END[3] _0158_ Tile_X0Y1_IHP_SRAM_bot.Inst_IHP_SRAM_bot_ConfigMem.Inst_frame3_bit3.Q
+ net67 VPWR VGND sg13g2_mux4_1
X_0497_ Tile_X0Y0_IHP_SRAM_top.Inst_IHP_SRAM_top_ConfigMem.Inst_frame3_bit6.Q Tile_X0Y0_EE4END[4]
+ Tile_X0Y0_EE4END[12] Tile_X0Y0_E6END[4] Tile_X0Y0_IHP_SRAM_top.Inst_IHP_SRAM_top_switch_matrix.J_NS4_BEG4
+ Tile_X0Y0_IHP_SRAM_top.Inst_IHP_SRAM_top_ConfigMem.Inst_frame3_bit7.Q net57 VPWR
+ VGND sg13g2_mux4_1
XFILLER_110_58 VPWR VGND sg13g2_fill_1
X_1118_ Tile_X0Y0_FrameData[0] Tile_X0Y1_FrameStrobe[7] Tile_X0Y0_IHP_SRAM_top.Inst_IHP_SRAM_top_ConfigMem.Inst_frame7_bit0.Q
+ VPWR VGND sg13g2_dlhq_1
X_1049_ Tile_X0Y0_FrameData[5] Tile_X0Y1_FrameStrobe[5] Tile_X0Y0_IHP_SRAM_top.Inst_IHP_SRAM_top_ConfigMem.Inst_frame5_bit5.Q
+ VPWR VGND sg13g2_dlhq_1
XFILLER_56_183 VPWR VGND sg13g2_decap_8
XFILLER_60_51 VPWR VGND sg13g2_fill_2
XFILLER_69_93 VPWR VGND sg13g2_fill_2
XFILLER_69_82 VPWR VGND sg13g2_decap_8
X_0420_ Tile_X0Y1_IHP_SRAM_bot.Inst_IHP_SRAM_bot_ConfigMem.Inst_frame0_bit22.Q Tile_X0Y1_N2MID[7]
+ Tile_X0Y1_N2END[7] Tile_X0Y0_IHP_SRAM_top.Inst_IHP_SRAM_top_switch_matrix.S2BEG7
+ Tile_X0Y0_S2MID[7] Tile_X0Y1_IHP_SRAM_bot.Inst_IHP_SRAM_bot_ConfigMem.Inst_frame0_bit23.Q
+ _0084_ VPWR VGND sg13g2_mux4_1
XFILLER_39_128 VPWR VGND sg13g2_fill_1
X_0351_ _0050_ VPWR _0051_ VGND Tile_X0Y1_IHP_SRAM_bot.Inst_IHP_SRAM_bot_ConfigMem.Inst_frame1_bit1.Q
+ _0049_ sg13g2_o21ai_1
X_1667_ Tile_X0Y0_S4END[12] net278 VPWR VGND sg13g2_buf_1
XFILLER_105_25 VPWR VGND sg13g2_decap_8
X_0549_ Tile_X0Y0_IHP_SRAM_top.Inst_IHP_SRAM_top_switch_matrix.J_NS2_BEG1 Tile_X0Y0_IHP_SRAM_top.Inst_IHP_SRAM_top_ConfigMem.Inst_frame8_bit17.Q
+ _0110_ VPWR VGND sg13g2_nor2b_1
X_1598_ Tile_X0Y0_IHP_SRAM_top.Inst_IHP_SRAM_top_switch_matrix.WW4BEG3 net209 VPWR
+ VGND sg13g2_buf_1
X_0618_ Tile_X0Y1_IHP_SRAM_bot.Inst_IHP_SRAM_bot_ConfigMem.Inst_frame7_bit0.Q Tile_X0Y1_E1END[1]
+ Tile_X0Y1_E2MID[2] Tile_X0Y1_E2END[2] _0082_ Tile_X0Y1_IHP_SRAM_bot.Inst_IHP_SRAM_bot_ConfigMem.Inst_frame7_bit1.Q
+ Tile_X0Y1_IHP_SRAM_bot.Inst_IHP_SRAM_bot_switch_matrix.S2BEG5 VPWR VGND sg13g2_mux4_1
XFILLER_65_18 VPWR VGND sg13g2_fill_1
XFILLER_107_144 VPWR VGND sg13g2_decap_8
XFILLER_30_76 VPWR VGND sg13g2_decap_8
XFILLER_55_62 VPWR VGND sg13g2_fill_2
Xoutput307 net307 Tile_X0Y1_W6BEG[1] VPWR VGND sg13g2_buf_1
X_1521_ Tile_X0Y1_FrameStrobe[15] net117 VPWR VGND sg13g2_buf_1
X_0403_ Tile_X0Y0_IHP_SRAM_top.Inst_IHP_SRAM_top_ConfigMem.Inst_frame8_bit4.Q Tile_X0Y0_E2MID[4]
+ Tile_X0Y0_E2END[4] Tile_X0Y0_E6END[4] Tile_X0Y0_IHP_SRAM_top.Inst_IHP_SRAM_top_switch_matrix.J_NS2_BEG3
+ Tile_X0Y0_IHP_SRAM_top.Inst_IHP_SRAM_top_ConfigMem.Inst_frame8_bit5.Q Tile_X0Y0_IHP_SRAM_top.Inst_IHP_SRAM_top_switch_matrix.N2BEG3
+ VPWR VGND sg13g2_mux4_1
X_1383_ Tile_X0Y1_FrameData[1] Tile_X0Y1_FrameStrobe[6] Tile_X0Y1_IHP_SRAM_bot.Inst_IHP_SRAM_bot_ConfigMem.Inst_frame6_bit1.Q
+ VPWR VGND sg13g2_dlhq_1
Xoutput329 net329 Tile_X0Y1_WW4BEG[7] VPWR VGND sg13g2_buf_1
Xoutput318 net318 Tile_X0Y1_WW4BEG[11] VPWR VGND sg13g2_buf_1
X_1452_ Tile_X0Y1_FrameData[28] Tile_X0Y1_FrameStrobe[9] Tile_X0Y1_IHP_SRAM_bot.Inst_IHP_SRAM_bot_ConfigMem.Inst_frame9_bit28.Q
+ VPWR VGND sg13g2_dlhq_1
XFILLER_35_120 VPWR VGND sg13g2_decap_8
X_0334_ VPWR _0037_ Tile_X0Y1_IHP_SRAM_bot.Inst_IHP_SRAM_bot_ConfigMem.Inst_frame1_bit5.Q
+ VGND sg13g2_inv_1
XFILLER_50_189 VPWR VGND sg13g2_fill_1
XFILLER_104_136 VPWR VGND sg13g2_decap_8
X_1719_ Tile_X0Y1_IHP_SRAM_bot.Inst_IHP_SRAM_bot_switch_matrix.WW4BEG8 net330 VPWR
+ VGND sg13g2_buf_1
XFILLER_76_39 VPWR VGND sg13g2_fill_2
XFILLER_25_87 VPWR VGND sg13g2_decap_8
XFILLER_41_134 VPWR VGND sg13g2_decap_8
XFILLER_25_98 VPWR VGND sg13g2_fill_1
XFILLER_41_20 VPWR VGND sg13g2_fill_2
XFILLER_9_0 VPWR VGND sg13g2_fill_1
XFILLER_2_25 VPWR VGND sg13g2_fill_2
XANTENNA_19 VPWR VGND net163 sg13g2_antennanp
X_0952_ Tile_X0Y0_FrameData[6] Tile_X0Y1_FrameStrobe[2] Tile_X0Y0_IHP_SRAM_top.Inst_IHP_SRAM_top_ConfigMem.Inst_frame2_bit6.Q
+ VPWR VGND sg13g2_dlhq_1
Xoutput159 net159 Tile_X0Y0_N4BEG[2] VPWR VGND sg13g2_buf_1
Xoutput148 net148 Tile_X0Y0_N2BEGb[5] VPWR VGND sg13g2_buf_1
Xoutput137 net137 Tile_X0Y0_N2BEG[2] VPWR VGND sg13g2_buf_1
Xoutput126 net126 Tile_X0Y0_FrameStrobe_O[5] VPWR VGND sg13g2_buf_1
X_1504_ Tile_X0Y0_FrameData[30] net102 VPWR VGND sg13g2_buf_1
Xoutput115 net115 Tile_X0Y0_FrameStrobe_O[13] VPWR VGND sg13g2_buf_1
X_0883_ Tile_X0Y0_FrameData[11] Tile_X0Y1_FrameStrobe[0] Tile_X0Y0_IHP_SRAM_top.Inst_IHP_SRAM_top_ConfigMem.Inst_frame0_bit11.Q
+ VPWR VGND sg13g2_dlhq_1
Xoutput104 net104 Tile_X0Y0_FrameData_O[3] VPWR VGND sg13g2_buf_1
XFILLER_99_189 VPWR VGND sg13g2_decap_8
X_1366_ Tile_X0Y1_FrameData[18] Tile_X0Y1_FrameStrobe[6] Tile_X0Y1_IHP_SRAM_bot.Inst_IHP_SRAM_bot_ConfigMem.Inst_frame6_bit18.Q
+ VPWR VGND sg13g2_dlhq_1
X_0317_ VPWR _0020_ Tile_X0Y1_IHP_SRAM_bot.Inst_IHP_SRAM_bot_ConfigMem.Inst_frame8_bit3.Q
+ VGND sg13g2_inv_1
X_1435_ Tile_X0Y1_FrameData[13] Tile_X0Y1_FrameStrobe[8] Tile_X0Y1_IHP_SRAM_bot.Inst_IHP_SRAM_bot_ConfigMem.Inst_frame8_bit13.Q
+ VPWR VGND sg13g2_dlhq_1
XFILLER_102_48 VPWR VGND sg13g2_fill_2
X_1297_ Tile_X0Y1_FrameData[23] Tile_X0Y1_FrameStrobe[4] Tile_X0Y1_IHP_SRAM_bot.Inst_IHP_SRAM_bot_ConfigMem.Inst_frame4_bit23.Q
+ VPWR VGND sg13g2_dlhq_1
XFILLER_36_20 VPWR VGND sg13g2_fill_1
XFILLER_46_215 VPWR VGND sg13g2_fill_1
XFILLER_52_96 VPWR VGND sg13g2_fill_1
X_1151_ Tile_X0Y0_FrameData[31] Tile_X0Y1_FrameStrobe[9] Tile_X0Y0_IHP_SRAM_top.Inst_IHP_SRAM_top_ConfigMem.Inst_frame9_bit31.Q
+ VPWR VGND sg13g2_dlhq_1
X_1220_ Tile_X0Y1_FrameData[4] Tile_X0Y1_FrameStrobe[1] Tile_X0Y1_IHP_SRAM_bot.Inst_IHP_SRAM_bot_ConfigMem.Inst_frame1_bit4.Q
+ VPWR VGND sg13g2_dlhq_1
X_1082_ Tile_X0Y0_FrameData[4] Tile_X0Y1_FrameStrobe[6] Tile_X0Y0_IHP_SRAM_top.Inst_IHP_SRAM_top_ConfigMem.Inst_frame6_bit4.Q
+ VPWR VGND sg13g2_dlhq_1
X_0935_ Tile_X0Y0_FrameData[23] Tile_X0Y1_FrameStrobe[2] Tile_X0Y0_IHP_SRAM_top.Inst_IHP_SRAM_top_ConfigMem.Inst_frame2_bit23.Q
+ VPWR VGND sg13g2_dlhq_1
X_0866_ Tile_X0Y0_FrameData[28] Tile_X0Y1_FrameStrobe[0] Tile_X0Y0_IHP_SRAM_top.Inst_IHP_SRAM_top_ConfigMem.Inst_frame0_bit28.Q
+ VPWR VGND sg13g2_dlhq_1
XFILLER_9_171 VPWR VGND sg13g2_fill_1
X_0797_ VGND VPWR _0030_ _0234_ _0236_ _0235_ sg13g2_a21oi_1
XFILLER_87_137 VPWR VGND sg13g2_decap_4
X_1349_ Tile_X0Y1_FrameData[3] Tile_X0Y1_FrameStrobe[5] Tile_X0Y1_IHP_SRAM_bot.Inst_IHP_SRAM_bot_ConfigMem.Inst_frame5_bit3.Q
+ VPWR VGND sg13g2_dlhq_1
X_1418_ Tile_X0Y1_FrameData[30] Tile_X0Y1_FrameStrobe[8] Tile_X0Y1_IHP_SRAM_bot.Inst_IHP_SRAM_bot_ConfigMem.Inst_frame8_bit30.Q
+ VPWR VGND sg13g2_dlhq_1
XFILLER_103_91 VPWR VGND sg13g2_decap_8
X_0720_ Tile_X0Y1_IHP_SRAM_bot.Inst_IHP_SRAM_bot_ConfigMem.Inst_frame2_bit2.Q Tile_X0Y1_EE4END[3]
+ Tile_X0Y1_EE4END[11] Tile_X0Y1_E6END[3] _0158_ Tile_X0Y1_IHP_SRAM_bot.Inst_IHP_SRAM_bot_ConfigMem.Inst_frame2_bit3.Q
+ net34 VPWR VGND sg13g2_mux4_1
XFILLER_111_201 VPWR VGND sg13g2_fill_1
X_0582_ Tile_X0Y0_IHP_SRAM_top.Inst_IHP_SRAM_top_ConfigMem.Inst_frame7_bit22.Q VPWR
+ _0139_ VGND Tile_X0Y0_IHP_SRAM_top.Inst_IHP_SRAM_top_ConfigMem.Inst_frame7_bit21.Q
+ Tile_X0Y0_IHP_SRAM_top.Inst_IHP_SRAM_top_switch_matrix.J_NS4_BEG13 sg13g2_o21ai_1
XFILLER_69_126 VPWR VGND sg13g2_decap_4
X_0651_ Tile_X0Y1_IHP_SRAM_bot.Inst_IHP_SRAM_bot_ConfigMem.Inst_frame1_bit24.Q Tile_X0Y1_N1END[0]
+ Tile_X0Y1_N4END[0] _0088_ Tile_X0Y0_S4END[4] Tile_X0Y1_IHP_SRAM_bot.Inst_IHP_SRAM_bot_ConfigMem.Inst_frame1_bit25.Q
+ Tile_X0Y1_IHP_SRAM_bot.Inst_IHP_SRAM_bot_switch_matrix.J_NS4_BEG8 VPWR VGND sg13g2_mux4_1
X_1134_ Tile_X0Y0_FrameData[16] Tile_X0Y1_FrameStrobe[8] Tile_X0Y0_IHP_SRAM_top.Inst_IHP_SRAM_top_ConfigMem.Inst_frame8_bit16.Q
+ VPWR VGND sg13g2_dlhq_1
X_1203_ Tile_X0Y1_FrameData[21] Tile_X0Y1_FrameStrobe[1] Tile_X0Y1_IHP_SRAM_bot.Inst_IHP_SRAM_bot_ConfigMem.Inst_frame1_bit21.Q
+ VPWR VGND sg13g2_dlhq_1
X_1065_ Tile_X0Y0_FrameData[21] Tile_X0Y1_FrameStrobe[6] Tile_X0Y0_IHP_SRAM_top.Inst_IHP_SRAM_top_ConfigMem.Inst_frame6_bit21.Q
+ VPWR VGND sg13g2_dlhq_1
X_0918_ Tile_X0Y0_FrameData[8] Tile_X0Y1_FrameStrobe[1] Tile_X0Y0_IHP_SRAM_top.Inst_IHP_SRAM_top_ConfigMem.Inst_frame1_bit8.Q
+ VPWR VGND sg13g2_dlhq_1
X_0849_ _0284_ Tile_X0Y1_E2MID[3] Tile_X0Y1_IHP_SRAM_bot.Inst_IHP_SRAM_bot_ConfigMem.Inst_frame1_bit4.Q
+ VPWR VGND sg13g2_nand2b_1
XFILLER_108_58 VPWR VGND sg13g2_decap_8
XFILLER_109_0 VPWR VGND sg13g2_fill_2
X_1683_ Tile_X0Y1_IHP_SRAM_bot.Inst_IHP_SRAM_bot_switch_matrix.W2BEG0 net288 VPWR
+ VGND sg13g2_buf_1
X_0703_ Tile_X0Y1_IHP_SRAM_bot.Inst_IHP_SRAM_bot_ConfigMem.Inst_frame3_bit0.Q Tile_X0Y1_EE4END[2]
+ Tile_X0Y1_EE4END[10] Tile_X0Y1_E6END[2] _0159_ Tile_X0Y1_IHP_SRAM_bot.Inst_IHP_SRAM_bot_ConfigMem.Inst_frame3_bit1.Q
+ net56 VPWR VGND sg13g2_mux4_1
X_0565_ Tile_X0Y0_IHP_SRAM_top.Inst_IHP_SRAM_top_switch_matrix.J_NS2_BEG3 Tile_X0Y0_IHP_SRAM_top.Inst_IHP_SRAM_top_ConfigMem.Inst_frame8_bit23.Q
+ _0124_ VPWR VGND sg13g2_nor2b_1
X_0496_ Tile_X0Y0_IHP_SRAM_top.Inst_IHP_SRAM_top_ConfigMem.Inst_frame3_bit4.Q Tile_X0Y0_EE4END[3]
+ Tile_X0Y0_EE4END[11] Tile_X0Y0_E6END[3] Tile_X0Y0_IHP_SRAM_top.Inst_IHP_SRAM_top_switch_matrix.J_NS4_BEG3
+ Tile_X0Y0_IHP_SRAM_top.Inst_IHP_SRAM_top_ConfigMem.Inst_frame3_bit5.Q net55 VPWR
+ VGND sg13g2_mux4_1
X_0634_ Tile_X0Y1_IHP_SRAM_bot.Inst_IHP_SRAM_bot_ConfigMem.Inst_frame6_bit12.Q A_DOUT_SRAM1
+ A_DOUT_SRAM9 _0078_ _0083_ Tile_X0Y1_IHP_SRAM_bot.Inst_IHP_SRAM_bot_ConfigMem.Inst_frame6_bit13.Q
+ Tile_X0Y1_IHP_SRAM_bot.Inst_IHP_SRAM_bot_switch_matrix.W2BEGb1 VPWR VGND sg13g2_mux4_1
XFILLER_57_107 VPWR VGND sg13g2_fill_1
X_1117_ Tile_X0Y0_FrameData[1] Tile_X0Y1_FrameStrobe[7] Tile_X0Y0_IHP_SRAM_top.Inst_IHP_SRAM_top_ConfigMem.Inst_frame7_bit1.Q
+ VPWR VGND sg13g2_dlhq_1
XFILLER_65_151 VPWR VGND sg13g2_fill_1
X_1048_ Tile_X0Y0_FrameData[6] Tile_X0Y1_FrameStrobe[5] Tile_X0Y0_IHP_SRAM_top.Inst_IHP_SRAM_top_ConfigMem.Inst_frame5_bit6.Q
+ VPWR VGND sg13g2_dlhq_1
XFILLER_28_76 VPWR VGND sg13g2_fill_2
XFILLER_44_20 VPWR VGND sg13g2_fill_1
XFILLER_44_42 VPWR VGND sg13g2_decap_4
Xclkbuf_1_0__f_Tile_X0Y1_UserCLK clknet_0_Tile_X0Y1_UserCLK clknet_1_0__leaf_Tile_X0Y1_UserCLK
+ VPWR VGND sg13g2_buf_8
X_0350_ Tile_X0Y1_E2END[5] Tile_X0Y1_IHP_SRAM_bot.Inst_IHP_SRAM_bot_ConfigMem.Inst_frame1_bit1.Q
+ _0050_ VPWR VGND Tile_X0Y1_IHP_SRAM_bot.Inst_IHP_SRAM_bot_ConfigMem.Inst_frame1_bit2.Q
+ sg13g2_nand3b_1
XFILLER_94_213 VPWR VGND sg13g2_fill_2
X_1666_ Tile_X0Y0_S4END[11] net277 VPWR VGND sg13g2_buf_1
XFILLER_105_59 VPWR VGND sg13g2_decap_8
X_0479_ Tile_X0Y0_IHP_SRAM_top.Inst_IHP_SRAM_top_ConfigMem.Inst_frame1_bit8.Q Tile_X0Y0_IHP_SRAM_top.Inst_IHP_SRAM_top_switch_matrix.N1END0
+ Tile_X0Y1_N4END[4] Tile_X0Y0_S1END[0] Tile_X0Y0_S4END[0] Tile_X0Y0_IHP_SRAM_top.Inst_IHP_SRAM_top_ConfigMem.Inst_frame1_bit9.Q
+ Tile_X0Y0_IHP_SRAM_top.Inst_IHP_SRAM_top_switch_matrix.J_NS4_BEG0 VPWR VGND sg13g2_mux4_1
X_0548_ Tile_X0Y0_IHP_SRAM_top.Inst_IHP_SRAM_top_switch_matrix.J_NS4_BEG5 Tile_X0Y0_IHP_SRAM_top.Inst_IHP_SRAM_top_switch_matrix.J_NS4_BEG9
+ Tile_X0Y0_IHP_SRAM_top.Inst_IHP_SRAM_top_ConfigMem.Inst_frame8_bit17.Q _0109_ VPWR
+ VGND sg13g2_mux2_1
X_1597_ Tile_X0Y0_IHP_SRAM_top.Inst_IHP_SRAM_top_switch_matrix.WW4BEG2 net208 VPWR
+ VGND sg13g2_buf_1
X_0617_ Tile_X0Y1_IHP_SRAM_bot.Inst_IHP_SRAM_bot_ConfigMem.Inst_frame8_bit31.Q Tile_X0Y1_E1END[0]
+ Tile_X0Y1_E2END[3] Tile_X0Y1_E2MID[3] _0081_ Tile_X0Y1_IHP_SRAM_bot.Inst_IHP_SRAM_bot_ConfigMem.Inst_frame8_bit30.Q
+ Tile_X0Y1_IHP_SRAM_bot.Inst_IHP_SRAM_bot_switch_matrix.S2BEG4 VPWR VGND sg13g2_mux4_1
XFILLER_38_162 VPWR VGND sg13g2_decap_8
XFILLER_107_123 VPWR VGND sg13g2_decap_8
X_1520_ Tile_X0Y1_FrameStrobe[14] net116 VPWR VGND sg13g2_buf_1
Xoutput308 net308 Tile_X0Y1_W6BEG[2] VPWR VGND sg13g2_buf_1
Xoutput319 net319 Tile_X0Y1_WW4BEG[12] VPWR VGND sg13g2_buf_1
X_0402_ Tile_X0Y0_IHP_SRAM_top.Inst_IHP_SRAM_top_ConfigMem.Inst_frame0_bit14.Q Tile_X0Y0_IHP_SRAM_top.Inst_IHP_SRAM_top_switch_matrix.N2BEGb3
+ Tile_X0Y1_N2MID[3] Tile_X0Y0_S2MID[3] Tile_X0Y0_S2END[3] Tile_X0Y0_IHP_SRAM_top.Inst_IHP_SRAM_top_ConfigMem.Inst_frame0_bit15.Q
+ Tile_X0Y0_IHP_SRAM_top.Inst_IHP_SRAM_top_switch_matrix.J_NS2_BEG3 VPWR VGND sg13g2_mux4_1
XFILLER_96_70 VPWR VGND sg13g2_decap_4
X_1382_ Tile_X0Y1_FrameData[2] Tile_X0Y1_FrameStrobe[6] Tile_X0Y1_IHP_SRAM_bot.Inst_IHP_SRAM_bot_ConfigMem.Inst_frame6_bit2.Q
+ VPWR VGND sg13g2_dlhq_1
X_1451_ Tile_X0Y1_FrameData[29] Tile_X0Y1_FrameStrobe[9] Tile_X0Y1_IHP_SRAM_bot.Inst_IHP_SRAM_bot_ConfigMem.Inst_frame9_bit29.Q
+ VPWR VGND sg13g2_dlhq_1
X_0333_ VPWR _0036_ Tile_X0Y1_IHP_SRAM_bot.Inst_IHP_SRAM_bot_ConfigMem.Inst_frame2_bit31.Q
+ VGND sg13g2_inv_1
XFILLER_91_0 VPWR VGND sg13g2_decap_8
X_1718_ Tile_X0Y1_IHP_SRAM_bot.Inst_IHP_SRAM_bot_switch_matrix.WW4BEG7 net329 VPWR
+ VGND sg13g2_buf_1
X_1649_ Tile_X0Y1_IHP_SRAM_bot.Inst_IHP_SRAM_bot_switch_matrix.S2BEG2 net254 VPWR
+ VGND sg13g2_buf_1
XFILLER_2_209 VPWR VGND sg13g2_decap_8
XFILLER_41_87 VPWR VGND sg13g2_decap_4
XFILLER_66_40 VPWR VGND sg13g2_fill_1
XFILLER_17_110 VPWR VGND sg13g2_decap_8
X_0882_ Tile_X0Y0_FrameData[12] Tile_X0Y1_FrameStrobe[0] Tile_X0Y0_IHP_SRAM_top.Inst_IHP_SRAM_top_ConfigMem.Inst_frame0_bit12.Q
+ VPWR VGND sg13g2_dlhq_1
X_0951_ Tile_X0Y0_FrameData[7] Tile_X0Y1_FrameStrobe[2] Tile_X0Y0_IHP_SRAM_top.Inst_IHP_SRAM_top_ConfigMem.Inst_frame2_bit7.Q
+ VPWR VGND sg13g2_dlhq_1
XFILLER_32_168 VPWR VGND sg13g2_decap_4
Xoutput127 net127 Tile_X0Y0_FrameStrobe_O[6] VPWR VGND sg13g2_buf_1
Xoutput149 net149 Tile_X0Y0_N2BEGb[6] VPWR VGND sg13g2_buf_1
X_1503_ Tile_X0Y0_FrameData[29] net100 VPWR VGND sg13g2_buf_1
Xoutput138 net138 Tile_X0Y0_N2BEG[3] VPWR VGND sg13g2_buf_1
Xoutput116 net116 Tile_X0Y0_FrameStrobe_O[14] VPWR VGND sg13g2_buf_1
XFILLER_99_102 VPWR VGND sg13g2_decap_8
Xoutput105 net105 Tile_X0Y0_FrameData_O[4] VPWR VGND sg13g2_buf_1
XFILLER_49_2 VPWR VGND sg13g2_fill_1
X_1365_ Tile_X0Y1_FrameData[19] Tile_X0Y1_FrameStrobe[6] Tile_X0Y1_IHP_SRAM_bot.Inst_IHP_SRAM_bot_ConfigMem.Inst_frame6_bit19.Q
+ VPWR VGND sg13g2_dlhq_1
X_1434_ Tile_X0Y1_FrameData[14] Tile_X0Y1_FrameStrobe[8] Tile_X0Y1_IHP_SRAM_bot.Inst_IHP_SRAM_bot_ConfigMem.Inst_frame8_bit14.Q
+ VPWR VGND sg13g2_dlhq_1
X_0316_ VPWR _0019_ Tile_X0Y1_IHP_SRAM_bot.Inst_IHP_SRAM_bot_ConfigMem.Inst_frame8_bit2.Q
+ VGND sg13g2_inv_1
X_1296_ Tile_X0Y1_FrameData[24] Tile_X0Y1_FrameStrobe[4] Tile_X0Y1_IHP_SRAM_bot.Inst_IHP_SRAM_bot_ConfigMem.Inst_frame4_bit24.Q
+ VPWR VGND sg13g2_dlhq_1
XFILLER_98_190 VPWR VGND sg13g2_fill_2
X_1150_ Tile_X0Y0_FrameData[0] Tile_X0Y1_FrameStrobe[8] Tile_X0Y0_IHP_SRAM_top.Inst_IHP_SRAM_top_ConfigMem.Inst_frame8_bit0.Q
+ VPWR VGND sg13g2_dlhq_1
X_1081_ Tile_X0Y0_FrameData[5] Tile_X0Y1_FrameStrobe[6] Tile_X0Y0_IHP_SRAM_top.Inst_IHP_SRAM_top_ConfigMem.Inst_frame6_bit5.Q
+ VPWR VGND sg13g2_dlhq_1
X_0865_ Tile_X0Y0_FrameData[29] Tile_X0Y1_FrameStrobe[0] Tile_X0Y0_IHP_SRAM_top.Inst_IHP_SRAM_top_ConfigMem.Inst_frame0_bit29.Q
+ VPWR VGND sg13g2_dlhq_1
X_0934_ Tile_X0Y0_FrameData[24] Tile_X0Y1_FrameStrobe[2] Tile_X0Y0_IHP_SRAM_top.Inst_IHP_SRAM_top_ConfigMem.Inst_frame2_bit24.Q
+ VPWR VGND sg13g2_dlhq_1
X_1417_ Tile_X0Y1_FrameData[31] Tile_X0Y1_FrameStrobe[8] Tile_X0Y1_IHP_SRAM_bot.Inst_IHP_SRAM_bot_ConfigMem.Inst_frame8_bit31.Q
+ VPWR VGND sg13g2_dlhq_1
X_0796_ Tile_X0Y1_IHP_SRAM_bot.Inst_IHP_SRAM_bot_ConfigMem.Inst_frame7_bit11.Q VPWR
+ _0235_ VGND _0232_ _0233_ sg13g2_o21ai_1
X_1348_ Tile_X0Y1_FrameData[4] Tile_X0Y1_FrameStrobe[5] Tile_X0Y1_IHP_SRAM_bot.Inst_IHP_SRAM_bot_ConfigMem.Inst_frame5_bit4.Q
+ VPWR VGND sg13g2_dlhq_1
X_1279_ Tile_X0Y1_FrameData[9] Tile_X0Y1_FrameStrobe[3] Tile_X0Y1_IHP_SRAM_bot.Inst_IHP_SRAM_bot_ConfigMem.Inst_frame3_bit9.Q
+ VPWR VGND sg13g2_dlhq_1
XFILLER_11_127 VPWR VGND sg13g2_fill_2
XFILLER_105_210 VPWR VGND sg13g2_decap_4
XFILLER_86_171 VPWR VGND sg13g2_decap_4
XFILLER_103_70 VPWR VGND sg13g2_decap_4
XFILLER_63_85 VPWR VGND sg13g2_fill_2
XFILLER_6_153 VPWR VGND sg13g2_fill_1
X_0581_ Tile_X0Y0_IHP_SRAM_top.Inst_IHP_SRAM_top_switch_matrix.J_NS2_BEG5 Tile_X0Y0_IHP_SRAM_top.Inst_IHP_SRAM_top_ConfigMem.Inst_frame7_bit21.Q
+ _0138_ VPWR VGND sg13g2_nor2b_1
X_0650_ Tile_X0Y1_IHP_SRAM_bot.Inst_IHP_SRAM_bot_ConfigMem.Inst_frame5_bit6.Q A_DOUT_SRAM6
+ A_DOUT_SRAM10 Tile_X0Y1_IHP_SRAM_bot.Inst_IHP_SRAM_bot_switch_matrix.J_NS4_BEG9
+ _0078_ Tile_X0Y1_IHP_SRAM_bot.Inst_IHP_SRAM_bot_ConfigMem.Inst_frame5_bit7.Q Tile_X0Y1_IHP_SRAM_bot.Inst_IHP_SRAM_bot_switch_matrix.WW4BEG6
+ VPWR VGND sg13g2_mux4_1
XFILLER_92_152 VPWR VGND sg13g2_fill_1
X_1064_ Tile_X0Y0_FrameData[22] Tile_X0Y1_FrameStrobe[6] Tile_X0Y0_IHP_SRAM_top.Inst_IHP_SRAM_top_ConfigMem.Inst_frame6_bit22.Q
+ VPWR VGND sg13g2_dlhq_1
X_1133_ Tile_X0Y0_FrameData[17] Tile_X0Y1_FrameStrobe[8] Tile_X0Y0_IHP_SRAM_top.Inst_IHP_SRAM_top_ConfigMem.Inst_frame8_bit17.Q
+ VPWR VGND sg13g2_dlhq_1
X_1202_ Tile_X0Y1_FrameData[22] Tile_X0Y1_FrameStrobe[1] Tile_X0Y1_IHP_SRAM_bot.Inst_IHP_SRAM_bot_ConfigMem.Inst_frame1_bit22.Q
+ VPWR VGND sg13g2_dlhq_1
XFILLER_108_37 VPWR VGND sg13g2_decap_8
X_0917_ Tile_X0Y0_FrameData[9] Tile_X0Y1_FrameStrobe[1] Tile_X0Y0_IHP_SRAM_top.Inst_IHP_SRAM_top_ConfigMem.Inst_frame1_bit9.Q
+ VPWR VGND sg13g2_dlhq_1
X_0779_ _0218_ VPWR _0219_ VGND _0027_ _0161_ sg13g2_o21ai_1
X_0848_ _0283_ _0037_ Tile_X0Y1_IHP_SRAM_bot.Inst_IHP_SRAM_bot_ConfigMem.Inst_frame1_bit6.Q
+ VPWR VGND sg13g2_nand2_1
X_0633_ Tile_X0Y1_IHP_SRAM_bot.Inst_IHP_SRAM_bot_ConfigMem.Inst_frame6_bit10.Q A_DOUT_SRAM0
+ A_DOUT_SRAM8 _0043_ _0084_ Tile_X0Y1_IHP_SRAM_bot.Inst_IHP_SRAM_bot_ConfigMem.Inst_frame6_bit11.Q
+ Tile_X0Y1_IHP_SRAM_bot.Inst_IHP_SRAM_bot_switch_matrix.W2BEGb0 VPWR VGND sg13g2_mux4_1
X_1682_ Tile_X0Y1_IHP_SRAM_bot.Inst_IHP_SRAM_bot_switch_matrix.W1BEG3 net287 VPWR
+ VGND sg13g2_buf_1
X_0702_ Tile_X0Y1_IHP_SRAM_bot.Inst_IHP_SRAM_bot_ConfigMem.Inst_frame4_bit30.Q Tile_X0Y1_EE4END[1]
+ Tile_X0Y1_EE4END[9] Tile_X0Y1_E6END[1] _0160_ Tile_X0Y1_IHP_SRAM_bot.Inst_IHP_SRAM_bot_ConfigMem.Inst_frame4_bit31.Q
+ net45 VPWR VGND sg13g2_mux4_1
X_0564_ Tile_X0Y0_IHP_SRAM_top.Inst_IHP_SRAM_top_switch_matrix.J_NS4_BEG7 Tile_X0Y0_IHP_SRAM_top.Inst_IHP_SRAM_top_switch_matrix.J_NS4_BEG11
+ Tile_X0Y0_IHP_SRAM_top.Inst_IHP_SRAM_top_ConfigMem.Inst_frame8_bit23.Q _0123_ VPWR
+ VGND sg13g2_mux2_1
X_0495_ Tile_X0Y0_IHP_SRAM_top.Inst_IHP_SRAM_top_ConfigMem.Inst_frame3_bit2.Q Tile_X0Y0_EE4END[2]
+ Tile_X0Y0_EE4END[10] Tile_X0Y0_E6END[2] Tile_X0Y0_IHP_SRAM_top.Inst_IHP_SRAM_top_switch_matrix.J_NS4_BEG2
+ Tile_X0Y0_IHP_SRAM_top.Inst_IHP_SRAM_top_ConfigMem.Inst_frame3_bit3.Q net54 VPWR
+ VGND sg13g2_mux4_1
X_1116_ Tile_X0Y0_FrameData[2] Tile_X0Y1_FrameStrobe[7] Tile_X0Y0_IHP_SRAM_top.Inst_IHP_SRAM_top_ConfigMem.Inst_frame7_bit2.Q
+ VPWR VGND sg13g2_dlhq_1
X_1047_ Tile_X0Y0_FrameData[7] Tile_X0Y1_FrameStrobe[5] Tile_X0Y0_IHP_SRAM_top.Inst_IHP_SRAM_top_ConfigMem.Inst_frame5_bit7.Q
+ VPWR VGND sg13g2_dlhq_1
XFILLER_17_0 VPWR VGND sg13g2_fill_1
XFILLER_60_75 VPWR VGND sg13g2_decap_8
XFILLER_60_53 VPWR VGND sg13g2_fill_1
XFILLER_60_20 VPWR VGND sg13g2_fill_2
XFILLER_109_80 VPWR VGND sg13g2_decap_8
XFILLER_39_119 VPWR VGND sg13g2_decap_8
X_1596_ Tile_X0Y0_IHP_SRAM_top.Inst_IHP_SRAM_top_switch_matrix.WW4BEG1 net207 VPWR
+ VGND sg13g2_buf_1
X_1665_ Tile_X0Y0_S4END[10] net276 VPWR VGND sg13g2_buf_1
X_0616_ Tile_X0Y1_IHP_SRAM_bot.Inst_IHP_SRAM_bot_ConfigMem.Inst_frame8_bit29.Q Tile_X0Y1_E2MID[4]
+ Tile_X0Y1_E6END[11] Tile_X0Y1_E2END[4] _0080_ Tile_X0Y1_IHP_SRAM_bot.Inst_IHP_SRAM_bot_ConfigMem.Inst_frame8_bit28.Q
+ Tile_X0Y1_IHP_SRAM_bot.Inst_IHP_SRAM_bot_switch_matrix.S2BEG3 VPWR VGND sg13g2_mux4_1
X_0547_ _0106_ _0108_ Tile_X0Y0_IHP_SRAM_top.Inst_IHP_SRAM_top_switch_matrix.N4BEG0
+ VPWR VGND sg13g2_nor2_1
X_0478_ Tile_X0Y0_IHP_SRAM_top.Inst_IHP_SRAM_top_ConfigMem.Inst_frame4_bit2.Q A_DOUT_SRAM18
+ A_DOUT_SRAM30 Tile_X0Y0_IHP_SRAM_top.Inst_IHP_SRAM_top_switch_matrix.J_NS4_BEG1
+ Tile_X0Y0_IHP_SRAM_top.Inst_IHP_SRAM_top_switch_matrix.J_NS2_BEG1 Tile_X0Y0_IHP_SRAM_top.Inst_IHP_SRAM_top_ConfigMem.Inst_frame4_bit3.Q
+ Tile_X0Y0_IHP_SRAM_top.Inst_IHP_SRAM_top_switch_matrix.WW4BEG14 VPWR VGND sg13g2_mux4_1
XFILLER_107_102 VPWR VGND sg13g2_decap_8
XFILLER_14_46 VPWR VGND sg13g2_fill_2
XFILLER_107_179 VPWR VGND sg13g2_decap_8
XFILLER_44_144 VPWR VGND sg13g2_fill_1
XFILLER_71_96 VPWR VGND sg13g2_decap_8
Xoutput309 net309 Tile_X0Y1_W6BEG[3] VPWR VGND sg13g2_buf_1
X_1450_ Tile_X0Y1_FrameData[30] Tile_X0Y1_FrameStrobe[9] Tile_X0Y1_IHP_SRAM_bot.Inst_IHP_SRAM_bot_ConfigMem.Inst_frame9_bit30.Q
+ VPWR VGND sg13g2_dlhq_1
X_1381_ Tile_X0Y1_FrameData[3] Tile_X0Y1_FrameStrobe[6] Tile_X0Y1_IHP_SRAM_bot.Inst_IHP_SRAM_bot_ConfigMem.Inst_frame6_bit3.Q
+ VPWR VGND sg13g2_dlhq_1
X_0401_ Tile_X0Y1_IHP_SRAM_bot.Inst_IHP_SRAM_bot_ConfigMem.Inst_frame9_bit25.Q Tile_X0Y1_E2MID[4]
+ Tile_X0Y1_E6END[4] Tile_X0Y1_E2END[4] _0080_ Tile_X0Y1_IHP_SRAM_bot.Inst_IHP_SRAM_bot_ConfigMem.Inst_frame9_bit24.Q
+ Tile_X0Y0_IHP_SRAM_top.Inst_IHP_SRAM_top_switch_matrix.N2BEGb3 VPWR VGND sg13g2_mux4_1
X_0332_ VPWR _0035_ Tile_X0Y1_IHP_SRAM_bot.Inst_IHP_SRAM_bot_ConfigMem.Inst_frame2_bit28.Q
+ VGND sg13g2_inv_1
X_1579_ Tile_X0Y0_IHP_SRAM_top.Inst_IHP_SRAM_top_switch_matrix.W2BEGb4 net184 VPWR
+ VGND sg13g2_buf_1
X_1717_ Tile_X0Y1_IHP_SRAM_bot.Inst_IHP_SRAM_bot_switch_matrix.WW4BEG6 net328 VPWR
+ VGND sg13g2_buf_1
X_1648_ Tile_X0Y1_IHP_SRAM_bot.Inst_IHP_SRAM_bot_switch_matrix.S2BEG1 net253 VPWR
+ VGND sg13g2_buf_1
XFILLER_92_18 VPWR VGND sg13g2_decap_4
XFILLER_110_108 VPWR VGND sg13g2_decap_8
XFILLER_106_81 VPWR VGND sg13g2_decap_8
XFILLER_103_182 VPWR VGND sg13g2_decap_8
X_0881_ Tile_X0Y0_FrameData[13] Tile_X0Y1_FrameStrobe[0] Tile_X0Y0_IHP_SRAM_top.Inst_IHP_SRAM_top_ConfigMem.Inst_frame0_bit13.Q
+ VPWR VGND sg13g2_dlhq_1
X_0950_ Tile_X0Y0_FrameData[8] Tile_X0Y1_FrameStrobe[2] Tile_X0Y0_IHP_SRAM_top.Inst_IHP_SRAM_top_ConfigMem.Inst_frame2_bit8.Q
+ VPWR VGND sg13g2_dlhq_1
Xoutput128 net128 Tile_X0Y0_FrameStrobe_O[7] VPWR VGND sg13g2_buf_1
Xoutput139 net139 Tile_X0Y0_N2BEG[4] VPWR VGND sg13g2_buf_1
Xoutput117 net117 Tile_X0Y0_FrameStrobe_O[15] VPWR VGND sg13g2_buf_1
X_1502_ Tile_X0Y0_FrameData[28] net99 VPWR VGND sg13g2_buf_1
Xoutput106 net106 Tile_X0Y0_FrameData_O[5] VPWR VGND sg13g2_buf_1
X_1433_ Tile_X0Y1_FrameData[15] Tile_X0Y1_FrameStrobe[8] Tile_X0Y1_IHP_SRAM_bot.Inst_IHP_SRAM_bot_ConfigMem.Inst_frame8_bit15.Q
+ VPWR VGND sg13g2_dlhq_1
X_0315_ VPWR _0018_ Tile_X0Y0_IHP_SRAM_top.Inst_IHP_SRAM_top_ConfigMem.Inst_frame7_bit28.Q
+ VGND sg13g2_inv_1
X_1364_ Tile_X0Y1_FrameData[20] Tile_X0Y1_FrameStrobe[6] Tile_X0Y1_IHP_SRAM_bot.Inst_IHP_SRAM_bot_ConfigMem.Inst_frame6_bit20.Q
+ VPWR VGND sg13g2_dlhq_1
X_1295_ Tile_X0Y1_FrameData[25] Tile_X0Y1_FrameStrobe[4] Tile_X0Y1_IHP_SRAM_bot.Inst_IHP_SRAM_bot_ConfigMem.Inst_frame4_bit25.Q
+ VPWR VGND sg13g2_dlhq_1
XFILLER_100_196 VPWR VGND sg13g2_decap_8
XFILLER_36_77 VPWR VGND sg13g2_decap_8
X_1080_ Tile_X0Y0_FrameData[6] Tile_X0Y1_FrameStrobe[6] Tile_X0Y0_IHP_SRAM_top.Inst_IHP_SRAM_top_ConfigMem.Inst_frame6_bit6.Q
+ VPWR VGND sg13g2_dlhq_1
XFILLER_77_95 VPWR VGND sg13g2_fill_1
X_0864_ Tile_X0Y0_FrameData[30] Tile_X0Y1_FrameStrobe[0] Tile_X0Y0_IHP_SRAM_top.Inst_IHP_SRAM_top_ConfigMem.Inst_frame0_bit30.Q
+ VPWR VGND sg13g2_dlhq_1
X_0933_ Tile_X0Y0_FrameData[25] Tile_X0Y1_FrameStrobe[2] Tile_X0Y0_IHP_SRAM_top.Inst_IHP_SRAM_top_ConfigMem.Inst_frame2_bit25.Q
+ VPWR VGND sg13g2_dlhq_1
XFILLER_9_162 VPWR VGND sg13g2_decap_8
X_0795_ Tile_X0Y1_IHP_SRAM_bot.Inst_IHP_SRAM_bot_switch_matrix.J_NS4_BEG5 Tile_X0Y1_IHP_SRAM_bot.Inst_IHP_SRAM_bot_switch_matrix.J_NS4_BEG9
+ Tile_X0Y1_IHP_SRAM_bot.Inst_IHP_SRAM_bot_ConfigMem.Inst_frame7_bit9.Q _0234_ VPWR
+ VGND sg13g2_mux2_1
X_1347_ Tile_X0Y1_FrameData[5] Tile_X0Y1_FrameStrobe[5] Tile_X0Y1_IHP_SRAM_bot.Inst_IHP_SRAM_bot_ConfigMem.Inst_frame5_bit5.Q
+ VPWR VGND sg13g2_dlhq_1
X_1416_ Tile_X0Y1_FrameData[0] Tile_X0Y1_FrameStrobe[7] Tile_X0Y1_IHP_SRAM_bot.Inst_IHP_SRAM_bot_ConfigMem.Inst_frame7_bit0.Q
+ VPWR VGND sg13g2_dlhq_1
XFILLER_47_0 VPWR VGND sg13g2_decap_4
X_1278_ Tile_X0Y1_FrameData[10] Tile_X0Y1_FrameStrobe[3] Tile_X0Y1_IHP_SRAM_bot.Inst_IHP_SRAM_bot_ConfigMem.Inst_frame3_bit10.Q
+ VPWR VGND sg13g2_dlhq_1
XFILLER_22_57 VPWR VGND sg13g2_decap_8
XFILLER_63_64 VPWR VGND sg13g2_decap_4
XFILLER_10_150 VPWR VGND sg13g2_decap_4
XFILLER_111_214 VPWR VGND sg13g2_fill_2
X_0580_ Tile_X0Y0_IHP_SRAM_top.Inst_IHP_SRAM_top_switch_matrix.J_NS4_BEG5 Tile_X0Y0_IHP_SRAM_top.Inst_IHP_SRAM_top_switch_matrix.J_NS4_BEG9
+ Tile_X0Y0_IHP_SRAM_top.Inst_IHP_SRAM_top_ConfigMem.Inst_frame7_bit21.Q _0137_ VPWR
+ VGND sg13g2_mux2_1
X_1201_ Tile_X0Y1_FrameData[23] Tile_X0Y1_FrameStrobe[1] Tile_X0Y1_IHP_SRAM_bot.Inst_IHP_SRAM_bot_ConfigMem.Inst_frame1_bit23.Q
+ VPWR VGND sg13g2_dlhq_1
XFILLER_77_194 VPWR VGND sg13g2_fill_1
X_1063_ Tile_X0Y0_FrameData[23] Tile_X0Y1_FrameStrobe[6] Tile_X0Y0_IHP_SRAM_top.Inst_IHP_SRAM_top_ConfigMem.Inst_frame6_bit23.Q
+ VPWR VGND sg13g2_dlhq_1
X_1132_ Tile_X0Y0_FrameData[18] Tile_X0Y1_FrameStrobe[8] Tile_X0Y0_IHP_SRAM_top.Inst_IHP_SRAM_top_ConfigMem.Inst_frame8_bit18.Q
+ VPWR VGND sg13g2_dlhq_1
X_0916_ Tile_X0Y0_FrameData[10] Tile_X0Y1_FrameStrobe[1] Tile_X0Y0_IHP_SRAM_top.Inst_IHP_SRAM_top_ConfigMem.Inst_frame1_bit10.Q
+ VPWR VGND sg13g2_dlhq_1
X_0778_ VPWR _0218_ _0217_ VGND sg13g2_inv_1
X_0847_ Tile_X0Y1_IHP_SRAM_bot.Inst_IHP_SRAM_bot_ConfigMem.Inst_frame1_bit5.Q Tile_X0Y1_IHP_SRAM_bot.Inst_IHP_SRAM_bot_ConfigMem.Inst_frame1_bit6.Q
+ _0281_ _0282_ VPWR VGND sg13g2_nor3_1
XFILLER_83_186 VPWR VGND sg13g2_decap_8
XFILLER_17_79 VPWR VGND sg13g2_decap_8
XFILLER_109_2 VPWR VGND sg13g2_fill_1
XFILLER_74_120 VPWR VGND sg13g2_decap_4
XFILLER_99_82 VPWR VGND sg13g2_fill_1
X_0563_ _0120_ _0122_ Tile_X0Y0_IHP_SRAM_top.Inst_IHP_SRAM_top_switch_matrix.N4BEG2
+ VPWR VGND sg13g2_nor2_1
X_1681_ Tile_X0Y1_IHP_SRAM_bot.Inst_IHP_SRAM_bot_switch_matrix.W1BEG2 net286 VPWR
+ VGND sg13g2_buf_1
X_0632_ Tile_X0Y1_IHP_SRAM_bot.Inst_IHP_SRAM_bot_ConfigMem.Inst_frame6_bit8.Q A_DOUT_SRAM7
+ A_DOUT_SRAM15 _0043_ _0084_ Tile_X0Y1_IHP_SRAM_bot.Inst_IHP_SRAM_bot_ConfigMem.Inst_frame6_bit9.Q
+ Tile_X0Y1_IHP_SRAM_bot.Inst_IHP_SRAM_bot_switch_matrix.W2BEG7 VPWR VGND sg13g2_mux4_1
X_0701_ Tile_X0Y1_IHP_SRAM_bot.Inst_IHP_SRAM_bot_ConfigMem.Inst_frame4_bit28.Q Tile_X0Y1_EE4END[0]
+ Tile_X0Y1_EE4END[8] Tile_X0Y1_E6END[0] _0161_ Tile_X0Y1_IHP_SRAM_bot.Inst_IHP_SRAM_bot_ConfigMem.Inst_frame4_bit29.Q
+ net44 VPWR VGND sg13g2_mux4_1
X_0494_ Tile_X0Y0_IHP_SRAM_top.Inst_IHP_SRAM_top_ConfigMem.Inst_frame3_bit0.Q Tile_X0Y0_EE4END[1]
+ Tile_X0Y0_EE4END[9] Tile_X0Y0_E6END[1] Tile_X0Y0_IHP_SRAM_top.Inst_IHP_SRAM_top_switch_matrix.J_NS4_BEG1
+ Tile_X0Y0_IHP_SRAM_top.Inst_IHP_SRAM_top_ConfigMem.Inst_frame3_bit1.Q net53 VPWR
+ VGND sg13g2_mux4_1
X_1115_ Tile_X0Y0_FrameData[3] Tile_X0Y1_FrameStrobe[7] Tile_X0Y0_IHP_SRAM_top.Inst_IHP_SRAM_top_ConfigMem.Inst_frame7_bit3.Q
+ VPWR VGND sg13g2_dlhq_1
X_1046_ Tile_X0Y0_FrameData[8] Tile_X0Y1_FrameStrobe[5] Tile_X0Y0_IHP_SRAM_top.Inst_IHP_SRAM_top_ConfigMem.Inst_frame5_bit8.Q
+ VPWR VGND sg13g2_dlhq_1
XFILLER_0_60 VPWR VGND sg13g2_fill_2
XFILLER_95_18 VPWR VGND sg13g2_fill_1
XFILLER_71_167 VPWR VGND sg13g2_fill_1
XFILLER_94_215 VPWR VGND sg13g2_fill_1
X_0546_ Tile_X0Y0_IHP_SRAM_top.Inst_IHP_SRAM_top_ConfigMem.Inst_frame8_bit16.Q _0107_
+ _0108_ VPWR VGND sg13g2_nor2_1
X_1595_ Tile_X0Y0_IHP_SRAM_top.Inst_IHP_SRAM_top_switch_matrix.WW4BEG0 net200 VPWR
+ VGND sg13g2_buf_1
X_1664_ Tile_X0Y0_S4END[9] net275 VPWR VGND sg13g2_buf_1
X_0615_ Tile_X0Y1_IHP_SRAM_bot.Inst_IHP_SRAM_bot_ConfigMem.Inst_frame8_bit27.Q Tile_X0Y1_E2MID[5]
+ Tile_X0Y1_E6END[10] Tile_X0Y1_E2END[5] _0079_ Tile_X0Y1_IHP_SRAM_bot.Inst_IHP_SRAM_bot_ConfigMem.Inst_frame8_bit26.Q
+ Tile_X0Y1_IHP_SRAM_bot.Inst_IHP_SRAM_bot_switch_matrix.S2BEG2 VPWR VGND sg13g2_mux4_1
X_0477_ Tile_X0Y0_IHP_SRAM_top.Inst_IHP_SRAM_top_ConfigMem.Inst_frame1_bit10.Q Tile_X0Y0_IHP_SRAM_top.Inst_IHP_SRAM_top_switch_matrix.N1END1
+ Tile_X0Y1_N4END[5] Tile_X0Y0_S1END[1] Tile_X0Y0_S4END[1] Tile_X0Y0_IHP_SRAM_top.Inst_IHP_SRAM_top_ConfigMem.Inst_frame1_bit11.Q
+ Tile_X0Y0_IHP_SRAM_top.Inst_IHP_SRAM_top_switch_matrix.J_NS4_BEG1 VPWR VGND sg13g2_mux4_1
X_1029_ Tile_X0Y0_FrameData[25] Tile_X0Y1_FrameStrobe[5] Tile_X0Y0_IHP_SRAM_top.Inst_IHP_SRAM_top_ConfigMem.Inst_frame5_bit25.Q
+ VPWR VGND sg13g2_dlhq_1
XFILLER_107_158 VPWR VGND sg13g2_decap_8
XFILLER_44_134 VPWR VGND sg13g2_fill_1
XFILLER_55_98 VPWR VGND sg13g2_fill_1
XFILLER_71_42 VPWR VGND sg13g2_fill_2
XFILLER_71_20 VPWR VGND sg13g2_fill_1
X_1380_ Tile_X0Y1_FrameData[4] Tile_X0Y1_FrameStrobe[6] Tile_X0Y1_IHP_SRAM_bot.Inst_IHP_SRAM_bot_ConfigMem.Inst_frame6_bit4.Q
+ VPWR VGND sg13g2_dlhq_1
X_0400_ Tile_X0Y1_IHP_SRAM_bot.Inst_IHP_SRAM_bot_ConfigMem.Inst_frame0_bit15.Q Tile_X0Y1_N2MID[3]
+ Tile_X0Y0_IHP_SRAM_top.Inst_IHP_SRAM_top_switch_matrix.S2BEG3 Tile_X0Y1_N2END[3]
+ Tile_X0Y0_S2MID[3] Tile_X0Y1_IHP_SRAM_bot.Inst_IHP_SRAM_bot_ConfigMem.Inst_frame0_bit14.Q
+ _0080_ VPWR VGND sg13g2_mux4_1
X_0331_ VPWR _0034_ Tile_X0Y1_IHP_SRAM_bot.Inst_IHP_SRAM_bot_ConfigMem.Inst_frame7_bit16.Q
+ VGND sg13g2_inv_1
XFILLER_77_0 VPWR VGND sg13g2_fill_2
X_1716_ Tile_X0Y1_IHP_SRAM_bot.Inst_IHP_SRAM_bot_switch_matrix.WW4BEG5 net327 VPWR
+ VGND sg13g2_buf_1
X_0529_ _0095_ Tile_X0Y0_E2END[1] Tile_X0Y0_IHP_SRAM_top.Inst_IHP_SRAM_top_ConfigMem.Inst_frame1_bit1.Q
+ VPWR VGND sg13g2_nand2b_1
X_1578_ Tile_X0Y0_IHP_SRAM_top.Inst_IHP_SRAM_top_switch_matrix.W2BEGb3 net183 VPWR
+ VGND sg13g2_buf_1
X_1647_ Tile_X0Y1_IHP_SRAM_bot.Inst_IHP_SRAM_bot_switch_matrix.S2BEG0 net252 VPWR
+ VGND sg13g2_buf_1
XFILLER_25_46 VPWR VGND sg13g2_fill_2
XFILLER_41_67 VPWR VGND sg13g2_decap_4
XFILLER_106_60 VPWR VGND sg13g2_decap_8
XFILLER_103_161 VPWR VGND sg13g2_decap_8
XFILLER_17_189 VPWR VGND sg13g2_fill_2
X_0880_ Tile_X0Y0_FrameData[14] Tile_X0Y1_FrameStrobe[0] Tile_X0Y0_IHP_SRAM_top.Inst_IHP_SRAM_top_ConfigMem.Inst_frame0_bit14.Q
+ VPWR VGND sg13g2_dlhq_1
Xoutput107 net107 Tile_X0Y0_FrameData_O[6] VPWR VGND sg13g2_buf_1
Xoutput129 net129 Tile_X0Y0_FrameStrobe_O[8] VPWR VGND sg13g2_buf_1
Xoutput118 net118 Tile_X0Y0_FrameStrobe_O[16] VPWR VGND sg13g2_buf_1
X_1501_ Tile_X0Y0_FrameData[27] net98 VPWR VGND sg13g2_buf_1
X_1363_ Tile_X0Y1_FrameData[21] Tile_X0Y1_FrameStrobe[6] Tile_X0Y1_IHP_SRAM_bot.Inst_IHP_SRAM_bot_ConfigMem.Inst_frame6_bit21.Q
+ VPWR VGND sg13g2_dlhq_1
X_1432_ Tile_X0Y1_FrameData[16] Tile_X0Y1_FrameStrobe[8] Tile_X0Y1_IHP_SRAM_bot.Inst_IHP_SRAM_bot_ConfigMem.Inst_frame8_bit16.Q
+ VPWR VGND sg13g2_dlhq_1
X_0314_ VPWR _0017_ Tile_X0Y0_IHP_SRAM_top.Inst_IHP_SRAM_top_ConfigMem.Inst_frame7_bit25.Q
+ VGND sg13g2_inv_1
X_1294_ Tile_X0Y1_FrameData[26] Tile_X0Y1_FrameStrobe[4] Tile_X0Y1_IHP_SRAM_bot.Inst_IHP_SRAM_bot_ConfigMem.Inst_frame4_bit26.Q
+ VPWR VGND sg13g2_dlhq_1
XFILLER_36_56 VPWR VGND sg13g2_decap_4
XFILLER_13_181 VPWR VGND sg13g2_fill_1
X_0932_ Tile_X0Y0_FrameData[26] Tile_X0Y1_FrameStrobe[2] Tile_X0Y0_IHP_SRAM_top.Inst_IHP_SRAM_top_ConfigMem.Inst_frame2_bit26.Q
+ VPWR VGND sg13g2_dlhq_1
X_0863_ Tile_X0Y0_FrameData[31] Tile_X0Y1_FrameStrobe[0] Tile_X0Y0_IHP_SRAM_top.Inst_IHP_SRAM_top_ConfigMem.Inst_frame0_bit31.Q
+ VPWR VGND sg13g2_dlhq_1
X_0794_ Tile_X0Y1_IHP_SRAM_bot.Inst_IHP_SRAM_bot_ConfigMem.Inst_frame7_bit10.Q VPWR
+ _0233_ VGND Tile_X0Y1_IHP_SRAM_bot.Inst_IHP_SRAM_bot_ConfigMem.Inst_frame7_bit9.Q
+ Tile_X0Y1_IHP_SRAM_bot.Inst_IHP_SRAM_bot_switch_matrix.J_NS4_BEG13 sg13g2_o21ai_1
X_1346_ Tile_X0Y1_FrameData[6] Tile_X0Y1_FrameStrobe[5] Tile_X0Y1_IHP_SRAM_bot.Inst_IHP_SRAM_bot_ConfigMem.Inst_frame5_bit6.Q
+ VPWR VGND sg13g2_dlhq_1
X_1415_ Tile_X0Y1_FrameData[1] Tile_X0Y1_FrameStrobe[7] Tile_X0Y1_IHP_SRAM_bot.Inst_IHP_SRAM_bot_ConfigMem.Inst_frame7_bit1.Q
+ VPWR VGND sg13g2_dlhq_1
XFILLER_28_207 VPWR VGND sg13g2_fill_1
X_1277_ Tile_X0Y1_FrameData[11] Tile_X0Y1_FrameStrobe[3] Tile_X0Y1_IHP_SRAM_bot.Inst_IHP_SRAM_bot_ConfigMem.Inst_frame3_bit11.Q
+ VPWR VGND sg13g2_dlhq_1
XFILLER_11_129 VPWR VGND sg13g2_fill_1
XFILLER_78_107 VPWR VGND sg13g2_fill_2
XFILLER_47_88 VPWR VGND sg13g2_decap_8
X_1200_ Tile_X0Y1_FrameData[24] Tile_X0Y1_FrameStrobe[1] Tile_X0Y1_IHP_SRAM_bot.Inst_IHP_SRAM_bot_ConfigMem.Inst_frame1_bit24.Q
+ VPWR VGND sg13g2_dlhq_1
X_1131_ Tile_X0Y0_FrameData[19] Tile_X0Y1_FrameStrobe[8] Tile_X0Y0_IHP_SRAM_top.Inst_IHP_SRAM_top_ConfigMem.Inst_frame8_bit19.Q
+ VPWR VGND sg13g2_dlhq_1
X_1062_ Tile_X0Y0_FrameData[24] Tile_X0Y1_FrameStrobe[6] Tile_X0Y0_IHP_SRAM_top.Inst_IHP_SRAM_top_ConfigMem.Inst_frame6_bit24.Q
+ VPWR VGND sg13g2_dlhq_1
X_0915_ Tile_X0Y0_FrameData[11] Tile_X0Y1_FrameStrobe[1] Tile_X0Y0_IHP_SRAM_top.Inst_IHP_SRAM_top_ConfigMem.Inst_frame1_bit11.Q
+ VPWR VGND sg13g2_dlhq_1
X_0777_ Tile_X0Y1_IHP_SRAM_bot.Inst_IHP_SRAM_bot_ConfigMem.Inst_frame7_bit7.Q VPWR
+ _0217_ VGND Tile_X0Y1_E6END[4] Tile_X0Y1_IHP_SRAM_bot.Inst_IHP_SRAM_bot_ConfigMem.Inst_frame7_bit6.Q
+ sg13g2_o21ai_1
X_0846_ Tile_X0Y1_IHP_SRAM_bot.Inst_IHP_SRAM_bot_ConfigMem.Inst_frame1_bit4.Q Tile_X0Y1_N2MID[6]
+ _0281_ VPWR VGND sg13g2_nor2b_1
X_1329_ Tile_X0Y1_FrameData[23] Tile_X0Y1_FrameStrobe[5] Tile_X0Y1_IHP_SRAM_bot.Inst_IHP_SRAM_bot_ConfigMem.Inst_frame5_bit23.Q
+ VPWR VGND sg13g2_dlhq_1
Xoutput290 net290 Tile_X0Y1_W2BEG[2] VPWR VGND sg13g2_buf_1
XFILLER_74_143 VPWR VGND sg13g2_decap_8
X_0700_ _0174_ VPWR net5 VGND Tile_X0Y1_IHP_SRAM_bot.Inst_IHP_SRAM_bot_ConfigMem.Inst_frame4_bit27.Q
+ _0176_ sg13g2_o21ai_1
XFILLER_99_61 VPWR VGND sg13g2_decap_4
XFILLER_97_213 VPWR VGND sg13g2_fill_2
X_0562_ Tile_X0Y0_IHP_SRAM_top.Inst_IHP_SRAM_top_ConfigMem.Inst_frame8_bit22.Q _0121_
+ _0122_ VPWR VGND sg13g2_nor2_1
X_0631_ Tile_X0Y1_IHP_SRAM_bot.Inst_IHP_SRAM_bot_ConfigMem.Inst_frame6_bit6.Q A_DOUT_SRAM6
+ A_DOUT_SRAM14 _0078_ _0083_ Tile_X0Y1_IHP_SRAM_bot.Inst_IHP_SRAM_bot_ConfigMem.Inst_frame6_bit7.Q
+ Tile_X0Y1_IHP_SRAM_bot.Inst_IHP_SRAM_bot_switch_matrix.W2BEG6 VPWR VGND sg13g2_mux4_1
X_1680_ Tile_X0Y1_IHP_SRAM_bot.Inst_IHP_SRAM_bot_switch_matrix.W1BEG1 net285 VPWR
+ VGND sg13g2_buf_1
X_1114_ Tile_X0Y0_FrameData[4] Tile_X0Y1_FrameStrobe[7] Tile_X0Y0_IHP_SRAM_top.Inst_IHP_SRAM_top_ConfigMem.Inst_frame7_bit4.Q
+ VPWR VGND sg13g2_dlhq_1
X_0493_ Tile_X0Y0_IHP_SRAM_top.Inst_IHP_SRAM_top_ConfigMem.Inst_frame4_bit30.Q Tile_X0Y0_EE4END[0]
+ Tile_X0Y0_EE4END[8] Tile_X0Y0_E6END[0] Tile_X0Y0_IHP_SRAM_top.Inst_IHP_SRAM_top_switch_matrix.J_NS4_BEG0
+ Tile_X0Y0_IHP_SRAM_top.Inst_IHP_SRAM_top_ConfigMem.Inst_frame4_bit31.Q net52 VPWR
+ VGND sg13g2_mux4_1
X_1045_ Tile_X0Y0_FrameData[9] Tile_X0Y1_FrameStrobe[5] Tile_X0Y0_IHP_SRAM_top.Inst_IHP_SRAM_top_ConfigMem.Inst_frame5_bit9.Q
+ VPWR VGND sg13g2_dlhq_1
X_0829_ VGND VPWR Tile_X0Y1_E2MID[6] Tile_X0Y1_IHP_SRAM_bot.Inst_IHP_SRAM_bot_ConfigMem.Inst_frame2_bit28.Q
+ _0265_ _0258_ sg13g2_a21oi_1
XFILLER_0_117 VPWR VGND sg13g2_fill_1
XFILLER_56_176 VPWR VGND sg13g2_decap_8
XFILLER_28_24 VPWR VGND sg13g2_decap_8
XFILLER_100_62 VPWR VGND sg13g2_decap_8
XFILLER_60_44 VPWR VGND sg13g2_decap_8
XFILLER_60_22 VPWR VGND sg13g2_fill_1
XFILLER_107_0 VPWR VGND sg13g2_fill_1
XFILLER_62_124 VPWR VGND sg13g2_fill_2
X_1663_ Tile_X0Y0_S4END[8] net268 VPWR VGND sg13g2_buf_1
XFILLER_105_18 VPWR VGND sg13g2_decap_8
X_0545_ Tile_X0Y0_IHP_SRAM_top.Inst_IHP_SRAM_top_ConfigMem.Inst_frame8_bit14.Q Tile_X0Y0_E1END[0]
+ Tile_X0Y0_EE4END[0] Tile_X0Y0_E6END[8] Tile_X0Y0_IHP_SRAM_top.Inst_IHP_SRAM_top_switch_matrix.J_NS4_BEG0
+ Tile_X0Y0_IHP_SRAM_top.Inst_IHP_SRAM_top_ConfigMem.Inst_frame8_bit15.Q _0107_ VPWR
+ VGND sg13g2_mux4_1
X_1594_ Tile_X0Y0_IHP_SRAM_top.Inst_IHP_SRAM_top_switch_matrix.W6BEG11 net190 VPWR
+ VGND sg13g2_buf_1
X_0476_ Tile_X0Y0_IHP_SRAM_top.Inst_IHP_SRAM_top_ConfigMem.Inst_frame4_bit0.Q A_DOUT_SRAM17
+ A_DOUT_SRAM29 Tile_X0Y0_IHP_SRAM_top.Inst_IHP_SRAM_top_switch_matrix.J_NS4_BEG2
+ Tile_X0Y0_IHP_SRAM_top.Inst_IHP_SRAM_top_switch_matrix.J_NS2_BEG2 Tile_X0Y0_IHP_SRAM_top.Inst_IHP_SRAM_top_ConfigMem.Inst_frame4_bit1.Q
+ Tile_X0Y0_IHP_SRAM_top.Inst_IHP_SRAM_top_switch_matrix.WW4BEG13 VPWR VGND sg13g2_mux4_1
XFILLER_22_0 VPWR VGND sg13g2_fill_2
X_0614_ Tile_X0Y1_IHP_SRAM_bot.Inst_IHP_SRAM_bot_ConfigMem.Inst_frame8_bit24.Q Tile_X0Y1_E2MID[6]
+ Tile_X0Y1_E2END[6] Tile_X0Y1_E6END[9] _0078_ Tile_X0Y1_IHP_SRAM_bot.Inst_IHP_SRAM_bot_ConfigMem.Inst_frame8_bit25.Q
+ Tile_X0Y1_IHP_SRAM_bot.Inst_IHP_SRAM_bot_switch_matrix.S2BEG1 VPWR VGND sg13g2_mux4_1
XFILLER_53_146 VPWR VGND sg13g2_decap_4
X_1028_ Tile_X0Y0_FrameData[26] Tile_X0Y1_FrameStrobe[5] Tile_X0Y0_IHP_SRAM_top.Inst_IHP_SRAM_top_ConfigMem.Inst_frame5_bit26.Q
+ VPWR VGND sg13g2_dlhq_1
XFILLER_107_137 VPWR VGND sg13g2_decap_8
XFILLER_55_55 VPWR VGND sg13g2_decap_8
X_0330_ VPWR _0033_ Tile_X0Y1_IHP_SRAM_bot.Inst_IHP_SRAM_bot_ConfigMem.Inst_frame7_bit15.Q
+ VGND sg13g2_inv_1
XFILLER_35_113 VPWR VGND sg13g2_decap_8
X_1715_ Tile_X0Y1_IHP_SRAM_bot.Inst_IHP_SRAM_bot_switch_matrix.WW4BEG4 net326 VPWR
+ VGND sg13g2_buf_1
XFILLER_6_82 VPWR VGND sg13g2_fill_2
X_1646_ Tile_X0Y1_IHP_SRAM_bot.Inst_IHP_SRAM_bot_switch_matrix.S1BEG3 net251 VPWR
+ VGND sg13g2_buf_1
XFILLER_104_129 VPWR VGND sg13g2_decap_8
X_0528_ Tile_X0Y0_E2MID[1] Tile_X0Y0_IHP_SRAM_top.Inst_IHP_SRAM_top_ConfigMem.Inst_frame1_bit0.Q
+ Tile_X0Y0_IHP_SRAM_top.Inst_IHP_SRAM_top_ConfigMem.Inst_frame1_bit1.Q _0094_ VPWR
+ VGND sg13g2_nor3_1
X_0459_ Tile_X0Y0_IHP_SRAM_top.Inst_IHP_SRAM_top_ConfigMem.Inst_frame1_bit28.Q Tile_X0Y0_IHP_SRAM_top.Inst_IHP_SRAM_top_switch_matrix.N1END2
+ Tile_X0Y1_N4END[6] Tile_X0Y0_S1END[2] Tile_X0Y0_S4END[2] Tile_X0Y0_IHP_SRAM_top.Inst_IHP_SRAM_top_ConfigMem.Inst_frame1_bit29.Q
+ Tile_X0Y0_IHP_SRAM_top.Inst_IHP_SRAM_top_switch_matrix.J_NS4_BEG10 VPWR VGND sg13g2_mux4_1
X_1577_ Tile_X0Y0_IHP_SRAM_top.Inst_IHP_SRAM_top_switch_matrix.W2BEGb2 net182 VPWR
+ VGND sg13g2_buf_1
XFILLER_103_140 VPWR VGND sg13g2_decap_8
Xoutput119 net119 Tile_X0Y0_FrameStrobe_O[17] VPWR VGND sg13g2_buf_1
X_1500_ Tile_X0Y0_FrameData[26] net97 VPWR VGND sg13g2_buf_1
XFILLER_99_116 VPWR VGND sg13g2_decap_4
Xoutput108 net108 Tile_X0Y0_FrameData_O[7] VPWR VGND sg13g2_buf_1
XFILLER_63_7 VPWR VGND sg13g2_fill_1
Xoutput90 net90 Tile_X0Y0_FrameData_O[1] VPWR VGND sg13g2_buf_1
X_0313_ VPWR _0016_ Tile_X0Y0_IHP_SRAM_top.Inst_IHP_SRAM_top_ConfigMem.Inst_frame7_bit22.Q
+ VGND sg13g2_inv_1
X_1362_ Tile_X0Y1_FrameData[22] Tile_X0Y1_FrameStrobe[6] Tile_X0Y1_IHP_SRAM_bot.Inst_IHP_SRAM_bot_ConfigMem.Inst_frame6_bit22.Q
+ VPWR VGND sg13g2_dlhq_1
X_1293_ Tile_X0Y1_FrameData[27] Tile_X0Y1_FrameStrobe[4] Tile_X0Y1_IHP_SRAM_bot.Inst_IHP_SRAM_bot_ConfigMem.Inst_frame4_bit27.Q
+ VPWR VGND sg13g2_dlhq_1
X_1431_ Tile_X0Y1_FrameData[17] Tile_X0Y1_FrameStrobe[8] Tile_X0Y1_IHP_SRAM_bot.Inst_IHP_SRAM_bot_ConfigMem.Inst_frame8_bit17.Q
+ VPWR VGND sg13g2_dlhq_1
X_1629_ Tile_X0Y1_FrameData[18] net225 VPWR VGND sg13g2_buf_1
XFILLER_52_89 VPWR VGND sg13g2_decap_8
X_0931_ Tile_X0Y0_FrameData[27] Tile_X0Y1_FrameStrobe[2] Tile_X0Y0_IHP_SRAM_top.Inst_IHP_SRAM_top_ConfigMem.Inst_frame2_bit27.Q
+ VPWR VGND sg13g2_dlhq_1
X_0862_ _0296_ VPWR net77 VGND Tile_X0Y1_IHP_SRAM_bot.Inst_IHP_SRAM_bot_ConfigMem.Inst_frame1_bit7.Q
+ _0287_ sg13g2_o21ai_1
XFILLER_9_197 VPWR VGND sg13g2_fill_1
X_0793_ _0029_ _0082_ _0232_ VPWR VGND sg13g2_nor2_1
XFILLER_95_141 VPWR VGND sg13g2_fill_2
XFILLER_95_130 VPWR VGND sg13g2_decap_8
X_1345_ Tile_X0Y1_FrameData[7] Tile_X0Y1_FrameStrobe[5] Tile_X0Y1_IHP_SRAM_bot.Inst_IHP_SRAM_bot_ConfigMem.Inst_frame5_bit7.Q
+ VPWR VGND sg13g2_dlhq_1
X_1414_ Tile_X0Y1_FrameData[2] Tile_X0Y1_FrameStrobe[7] Tile_X0Y1_IHP_SRAM_bot.Inst_IHP_SRAM_bot_ConfigMem.Inst_frame7_bit2.Q
+ VPWR VGND sg13g2_dlhq_1
X_1276_ Tile_X0Y1_FrameData[12] Tile_X0Y1_FrameStrobe[3] Tile_X0Y1_IHP_SRAM_bot.Inst_IHP_SRAM_bot_ConfigMem.Inst_frame3_bit12.Q
+ VPWR VGND sg13g2_dlhq_1
XFILLER_0_8 VPWR VGND sg13g2_fill_1
XFILLER_92_111 VPWR VGND sg13g2_decap_4
XFILLER_88_74 VPWR VGND sg13g2_fill_2
XFILLER_77_130 VPWR VGND sg13g2_fill_2
X_1130_ Tile_X0Y0_FrameData[20] Tile_X0Y1_FrameStrobe[8] Tile_X0Y0_IHP_SRAM_top.Inst_IHP_SRAM_top_ConfigMem.Inst_frame8_bit20.Q
+ VPWR VGND sg13g2_dlhq_1
XFILLER_26_7 VPWR VGND sg13g2_fill_2
XFILLER_92_188 VPWR VGND sg13g2_fill_1
XFILLER_33_211 VPWR VGND sg13g2_fill_1
X_1061_ Tile_X0Y0_FrameData[25] Tile_X0Y1_FrameStrobe[6] Tile_X0Y0_IHP_SRAM_top.Inst_IHP_SRAM_top_ConfigMem.Inst_frame6_bit25.Q
+ VPWR VGND sg13g2_dlhq_1
X_0914_ Tile_X0Y0_FrameData[12] Tile_X0Y1_FrameStrobe[1] Tile_X0Y0_IHP_SRAM_top.Inst_IHP_SRAM_top_ConfigMem.Inst_frame1_bit12.Q
+ VPWR VGND sg13g2_dlhq_1
X_0845_ _0280_ Tile_X0Y1_N2END[2] Tile_X0Y1_IHP_SRAM_bot.Inst_IHP_SRAM_bot_ConfigMem.Inst_frame1_bit4.Q
+ VPWR VGND sg13g2_nand2_1
XFILLER_52_0 VPWR VGND sg13g2_fill_1
X_0776_ VGND VPWR _0209_ _0211_ Tile_X0Y0_IHP_SRAM_top.N4BEG_outbuf_11.A _0216_ sg13g2_a21oi_1
X_1328_ Tile_X0Y1_FrameData[24] Tile_X0Y1_FrameStrobe[5] Tile_X0Y1_IHP_SRAM_bot.Inst_IHP_SRAM_bot_ConfigMem.Inst_frame5_bit24.Q
+ VPWR VGND sg13g2_dlhq_1
X_1259_ Tile_X0Y1_FrameData[29] Tile_X0Y1_FrameStrobe[3] Tile_X0Y1_IHP_SRAM_bot.Inst_IHP_SRAM_bot_ConfigMem.Inst_frame3_bit29.Q
+ VPWR VGND sg13g2_dlhq_1
Xoutput291 net291 Tile_X0Y1_W2BEG[3] VPWR VGND sg13g2_buf_1
Xoutput280 net280 Tile_X0Y1_S4BEG[6] VPWR VGND sg13g2_buf_1
XFILLER_90_86 VPWR VGND sg13g2_decap_4
X_0492_ Tile_X0Y0_IHP_SRAM_top.Inst_IHP_SRAM_top_ConfigMem.Inst_frame4_bit29.Q A_DOUT_SRAM19
+ Tile_X0Y0_IHP_SRAM_top.Inst_IHP_SRAM_top_switch_matrix.J_NS4_BEG4 Tile_X0Y0_IHP_SRAM_top.Inst_IHP_SRAM_top_switch_matrix.J_NS4_BEG0
+ Tile_X0Y0_IHP_SRAM_top.Inst_IHP_SRAM_top_switch_matrix.J_NS2_BEG7 Tile_X0Y0_IHP_SRAM_top.Inst_IHP_SRAM_top_ConfigMem.Inst_frame4_bit28.Q
+ Tile_X0Y0_IHP_SRAM_top.Inst_IHP_SRAM_top_switch_matrix.W6BEG11 VPWR VGND sg13g2_mux4_1
X_0561_ Tile_X0Y0_IHP_SRAM_top.Inst_IHP_SRAM_top_ConfigMem.Inst_frame8_bit21.Q Tile_X0Y0_E1END[2]
+ Tile_X0Y0_E6END[10] Tile_X0Y0_EE4END[2] Tile_X0Y0_IHP_SRAM_top.Inst_IHP_SRAM_top_switch_matrix.J_NS4_BEG2
+ Tile_X0Y0_IHP_SRAM_top.Inst_IHP_SRAM_top_ConfigMem.Inst_frame8_bit20.Q _0121_ VPWR
+ VGND sg13g2_mux4_1
XFILLER_2_181 VPWR VGND sg13g2_decap_8
X_0630_ Tile_X0Y1_IHP_SRAM_bot.Inst_IHP_SRAM_bot_ConfigMem.Inst_frame6_bit4.Q A_DOUT_SRAM5
+ A_DOUT_SRAM13 _0079_ _0082_ Tile_X0Y1_IHP_SRAM_bot.Inst_IHP_SRAM_bot_ConfigMem.Inst_frame6_bit5.Q
+ Tile_X0Y1_IHP_SRAM_bot.Inst_IHP_SRAM_bot_switch_matrix.W2BEG5 VPWR VGND sg13g2_mux4_1
X_1113_ Tile_X0Y0_FrameData[5] Tile_X0Y1_FrameStrobe[7] Tile_X0Y0_IHP_SRAM_top.Inst_IHP_SRAM_top_ConfigMem.Inst_frame7_bit5.Q
+ VPWR VGND sg13g2_dlhq_1
XFILLER_65_133 VPWR VGND sg13g2_fill_1
X_1044_ Tile_X0Y0_FrameData[10] Tile_X0Y1_FrameStrobe[5] Tile_X0Y0_IHP_SRAM_top.Inst_IHP_SRAM_top_ConfigMem.Inst_frame5_bit10.Q
+ VPWR VGND sg13g2_dlhq_1
XFILLER_21_214 VPWR VGND sg13g2_fill_2
X_0759_ VGND VPWR _0024_ _0200_ _0201_ Tile_X0Y1_IHP_SRAM_bot.Inst_IHP_SRAM_bot_ConfigMem.Inst_frame8_bit10.Q
+ sg13g2_a21oi_1
X_0828_ Tile_X0Y1_IHP_SRAM_bot.Inst_IHP_SRAM_bot_ConfigMem.Inst_frame2_bit30.Q _0262_
+ Tile_X0Y1_IHP_SRAM_bot.Inst_IHP_SRAM_bot_ConfigMem.Inst_frame2_bit29.Q _0264_ VPWR
+ VGND _0263_ sg13g2_nand4_1
XFILLER_71_103 VPWR VGND sg13g2_decap_8
XFILLER_44_46 VPWR VGND sg13g2_fill_1
XFILLER_109_94 VPWR VGND sg13g2_decap_8
XFILLER_79_203 VPWR VGND sg13g2_fill_1
XFILLER_93_7 VPWR VGND sg13g2_fill_1
X_1662_ Tile_X0Y0_IHP_SRAM_top.Inst_IHP_SRAM_top_switch_matrix.S2BEG7 net267 VPWR
+ VGND sg13g2_buf_1
X_0613_ Tile_X0Y1_IHP_SRAM_bot.Inst_IHP_SRAM_bot_ConfigMem.Inst_frame8_bit22.Q Tile_X0Y1_E2MID[7]
+ Tile_X0Y1_E2END[7] Tile_X0Y1_E6END[8] _0043_ Tile_X0Y1_IHP_SRAM_bot.Inst_IHP_SRAM_bot_ConfigMem.Inst_frame8_bit23.Q
+ Tile_X0Y1_IHP_SRAM_bot.Inst_IHP_SRAM_bot_switch_matrix.S2BEG0 VPWR VGND sg13g2_mux4_1
X_0544_ VGND VPWR _0011_ _0102_ _0106_ _0105_ sg13g2_a21oi_1
X_0475_ Tile_X0Y0_IHP_SRAM_top.Inst_IHP_SRAM_top_ConfigMem.Inst_frame1_bit12.Q Tile_X0Y0_IHP_SRAM_top.Inst_IHP_SRAM_top_switch_matrix.N1END2
+ Tile_X0Y1_N4END[6] Tile_X0Y0_S1END[2] Tile_X0Y0_S4END[2] Tile_X0Y0_IHP_SRAM_top.Inst_IHP_SRAM_top_ConfigMem.Inst_frame1_bit13.Q
+ Tile_X0Y0_IHP_SRAM_top.Inst_IHP_SRAM_top_switch_matrix.J_NS4_BEG2 VPWR VGND sg13g2_mux4_1
X_1593_ Tile_X0Y0_IHP_SRAM_top.Inst_IHP_SRAM_top_switch_matrix.W6BEG10 net189 VPWR
+ VGND sg13g2_buf_1
XFILLER_38_111 VPWR VGND sg13g2_decap_8
X_1027_ Tile_X0Y0_FrameData[27] Tile_X0Y1_FrameStrobe[5] Tile_X0Y0_IHP_SRAM_top.Inst_IHP_SRAM_top_ConfigMem.Inst_frame5_bit27.Q
+ VPWR VGND sg13g2_dlhq_1
XFILLER_107_116 VPWR VGND sg13g2_decap_8
XFILLER_30_37 VPWR VGND sg13g2_fill_1
XFILLER_29_166 VPWR VGND sg13g2_fill_2
XFILLER_71_44 VPWR VGND sg13g2_fill_1
XFILLER_106_193 VPWR VGND sg13g2_decap_8
XFILLER_96_74 VPWR VGND sg13g2_fill_1
XFILLER_43_180 VPWR VGND sg13g2_fill_2
XFILLER_50_128 VPWR VGND sg13g2_decap_4
X_1576_ Tile_X0Y0_IHP_SRAM_top.Inst_IHP_SRAM_top_switch_matrix.W2BEGb1 net181 VPWR
+ VGND sg13g2_buf_1
X_1714_ Tile_X0Y1_IHP_SRAM_bot.Inst_IHP_SRAM_bot_switch_matrix.WW4BEG3 net325 VPWR
+ VGND sg13g2_buf_1
X_1645_ Tile_X0Y1_IHP_SRAM_bot.Inst_IHP_SRAM_bot_switch_matrix.S1BEG2 net250 VPWR
+ VGND sg13g2_buf_1
X_0389_ Tile_X0Y0_IHP_SRAM_top.Inst_IHP_SRAM_top_ConfigMem.Inst_frame7_bit4.Q Tile_X0Y0_E2MID[6]
+ Tile_X0Y0_E2END[6] Tile_X0Y0_E6END[9] Tile_X0Y0_IHP_SRAM_top.Inst_IHP_SRAM_top_switch_matrix.J_NS2_BEG1
+ Tile_X0Y0_IHP_SRAM_top.Inst_IHP_SRAM_top_ConfigMem.Inst_frame7_bit5.Q Tile_X0Y0_IHP_SRAM_top.Inst_IHP_SRAM_top_switch_matrix.S2BEG1
+ VPWR VGND sg13g2_mux4_1
X_0527_ VPWR VGND Tile_X0Y0_IHP_SRAM_top.Inst_IHP_SRAM_top_ConfigMem.Inst_frame2_bit30.Q
+ _0092_ _0093_ Tile_X0Y0_IHP_SRAM_top.Inst_IHP_SRAM_top_ConfigMem.Inst_frame2_bit31.Q
+ net6 _0038_ sg13g2_a221oi_1
X_0458_ Tile_X0Y0_IHP_SRAM_top.Inst_IHP_SRAM_top_ConfigMem.Inst_frame5_bit14.Q A_DOUT_SRAM20
+ A_DOUT_SRAM24 Tile_X0Y0_IHP_SRAM_top.Inst_IHP_SRAM_top_switch_matrix.J_NS4_BEG11
+ Tile_X0Y0_IHP_SRAM_top.Inst_IHP_SRAM_top_switch_matrix.J_NS2_BEG3 Tile_X0Y0_IHP_SRAM_top.Inst_IHP_SRAM_top_ConfigMem.Inst_frame5_bit15.Q
+ Tile_X0Y0_IHP_SRAM_top.Inst_IHP_SRAM_top_switch_matrix.WW4BEG4 VPWR VGND sg13g2_mux4_1
XFILLER_25_48 VPWR VGND sg13g2_fill_1
XFILLER_26_169 VPWR VGND sg13g2_fill_2
XFILLER_1_213 VPWR VGND sg13g2_fill_2
XFILLER_106_95 VPWR VGND sg13g2_decap_8
XFILLER_103_196 VPWR VGND sg13g2_decap_8
XFILLER_17_103 VPWR VGND sg13g2_decap_8
XFILLER_17_136 VPWR VGND sg13g2_fill_2
Xoutput109 net109 Tile_X0Y0_FrameData_O[8] VPWR VGND sg13g2_buf_1
Xoutput1 net1 A_ADDR_SRAM0 VPWR VGND sg13g2_buf_1
X_1430_ Tile_X0Y1_FrameData[18] Tile_X0Y1_FrameStrobe[8] Tile_X0Y1_IHP_SRAM_bot.Inst_IHP_SRAM_bot_ConfigMem.Inst_frame8_bit18.Q
+ VPWR VGND sg13g2_dlhq_1
Xoutput91 net91 Tile_X0Y0_FrameData_O[20] VPWR VGND sg13g2_buf_1
Xoutput80 net80 Tile_X0Y0_FrameData_O[10] VPWR VGND sg13g2_buf_1
X_0312_ VPWR _0015_ Tile_X0Y0_IHP_SRAM_top.Inst_IHP_SRAM_top_ConfigMem.Inst_frame7_bit19.Q
+ VGND sg13g2_inv_1
X_1361_ Tile_X0Y1_FrameData[23] Tile_X0Y1_FrameStrobe[6] Tile_X0Y1_IHP_SRAM_bot.Inst_IHP_SRAM_bot_ConfigMem.Inst_frame6_bit23.Q
+ VPWR VGND sg13g2_dlhq_1
X_1292_ Tile_X0Y1_FrameData[28] Tile_X0Y1_FrameStrobe[4] Tile_X0Y1_IHP_SRAM_bot.Inst_IHP_SRAM_bot_ConfigMem.Inst_frame4_bit28.Q
+ VPWR VGND sg13g2_dlhq_1
X_1559_ Tile_X0Y0_IHP_SRAM_top.Inst_IHP_SRAM_top_switch_matrix.N4BEG1 net155 VPWR
+ VGND sg13g2_buf_1
XFILLER_98_183 VPWR VGND sg13g2_decap_8
X_1628_ Tile_X0Y1_FrameData[17] net224 VPWR VGND sg13g2_buf_1
XFILLER_36_36 VPWR VGND sg13g2_fill_2
XFILLER_37_209 VPWR VGND sg13g2_fill_2
X_0930_ Tile_X0Y0_FrameData[28] Tile_X0Y1_FrameStrobe[2] Tile_X0Y0_IHP_SRAM_top.Inst_IHP_SRAM_top_ConfigMem.Inst_frame2_bit28.Q
+ VPWR VGND sg13g2_dlhq_1
X_0792_ VGND VPWR _0030_ _0230_ _0231_ Tile_X0Y1_IHP_SRAM_bot.Inst_IHP_SRAM_bot_ConfigMem.Inst_frame7_bit11.Q
+ sg13g2_a21oi_1
X_0861_ Tile_X0Y1_IHP_SRAM_bot.Inst_IHP_SRAM_bot_ConfigMem.Inst_frame1_bit7.Q VPWR
+ _0296_ VGND _0291_ _0295_ sg13g2_o21ai_1
X_1413_ Tile_X0Y1_FrameData[3] Tile_X0Y1_FrameStrobe[7] Tile_X0Y1_IHP_SRAM_bot.Inst_IHP_SRAM_bot_ConfigMem.Inst_frame7_bit3.Q
+ VPWR VGND sg13g2_dlhq_1
XFILLER_54_4 VPWR VGND sg13g2_decap_4
X_1344_ Tile_X0Y1_FrameData[8] Tile_X0Y1_FrameStrobe[5] Tile_X0Y1_IHP_SRAM_bot.Inst_IHP_SRAM_bot_ConfigMem.Inst_frame5_bit8.Q
+ VPWR VGND sg13g2_dlhq_1
X_1275_ Tile_X0Y1_FrameData[13] Tile_X0Y1_FrameStrobe[3] Tile_X0Y1_IHP_SRAM_bot.Inst_IHP_SRAM_bot_ConfigMem.Inst_frame3_bit13.Q
+ VPWR VGND sg13g2_dlhq_1
XFILLER_105_214 VPWR VGND sg13g2_fill_2
XFILLER_105_203 VPWR VGND sg13g2_decap_8
XFILLER_86_164 VPWR VGND sg13g2_decap_8
XFILLER_86_120 VPWR VGND sg13g2_fill_1
XFILLER_103_52 VPWR VGND sg13g2_fill_1
XFILLER_86_175 VPWR VGND sg13g2_fill_2
XFILLER_88_97 VPWR VGND sg13g2_decap_8
XFILLER_77_153 VPWR VGND sg13g2_fill_2
X_1060_ Tile_X0Y0_FrameData[26] Tile_X0Y1_FrameStrobe[6] Tile_X0Y0_IHP_SRAM_top.Inst_IHP_SRAM_top_ConfigMem.Inst_frame6_bit26.Q
+ VPWR VGND sg13g2_dlhq_1
XFILLER_108_19 VPWR VGND sg13g2_decap_4
X_0913_ Tile_X0Y0_FrameData[13] Tile_X0Y1_FrameStrobe[1] Tile_X0Y0_IHP_SRAM_top.Inst_IHP_SRAM_top_ConfigMem.Inst_frame1_bit13.Q
+ VPWR VGND sg13g2_dlhq_1
X_0844_ Tile_X0Y1_IHP_SRAM_bot.Inst_IHP_SRAM_bot_ConfigMem.Inst_frame1_bit4.Q Tile_X0Y1_N2END[3]
+ Tile_X0Y1_E2MID[0] Tile_X0Y1_E2END[1] Tile_X0Y1_E2END[2] Tile_X0Y1_IHP_SRAM_bot.Inst_IHP_SRAM_bot_ConfigMem.Inst_frame1_bit6.Q
+ _0279_ VPWR VGND sg13g2_mux4_1
X_0775_ VGND VPWR _0026_ _0214_ _0216_ _0215_ sg13g2_a21oi_1
XFILLER_5_190 VPWR VGND sg13g2_decap_8
XFILLER_45_0 VPWR VGND sg13g2_fill_1
X_1327_ Tile_X0Y1_FrameData[25] Tile_X0Y1_FrameStrobe[5] Tile_X0Y1_IHP_SRAM_bot.Inst_IHP_SRAM_bot_ConfigMem.Inst_frame5_bit25.Q
+ VPWR VGND sg13g2_dlhq_1
X_1258_ Tile_X0Y1_FrameData[30] Tile_X0Y1_FrameStrobe[3] Tile_X0Y1_IHP_SRAM_bot.Inst_IHP_SRAM_bot_ConfigMem.Inst_frame3_bit30.Q
+ VPWR VGND sg13g2_dlhq_1
X_1189_ Tile_X0Y1_FrameData[3] Tile_X0Y1_FrameStrobe[0] Tile_X0Y1_IHP_SRAM_bot.Inst_IHP_SRAM_bot_ConfigMem.Inst_frame0_bit3.Q
+ VPWR VGND sg13g2_dlhq_1
Xoutput270 net270 Tile_X0Y1_S4BEG[11] VPWR VGND sg13g2_buf_1
XFILLER_59_120 VPWR VGND sg13g2_fill_2
Xoutput292 net292 Tile_X0Y1_W2BEG[4] VPWR VGND sg13g2_buf_1
Xoutput281 net281 Tile_X0Y1_S4BEG[7] VPWR VGND sg13g2_buf_1
XFILLER_97_215 VPWR VGND sg13g2_fill_1
X_0560_ VGND VPWR _0013_ _0116_ _0120_ _0119_ sg13g2_a21oi_1
X_0491_ Tile_X0Y0_IHP_SRAM_top.Inst_IHP_SRAM_top_ConfigMem.Inst_frame4_bit27.Q A_DOUT_SRAM18
+ Tile_X0Y0_IHP_SRAM_top.Inst_IHP_SRAM_top_switch_matrix.J_NS4_BEG5 Tile_X0Y0_IHP_SRAM_top.Inst_IHP_SRAM_top_switch_matrix.J_NS4_BEG1
+ Tile_X0Y0_IHP_SRAM_top.Inst_IHP_SRAM_top_switch_matrix.J_NS2_BEG6 Tile_X0Y0_IHP_SRAM_top.Inst_IHP_SRAM_top_ConfigMem.Inst_frame4_bit26.Q
+ Tile_X0Y0_IHP_SRAM_top.Inst_IHP_SRAM_top_switch_matrix.W6BEG10 VPWR VGND sg13g2_mux4_1
X_1112_ Tile_X0Y0_FrameData[6] Tile_X0Y1_FrameStrobe[7] Tile_X0Y0_IHP_SRAM_top.Inst_IHP_SRAM_top_ConfigMem.Inst_frame7_bit6.Q
+ VPWR VGND sg13g2_dlhq_1
XFILLER_65_112 VPWR VGND sg13g2_fill_1
XFILLER_65_101 VPWR VGND sg13g2_decap_8
X_1043_ Tile_X0Y0_FrameData[11] Tile_X0Y1_FrameStrobe[5] Tile_X0Y0_IHP_SRAM_top.Inst_IHP_SRAM_top_ConfigMem.Inst_frame5_bit11.Q
+ VPWR VGND sg13g2_dlhq_1
XFILLER_0_74 VPWR VGND sg13g2_fill_2
X_0758_ Tile_X0Y1_E1END[2] Tile_X0Y1_EE4END[2] Tile_X0Y1_IHP_SRAM_bot.Inst_IHP_SRAM_bot_ConfigMem.Inst_frame8_bit8.Q
+ _0200_ VPWR VGND sg13g2_mux2_1
X_0827_ _0263_ Tile_X0Y1_E2END[2] Tile_X0Y1_IHP_SRAM_bot.Inst_IHP_SRAM_bot_ConfigMem.Inst_frame2_bit28.Q
+ VPWR VGND sg13g2_nand2_1
X_0689_ Tile_X0Y1_IHP_SRAM_bot.Inst_IHP_SRAM_bot_ConfigMem.Inst_frame4_bit23.Q _0079_
+ _0168_ VPWR VGND Tile_X0Y1_IHP_SRAM_bot.Inst_IHP_SRAM_bot_ConfigMem.Inst_frame4_bit22.Q
+ sg13g2_nand3b_1
XFILLER_109_40 VPWR VGND sg13g2_fill_2
XFILLER_109_73 VPWR VGND sg13g2_decap_8
XFILLER_85_98 VPWR VGND sg13g2_fill_1
X_1592_ Tile_X0Y0_IHP_SRAM_top.Inst_IHP_SRAM_top_switch_matrix.W6BEG9 net199 VPWR
+ VGND sg13g2_buf_1
X_1661_ Tile_X0Y0_IHP_SRAM_top.Inst_IHP_SRAM_top_switch_matrix.S2BEG6 net266 VPWR
+ VGND sg13g2_buf_1
X_0612_ Tile_X0Y1_IHP_SRAM_bot.Inst_IHP_SRAM_bot_ConfigMem.Inst_frame8_bit20.Q Tile_X0Y1_E1END[3]
+ Tile_X0Y1_E6END[11] Tile_X0Y1_IHP_SRAM_bot.Inst_IHP_SRAM_bot_switch_matrix.J_NS4_BEG15
+ _0077_ Tile_X0Y1_IHP_SRAM_bot.Inst_IHP_SRAM_bot_ConfigMem.Inst_frame8_bit21.Q Tile_X0Y1_IHP_SRAM_bot.Inst_IHP_SRAM_bot_switch_matrix.S1BEG3
+ VPWR VGND sg13g2_mux4_1
X_0543_ Tile_X0Y0_IHP_SRAM_top.Inst_IHP_SRAM_top_ConfigMem.Inst_frame8_bit16.Q VPWR
+ _0105_ VGND _0103_ _0104_ sg13g2_o21ai_1
X_0474_ Tile_X0Y0_IHP_SRAM_top.Inst_IHP_SRAM_top_ConfigMem.Inst_frame5_bit30.Q A_DOUT_SRAM16
+ A_DOUT_SRAM28 Tile_X0Y0_IHP_SRAM_top.Inst_IHP_SRAM_top_switch_matrix.J_NS4_BEG3
+ Tile_X0Y0_IHP_SRAM_top.Inst_IHP_SRAM_top_switch_matrix.J_NS2_BEG3 Tile_X0Y0_IHP_SRAM_top.Inst_IHP_SRAM_top_ConfigMem.Inst_frame5_bit31.Q
+ Tile_X0Y0_IHP_SRAM_top.Inst_IHP_SRAM_top_switch_matrix.WW4BEG12 VPWR VGND sg13g2_mux4_1
X_1026_ Tile_X0Y0_FrameData[28] Tile_X0Y1_FrameStrobe[5] Tile_X0Y0_IHP_SRAM_top.Inst_IHP_SRAM_top_ConfigMem.Inst_frame5_bit28.Q
+ VPWR VGND sg13g2_dlhq_1
XFILLER_38_156 VPWR VGND sg13g2_fill_1
XFILLER_29_123 VPWR VGND sg13g2_decap_4
XFILLER_39_58 VPWR VGND sg13g2_fill_1
XFILLER_111_96 VPWR VGND sg13g2_decap_8
XFILLER_4_211 VPWR VGND sg13g2_fill_1
XFILLER_106_172 VPWR VGND sg13g2_decap_8
XFILLER_35_148 VPWR VGND sg13g2_fill_2
X_1713_ Tile_X0Y1_IHP_SRAM_bot.Inst_IHP_SRAM_bot_switch_matrix.WW4BEG2 net324 VPWR
+ VGND sg13g2_buf_1
XFILLER_43_192 VPWR VGND sg13g2_fill_2
X_0526_ _0093_ Tile_X0Y0_E2END[0] Tile_X0Y0_IHP_SRAM_top.Inst_IHP_SRAM_top_ConfigMem.Inst_frame2_bit31.Q
+ VPWR VGND sg13g2_nand2b_1
X_1575_ Tile_X0Y0_IHP_SRAM_top.Inst_IHP_SRAM_top_switch_matrix.W2BEGb0 net180 VPWR
+ VGND sg13g2_buf_1
X_1644_ Tile_X0Y1_IHP_SRAM_bot.Inst_IHP_SRAM_bot_switch_matrix.S1BEG1 net249 VPWR
+ VGND sg13g2_buf_1
X_0388_ Tile_X0Y0_IHP_SRAM_top.Inst_IHP_SRAM_top_ConfigMem.Inst_frame9_bit30.Q Tile_X0Y0_E2MID[7]
+ Tile_X0Y0_E2END[7] Tile_X0Y0_E6END[7] Tile_X0Y0_IHP_SRAM_top.Inst_IHP_SRAM_top_switch_matrix.J_NS2_BEG0
+ Tile_X0Y0_IHP_SRAM_top.Inst_IHP_SRAM_top_ConfigMem.Inst_frame9_bit31.Q Tile_X0Y0_IHP_SRAM_top.Inst_IHP_SRAM_top_switch_matrix.N2BEG0
+ VPWR VGND sg13g2_mux4_1
X_0457_ Tile_X0Y0_IHP_SRAM_top.Inst_IHP_SRAM_top_ConfigMem.Inst_frame1_bit30.Q Tile_X0Y0_IHP_SRAM_top.Inst_IHP_SRAM_top_switch_matrix.N1END3
+ Tile_X0Y1_N4END[7] Tile_X0Y0_S1END[3] Tile_X0Y0_S4END[3] Tile_X0Y0_IHP_SRAM_top.Inst_IHP_SRAM_top_ConfigMem.Inst_frame1_bit31.Q
+ Tile_X0Y0_IHP_SRAM_top.Inst_IHP_SRAM_top_switch_matrix.J_NS4_BEG11 VPWR VGND sg13g2_mux4_1
XFILLER_81_210 VPWR VGND sg13g2_fill_2
X_1009_ Tile_X0Y0_FrameData[13] Tile_X0Y1_FrameStrobe[4] Tile_X0Y0_IHP_SRAM_top.Inst_IHP_SRAM_top_ConfigMem.Inst_frame4_bit13.Q
+ VPWR VGND sg13g2_dlhq_1
XFILLER_106_74 VPWR VGND sg13g2_decap_8
XFILLER_103_175 VPWR VGND sg13g2_decap_8
Xoutput2 net2 A_ADDR_SRAM1 VPWR VGND sg13g2_buf_1
X_1360_ Tile_X0Y1_FrameData[24] Tile_X0Y1_FrameStrobe[6] Tile_X0Y1_IHP_SRAM_bot.Inst_IHP_SRAM_bot_ConfigMem.Inst_frame6_bit24.Q
+ VPWR VGND sg13g2_dlhq_1
Xoutput70 net70 A_DIN_SRAM4 VPWR VGND sg13g2_buf_1
Xoutput92 net92 Tile_X0Y0_FrameData_O[21] VPWR VGND sg13g2_buf_1
X_0311_ VPWR _0014_ Tile_X0Y0_IHP_SRAM_top.Inst_IHP_SRAM_top_ConfigMem.Inst_frame8_bit24.Q
+ VGND sg13g2_inv_1
Xoutput81 net81 Tile_X0Y0_FrameData_O[11] VPWR VGND sg13g2_buf_1
XFILLER_63_210 VPWR VGND sg13g2_fill_2
X_1291_ Tile_X0Y1_FrameData[29] Tile_X0Y1_FrameStrobe[4] Tile_X0Y1_IHP_SRAM_bot.Inst_IHP_SRAM_bot_ConfigMem.Inst_frame4_bit29.Q
+ VPWR VGND sg13g2_dlhq_1
XFILLER_11_18 VPWR VGND sg13g2_fill_2
X_1558_ Tile_X0Y0_IHP_SRAM_top.Inst_IHP_SRAM_top_switch_matrix.N4BEG0 net154 VPWR
+ VGND sg13g2_buf_1
X_1489_ Tile_X0Y0_FrameData[15] net85 VPWR VGND sg13g2_buf_1
X_0509_ Tile_X0Y0_IHP_SRAM_top.Inst_IHP_SRAM_top_ConfigMem.Inst_frame3_bit30.Q Tile_X0Y0_EE4END[0]
+ Tile_X0Y0_EE4END[8] Tile_X0Y0_E6END[0] Tile_X0Y0_IHP_SRAM_top.Inst_IHP_SRAM_top_switch_matrix.J_NS4_BEG0
+ Tile_X0Y0_IHP_SRAM_top.Inst_IHP_SRAM_top_ConfigMem.Inst_frame3_bit31.Q net19 VPWR
+ VGND sg13g2_mux4_1
X_1627_ Tile_X0Y1_FrameData[16] net223 VPWR VGND sg13g2_buf_1
XFILLER_100_189 VPWR VGND sg13g2_decap_8
XFILLER_54_210 VPWR VGND sg13g2_fill_2
XFILLER_52_36 VPWR VGND sg13g2_fill_1
XFILLER_52_58 VPWR VGND sg13g2_decap_4
XFILLER_93_98 VPWR VGND sg13g2_decap_8
X_0791_ Tile_X0Y1_E1END[1] Tile_X0Y1_EE4END[13] Tile_X0Y1_IHP_SRAM_bot.Inst_IHP_SRAM_bot_ConfigMem.Inst_frame7_bit9.Q
+ _0230_ VPWR VGND sg13g2_mux2_1
X_0860_ Tile_X0Y1_IHP_SRAM_bot.Inst_IHP_SRAM_bot_ConfigMem.Inst_frame1_bit4.Q _0293_
+ _0294_ _0295_ VPWR VGND sg13g2_nor3_1
XFILLER_3_63 VPWR VGND sg13g2_fill_1
X_1343_ Tile_X0Y1_FrameData[9] Tile_X0Y1_FrameStrobe[5] Tile_X0Y1_IHP_SRAM_bot.Inst_IHP_SRAM_bot_ConfigMem.Inst_frame5_bit9.Q
+ VPWR VGND sg13g2_dlhq_1
X_1412_ Tile_X0Y1_FrameData[4] Tile_X0Y1_FrameStrobe[7] Tile_X0Y1_IHP_SRAM_bot.Inst_IHP_SRAM_bot_ConfigMem.Inst_frame7_bit4.Q
+ VPWR VGND sg13g2_dlhq_1
XFILLER_47_4 VPWR VGND sg13g2_fill_2
X_1274_ Tile_X0Y1_FrameData[14] Tile_X0Y1_FrameStrobe[3] Tile_X0Y1_IHP_SRAM_bot.Inst_IHP_SRAM_bot_ConfigMem.Inst_frame3_bit14.Q
+ VPWR VGND sg13g2_dlhq_1
X_0989_ Tile_X0Y0_FrameData[1] Tile_X0Y1_FrameStrobe[3] Tile_X0Y0_IHP_SRAM_top.Inst_IHP_SRAM_top_ConfigMem.Inst_frame3_bit1.Q
+ VPWR VGND sg13g2_dlhq_1
XFILLER_63_57 VPWR VGND sg13g2_decap_8
XFILLER_42_213 VPWR VGND sg13g2_fill_2
XFILLER_10_154 VPWR VGND sg13g2_fill_2
XFILLER_12_83 VPWR VGND sg13g2_fill_1
XFILLER_77_176 VPWR VGND sg13g2_fill_1
X_0912_ Tile_X0Y0_FrameData[14] Tile_X0Y1_FrameStrobe[1] Tile_X0Y0_IHP_SRAM_top.Inst_IHP_SRAM_top_ConfigMem.Inst_frame1_bit14.Q
+ VPWR VGND sg13g2_dlhq_1
X_0843_ net78 _0274_ _0278_ _0270_ _0036_ VPWR VGND sg13g2_a22oi_1
X_0774_ Tile_X0Y1_IHP_SRAM_bot.Inst_IHP_SRAM_bot_ConfigMem.Inst_frame8_bit13.Q VPWR
+ _0215_ VGND _0212_ _0213_ sg13g2_o21ai_1
X_1326_ Tile_X0Y1_FrameData[26] Tile_X0Y1_FrameStrobe[5] Tile_X0Y1_IHP_SRAM_bot.Inst_IHP_SRAM_bot_ConfigMem.Inst_frame5_bit26.Q
+ VPWR VGND sg13g2_dlhq_1
X_1257_ Tile_X0Y1_FrameData[31] Tile_X0Y1_FrameStrobe[3] Tile_X0Y1_IHP_SRAM_bot.Inst_IHP_SRAM_bot_ConfigMem.Inst_frame3_bit31.Q
+ VPWR VGND sg13g2_dlhq_1
X_1188_ Tile_X0Y1_FrameData[4] Tile_X0Y1_FrameStrobe[0] Tile_X0Y1_IHP_SRAM_bot.Inst_IHP_SRAM_bot_ConfigMem.Inst_frame0_bit4.Q
+ VPWR VGND sg13g2_dlhq_1
Xoutput293 net293 Tile_X0Y1_W2BEG[5] VPWR VGND sg13g2_buf_1
Xoutput260 net260 Tile_X0Y1_S2BEGb[0] VPWR VGND sg13g2_buf_1
Xoutput282 net282 Tile_X0Y1_S4BEG[8] VPWR VGND sg13g2_buf_1
Xoutput271 net271 Tile_X0Y1_S4BEG[12] VPWR VGND sg13g2_buf_1
XFILLER_74_124 VPWR VGND sg13g2_fill_2
XFILLER_59_176 VPWR VGND sg13g2_fill_2
XFILLER_58_79 VPWR VGND sg13g2_decap_4
XFILLER_90_77 VPWR VGND sg13g2_decap_4
X_0490_ Tile_X0Y0_IHP_SRAM_top.Inst_IHP_SRAM_top_ConfigMem.Inst_frame4_bit25.Q A_DOUT_SRAM17
+ Tile_X0Y0_IHP_SRAM_top.Inst_IHP_SRAM_top_switch_matrix.J_NS4_BEG6 Tile_X0Y0_IHP_SRAM_top.Inst_IHP_SRAM_top_switch_matrix.J_NS4_BEG2
+ Tile_X0Y0_IHP_SRAM_top.Inst_IHP_SRAM_top_switch_matrix.J_NS2_BEG5 Tile_X0Y0_IHP_SRAM_top.Inst_IHP_SRAM_top_ConfigMem.Inst_frame4_bit24.Q
+ Tile_X0Y0_IHP_SRAM_top.Inst_IHP_SRAM_top_switch_matrix.W6BEG9 VPWR VGND sg13g2_mux4_1
X_1111_ Tile_X0Y0_FrameData[7] Tile_X0Y1_FrameStrobe[7] Tile_X0Y0_IHP_SRAM_top.Inst_IHP_SRAM_top_ConfigMem.Inst_frame7_bit7.Q
+ VPWR VGND sg13g2_dlhq_1
X_1042_ Tile_X0Y0_FrameData[12] Tile_X0Y1_FrameStrobe[5] Tile_X0Y0_IHP_SRAM_top.Inst_IHP_SRAM_top_ConfigMem.Inst_frame5_bit12.Q
+ VPWR VGND sg13g2_dlhq_1
XFILLER_0_42 VPWR VGND sg13g2_fill_1
X_0688_ _0165_ VPWR net2 VGND Tile_X0Y1_IHP_SRAM_bot.Inst_IHP_SRAM_bot_ConfigMem.Inst_frame4_bit21.Q
+ _0167_ sg13g2_o21ai_1
X_0757_ _0198_ VPWR _0199_ VGND _0023_ _0159_ sg13g2_o21ai_1
X_0826_ _0262_ Tile_X0Y1_E2END[1] _0035_ VPWR VGND sg13g2_nand2_1
X_1309_ Tile_X0Y1_FrameData[11] Tile_X0Y1_FrameStrobe[4] Tile_X0Y1_IHP_SRAM_bot.Inst_IHP_SRAM_bot_ConfigMem.Inst_frame4_bit11.Q
+ VPWR VGND sg13g2_dlhq_1
XFILLER_100_32 VPWR VGND sg13g2_decap_4
XFILLER_71_127 VPWR VGND sg13g2_fill_1
XFILLER_100_76 VPWR VGND sg13g2_fill_2
XFILLER_69_89 VPWR VGND sg13g2_decap_4
XFILLER_47_102 VPWR VGND sg13g2_fill_1
XFILLER_86_8 VPWR VGND sg13g2_fill_1
X_0542_ Tile_X0Y0_IHP_SRAM_top.Inst_IHP_SRAM_top_ConfigMem.Inst_frame8_bit15.Q VPWR
+ _0104_ VGND Tile_X0Y0_IHP_SRAM_top.Inst_IHP_SRAM_top_ConfigMem.Inst_frame8_bit14.Q
+ Tile_X0Y0_IHP_SRAM_top.Inst_IHP_SRAM_top_switch_matrix.J_NS4_BEG12 sg13g2_o21ai_1
X_1591_ Tile_X0Y0_IHP_SRAM_top.Inst_IHP_SRAM_top_switch_matrix.W6BEG8 net198 VPWR
+ VGND sg13g2_buf_1
X_1660_ Tile_X0Y0_IHP_SRAM_top.Inst_IHP_SRAM_top_switch_matrix.S2BEG5 net265 VPWR
+ VGND sg13g2_buf_1
X_0611_ Tile_X0Y1_IHP_SRAM_bot.Inst_IHP_SRAM_bot_ConfigMem.Inst_frame8_bit18.Q Tile_X0Y1_E1END[2]
+ Tile_X0Y1_E6END[10] Tile_X0Y1_IHP_SRAM_bot.Inst_IHP_SRAM_bot_switch_matrix.J_NS4_BEG14
+ _0070_ Tile_X0Y1_IHP_SRAM_bot.Inst_IHP_SRAM_bot_ConfigMem.Inst_frame8_bit19.Q Tile_X0Y1_IHP_SRAM_bot.Inst_IHP_SRAM_bot_switch_matrix.S1BEG2
+ VPWR VGND sg13g2_mux4_1
X_0473_ Tile_X0Y0_IHP_SRAM_top.Inst_IHP_SRAM_top_ConfigMem.Inst_frame1_bit14.Q Tile_X0Y0_IHP_SRAM_top.Inst_IHP_SRAM_top_switch_matrix.N1END3
+ Tile_X0Y1_N4END[7] Tile_X0Y0_S1END[3] Tile_X0Y0_S4END[3] Tile_X0Y0_IHP_SRAM_top.Inst_IHP_SRAM_top_ConfigMem.Inst_frame1_bit15.Q
+ Tile_X0Y0_IHP_SRAM_top.Inst_IHP_SRAM_top_switch_matrix.J_NS4_BEG3 VPWR VGND sg13g2_mux4_1
XFILLER_85_208 VPWR VGND sg13g2_decap_4
X_1025_ Tile_X0Y0_FrameData[29] Tile_X0Y1_FrameStrobe[5] Tile_X0Y0_IHP_SRAM_top.Inst_IHP_SRAM_top_ConfigMem.Inst_frame5_bit29.Q
+ VPWR VGND sg13g2_dlhq_1
X_0809_ VGND VPWR _0239_ _0241_ Tile_X0Y1_IHP_SRAM_bot.Inst_IHP_SRAM_bot_switch_matrix.S4BEG2
+ _0246_ sg13g2_a21oi_1
XFILLER_44_127 VPWR VGND sg13g2_decap_8
XFILLER_106_151 VPWR VGND sg13g2_decap_8
XFILLER_105_0 VPWR VGND sg13g2_fill_1
XFILLER_35_127 VPWR VGND sg13g2_decap_4
XFILLER_43_182 VPWR VGND sg13g2_fill_1
X_1712_ Tile_X0Y1_IHP_SRAM_bot.Inst_IHP_SRAM_bot_switch_matrix.WW4BEG1 net323 VPWR
+ VGND sg13g2_buf_1
X_1643_ Tile_X0Y1_IHP_SRAM_bot.Inst_IHP_SRAM_bot_switch_matrix.S1BEG0 net248 VPWR
+ VGND sg13g2_buf_1
XANTENNA_1 VPWR VGND A_DOUT_SRAM18 sg13g2_antennanp
X_0525_ Tile_X0Y0_E2MID[0] Tile_X0Y0_IHP_SRAM_top.Inst_IHP_SRAM_top_ConfigMem.Inst_frame2_bit30.Q
+ Tile_X0Y0_IHP_SRAM_top.Inst_IHP_SRAM_top_ConfigMem.Inst_frame2_bit31.Q _0092_ VPWR
+ VGND sg13g2_nor3_1
X_0456_ Tile_X0Y0_IHP_SRAM_top.Inst_IHP_SRAM_top_ConfigMem.Inst_frame5_bit12.Q A_DOUT_SRAM19
+ A_DOUT_SRAM31 Tile_X0Y0_IHP_SRAM_top.Inst_IHP_SRAM_top_switch_matrix.J_NS4_BEG12
+ Tile_X0Y0_IHP_SRAM_top.Inst_IHP_SRAM_top_switch_matrix.J_NS2_BEG4 Tile_X0Y0_IHP_SRAM_top.Inst_IHP_SRAM_top_ConfigMem.Inst_frame5_bit13.Q
+ Tile_X0Y0_IHP_SRAM_top.Inst_IHP_SRAM_top_switch_matrix.WW4BEG3 VPWR VGND sg13g2_mux4_1
X_1574_ Tile_X0Y0_IHP_SRAM_top.Inst_IHP_SRAM_top_switch_matrix.W2BEG7 net179 VPWR
+ VGND sg13g2_buf_1
XFILLER_6_63 VPWR VGND sg13g2_fill_2
X_0387_ Tile_X0Y0_IHP_SRAM_top.Inst_IHP_SRAM_top_ConfigMem.Inst_frame9_bit28.Q Tile_X0Y0_E1END[3]
+ Tile_X0Y0_E6END[7] Tile_X0Y0_IHP_SRAM_top.Inst_IHP_SRAM_top_switch_matrix.J_NS4_BEG15
+ _0073_ Tile_X0Y0_IHP_SRAM_top.Inst_IHP_SRAM_top_ConfigMem.Inst_frame9_bit29.Q Tile_X0Y0_IHP_SRAM_top.Inst_IHP_SRAM_top_switch_matrix.N1BEG3
+ VPWR VGND sg13g2_mux4_1
XFILLER_20_0 VPWR VGND sg13g2_fill_1
X_1008_ Tile_X0Y0_FrameData[14] Tile_X0Y1_FrameStrobe[4] Tile_X0Y0_IHP_SRAM_top.Inst_IHP_SRAM_top_ConfigMem.Inst_frame4_bit14.Q
+ VPWR VGND sg13g2_dlhq_1
XFILLER_25_39 VPWR VGND sg13g2_decap_8
XFILLER_34_171 VPWR VGND sg13g2_fill_1
XFILLER_1_215 VPWR VGND sg13g2_fill_1
XFILLER_106_53 VPWR VGND sg13g2_decap_8
XFILLER_103_154 VPWR VGND sg13g2_decap_8
XFILLER_17_138 VPWR VGND sg13g2_fill_1
Xoutput93 net93 Tile_X0Y0_FrameData_O[22] VPWR VGND sg13g2_buf_1
Xoutput82 net82 Tile_X0Y0_FrameData_O[12] VPWR VGND sg13g2_buf_1
X_0310_ VPWR _0013_ Tile_X0Y0_IHP_SRAM_top.Inst_IHP_SRAM_top_ConfigMem.Inst_frame8_bit21.Q
+ VGND sg13g2_inv_1
Xoutput71 net71 A_DIN_SRAM5 VPWR VGND sg13g2_buf_1
Xoutput3 net3 A_ADDR_SRAM2 VPWR VGND sg13g2_buf_1
Xoutput60 net60 A_DIN_SRAM23 VPWR VGND sg13g2_buf_1
X_1290_ Tile_X0Y1_FrameData[30] Tile_X0Y1_FrameStrobe[4] Tile_X0Y1_IHP_SRAM_bot.Inst_IHP_SRAM_bot_ConfigMem.Inst_frame4_bit30.Q
+ VPWR VGND sg13g2_dlhq_1
XFILLER_68_0 VPWR VGND sg13g2_fill_2
X_1626_ Tile_X0Y1_FrameData[15] net222 VPWR VGND sg13g2_buf_1
X_1557_ Tile_X0Y0_IHP_SRAM_top.N4BEG_outbuf_11.A net153 VPWR VGND sg13g2_buf_1
X_1488_ Tile_X0Y0_FrameData[14] net84 VPWR VGND sg13g2_buf_1
X_0508_ Tile_X0Y0_IHP_SRAM_top.Inst_IHP_SRAM_top_ConfigMem.Inst_frame3_bit28.Q Tile_X0Y0_E1END[3]
+ Tile_X0Y0_EE4END[7] Tile_X0Y0_EE4END[15] Tile_X0Y0_IHP_SRAM_top.Inst_IHP_SRAM_top_switch_matrix.J_NS4_BEG15
+ Tile_X0Y0_IHP_SRAM_top.Inst_IHP_SRAM_top_ConfigMem.Inst_frame3_bit29.Q net69 VPWR
+ VGND sg13g2_mux4_1
X_0439_ Tile_X0Y0_IHP_SRAM_top.Inst_IHP_SRAM_top_ConfigMem.Inst_frame6_bit12.Q A_DOUT_SRAM19
+ A_DOUT_SRAM27 Tile_X0Y0_IHP_SRAM_top.Inst_IHP_SRAM_top_switch_matrix.J_NS2_BEG3
+ Tile_X0Y0_IHP_SRAM_top.Inst_IHP_SRAM_top_switch_matrix.J_NS2_BEG4 Tile_X0Y0_IHP_SRAM_top.Inst_IHP_SRAM_top_ConfigMem.Inst_frame6_bit13.Q
+ Tile_X0Y0_IHP_SRAM_top.Inst_IHP_SRAM_top_switch_matrix.W2BEG3 VPWR VGND sg13g2_mux4_1
XFILLER_36_38 VPWR VGND sg13g2_fill_1
X_0790_ _0228_ VPWR _0229_ VGND _0029_ _0160_ sg13g2_o21ai_1
XFILLER_42_92 VPWR VGND sg13g2_fill_1
X_1342_ Tile_X0Y1_FrameData[10] Tile_X0Y1_FrameStrobe[5] Tile_X0Y1_IHP_SRAM_bot.Inst_IHP_SRAM_bot_ConfigMem.Inst_frame5_bit10.Q
+ VPWR VGND sg13g2_dlhq_1
X_1411_ Tile_X0Y1_FrameData[5] Tile_X0Y1_FrameStrobe[7] Tile_X0Y1_IHP_SRAM_bot.Inst_IHP_SRAM_bot_ConfigMem.Inst_frame7_bit5.Q
+ VPWR VGND sg13g2_dlhq_1
X_1273_ Tile_X0Y1_FrameData[15] Tile_X0Y1_FrameStrobe[3] Tile_X0Y1_IHP_SRAM_bot.Inst_IHP_SRAM_bot_ConfigMem.Inst_frame3_bit15.Q
+ VPWR VGND sg13g2_dlhq_1
X_0988_ Tile_X0Y0_FrameData[2] Tile_X0Y1_FrameStrobe[3] Tile_X0Y0_IHP_SRAM_top.Inst_IHP_SRAM_top_ConfigMem.Inst_frame3_bit2.Q
+ VPWR VGND sg13g2_dlhq_1
X_1609_ Tile_X0Y0_IHP_SRAM_top.Inst_IHP_SRAM_top_switch_matrix.WW4BEG14 net205 VPWR
+ VGND sg13g2_buf_1
XFILLER_27_211 VPWR VGND sg13g2_fill_1
XFILLER_103_98 VPWR VGND sg13g2_fill_1
XFILLER_18_211 VPWR VGND sg13g2_fill_1
XFILLER_37_92 VPWR VGND sg13g2_decap_4
X_0911_ Tile_X0Y0_FrameData[15] Tile_X0Y1_FrameStrobe[1] Tile_X0Y0_IHP_SRAM_top.Inst_IHP_SRAM_top_ConfigMem.Inst_frame1_bit15.Q
+ VPWR VGND sg13g2_dlhq_1
X_0842_ VGND VPWR _0035_ _0277_ _0278_ _0036_ sg13g2_a21oi_1
XFILLER_102_208 VPWR VGND sg13g2_decap_4
X_0773_ Tile_X0Y1_IHP_SRAM_bot.Inst_IHP_SRAM_bot_switch_matrix.J_NS4_BEG7 Tile_X0Y1_IHP_SRAM_bot.Inst_IHP_SRAM_bot_switch_matrix.J_NS4_BEG11
+ Tile_X0Y1_IHP_SRAM_bot.Inst_IHP_SRAM_bot_ConfigMem.Inst_frame8_bit11.Q _0214_ VPWR
+ VGND sg13g2_mux2_1
XFILLER_83_125 VPWR VGND sg13g2_decap_4
X_1325_ Tile_X0Y1_FrameData[27] Tile_X0Y1_FrameStrobe[5] Tile_X0Y1_IHP_SRAM_bot.Inst_IHP_SRAM_bot_ConfigMem.Inst_frame5_bit27.Q
+ VPWR VGND sg13g2_dlhq_1
X_1256_ Tile_X0Y1_FrameData[0] Tile_X0Y1_FrameStrobe[2] Tile_X0Y1_IHP_SRAM_bot.Inst_IHP_SRAM_bot_ConfigMem.Inst_frame2_bit0.Q
+ VPWR VGND sg13g2_dlhq_1
X_1187_ Tile_X0Y1_FrameData[5] Tile_X0Y1_FrameStrobe[0] Tile_X0Y1_IHP_SRAM_bot.Inst_IHP_SRAM_bot_ConfigMem.Inst_frame0_bit5.Q
+ VPWR VGND sg13g2_dlhq_1
XFILLER_109_7 VPWR VGND sg13g2_fill_1
Xoutput283 net283 Tile_X0Y1_S4BEG[9] VPWR VGND sg13g2_buf_1
Xoutput272 net272 Tile_X0Y1_S4BEG[13] VPWR VGND sg13g2_buf_1
Xoutput250 net250 Tile_X0Y1_S1BEG[2] VPWR VGND sg13g2_buf_1
Xoutput261 net261 Tile_X0Y1_S2BEGb[1] VPWR VGND sg13g2_buf_1
Xoutput294 net294 Tile_X0Y1_W2BEG[6] VPWR VGND sg13g2_buf_1
XFILLER_15_214 VPWR VGND sg13g2_fill_2
X_1110_ Tile_X0Y0_FrameData[8] Tile_X0Y1_FrameStrobe[7] Tile_X0Y0_IHP_SRAM_top.Inst_IHP_SRAM_top_ConfigMem.Inst_frame7_bit8.Q
+ VPWR VGND sg13g2_dlhq_1
XFILLER_2_195 VPWR VGND sg13g2_decap_8
X_1041_ Tile_X0Y0_FrameData[13] Tile_X0Y1_FrameStrobe[5] Tile_X0Y0_IHP_SRAM_top.Inst_IHP_SRAM_top_ConfigMem.Inst_frame5_bit13.Q
+ VPWR VGND sg13g2_dlhq_1
XFILLER_65_169 VPWR VGND sg13g2_decap_4
XFILLER_0_76 VPWR VGND sg13g2_fill_1
X_0825_ VGND VPWR Tile_X0Y1_N2MID[6] _0035_ _0261_ _0260_ sg13g2_a21oi_1
X_0687_ VGND VPWR Tile_X0Y1_E2END[1] Tile_X0Y1_IHP_SRAM_bot.Inst_IHP_SRAM_bot_ConfigMem.Inst_frame4_bit20.Q
+ _0167_ _0166_ sg13g2_a21oi_1
X_0756_ VPWR _0198_ _0197_ VGND sg13g2_inv_1
XFILLER_50_0 VPWR VGND sg13g2_fill_1
X_1308_ Tile_X0Y1_FrameData[12] Tile_X0Y1_FrameStrobe[4] Tile_X0Y1_IHP_SRAM_bot.Inst_IHP_SRAM_bot_ConfigMem.Inst_frame4_bit12.Q
+ VPWR VGND sg13g2_dlhq_1
X_1239_ Tile_X0Y1_FrameData[17] Tile_X0Y1_FrameStrobe[2] Tile_X0Y1_IHP_SRAM_bot.Inst_IHP_SRAM_bot_ConfigMem.Inst_frame2_bit17.Q
+ VPWR VGND sg13g2_dlhq_1
XFILLER_85_45 VPWR VGND sg13g2_decap_8
XFILLER_47_125 VPWR VGND sg13g2_decap_8
XFILLER_70_150 VPWR VGND sg13g2_decap_4
XFILLER_62_106 VPWR VGND sg13g2_fill_1
XFILLER_109_182 VPWR VGND sg13g2_fill_1
X_0541_ Tile_X0Y0_IHP_SRAM_top.Inst_IHP_SRAM_top_switch_matrix.J_NS2_BEG0 Tile_X0Y0_IHP_SRAM_top.Inst_IHP_SRAM_top_ConfigMem.Inst_frame8_bit14.Q
+ _0103_ VPWR VGND sg13g2_nor2b_1
X_1590_ Tile_X0Y0_IHP_SRAM_top.Inst_IHP_SRAM_top_switch_matrix.W6BEG7 net197 VPWR
+ VGND sg13g2_buf_1
X_0472_ Tile_X0Y0_IHP_SRAM_top.Inst_IHP_SRAM_top_ConfigMem.Inst_frame5_bit28.Q A_DOUT_SRAM23
+ A_DOUT_SRAM27 Tile_X0Y0_IHP_SRAM_top.Inst_IHP_SRAM_top_switch_matrix.J_NS4_BEG4
+ Tile_X0Y0_IHP_SRAM_top.Inst_IHP_SRAM_top_switch_matrix.J_NS2_BEG4 Tile_X0Y0_IHP_SRAM_top.Inst_IHP_SRAM_top_ConfigMem.Inst_frame5_bit29.Q
+ Tile_X0Y0_IHP_SRAM_top.Inst_IHP_SRAM_top_switch_matrix.WW4BEG11 VPWR VGND sg13g2_mux4_1
X_0610_ Tile_X0Y1_IHP_SRAM_bot.Inst_IHP_SRAM_bot_ConfigMem.Inst_frame8_bit16.Q Tile_X0Y1_E1END[1]
+ Tile_X0Y1_E6END[9] Tile_X0Y1_IHP_SRAM_bot.Inst_IHP_SRAM_bot_switch_matrix.J_NS4_BEG13
+ _0063_ Tile_X0Y1_IHP_SRAM_bot.Inst_IHP_SRAM_bot_ConfigMem.Inst_frame8_bit17.Q Tile_X0Y1_IHP_SRAM_bot.Inst_IHP_SRAM_bot_switch_matrix.S1BEG1
+ VPWR VGND sg13g2_mux4_1
X_1024_ Tile_X0Y0_FrameData[30] Tile_X0Y1_FrameStrobe[5] Tile_X0Y0_IHP_SRAM_top.Inst_IHP_SRAM_top_ConfigMem.Inst_frame5_bit30.Q
+ VPWR VGND sg13g2_dlhq_1
XFILLER_38_125 VPWR VGND sg13g2_fill_1
XFILLER_38_169 VPWR VGND sg13g2_fill_2
XFILLER_98_0 VPWR VGND sg13g2_decap_4
XFILLER_30_18 VPWR VGND sg13g2_fill_2
X_0808_ VGND VPWR _0032_ _0244_ _0246_ _0245_ sg13g2_a21oi_1
X_0739_ Tile_X0Y1_IHP_SRAM_bot.Inst_IHP_SRAM_bot_ConfigMem.Inst_frame8_bit3.Q VPWR
+ _0183_ VGND Tile_X0Y1_IHP_SRAM_bot.Inst_IHP_SRAM_bot_ConfigMem.Inst_frame8_bit2.Q
+ Tile_X0Y1_IHP_SRAM_bot.Inst_IHP_SRAM_bot_switch_matrix.J_NS4_BEG12 sg13g2_o21ai_1
XFILLER_106_130 VPWR VGND sg13g2_decap_8
XFILLER_4_202 VPWR VGND sg13g2_decap_8
XFILLER_91_7 VPWR VGND sg13g2_decap_4
XFILLER_43_194 VPWR VGND sg13g2_fill_1
XANTENNA_2 VPWR VGND A_DOUT_SRAM18 sg13g2_antennanp
X_1711_ Tile_X0Y1_IHP_SRAM_bot.Inst_IHP_SRAM_bot_switch_matrix.WW4BEG0 net316 VPWR
+ VGND sg13g2_buf_1
X_1642_ Tile_X0Y1_FrameData[31] net240 VPWR VGND sg13g2_buf_1
X_0455_ Tile_X0Y0_IHP_SRAM_top.Inst_IHP_SRAM_top_ConfigMem.Inst_frame0_bit0.Q Tile_X0Y0_IHP_SRAM_top.Inst_IHP_SRAM_top_switch_matrix.N1END0
+ Tile_X0Y1_N4END[4] Tile_X0Y0_S1END[0] Tile_X0Y0_S4END[0] Tile_X0Y0_IHP_SRAM_top.Inst_IHP_SRAM_top_ConfigMem.Inst_frame0_bit1.Q
+ Tile_X0Y0_IHP_SRAM_top.Inst_IHP_SRAM_top_switch_matrix.J_NS4_BEG12 VPWR VGND sg13g2_mux4_1
X_0524_ Tile_X0Y0_IHP_SRAM_top.Inst_IHP_SRAM_top_ConfigMem.Inst_frame2_bit28.Q Tile_X0Y0_E1END[3]
+ Tile_X0Y0_EE4END[7] Tile_X0Y0_EE4END[15] Tile_X0Y0_IHP_SRAM_top.Inst_IHP_SRAM_top_switch_matrix.J_NS4_BEG15
+ Tile_X0Y0_IHP_SRAM_top.Inst_IHP_SRAM_top_ConfigMem.Inst_frame2_bit29.Q net36 VPWR
+ VGND sg13g2_mux4_1
X_1573_ Tile_X0Y0_IHP_SRAM_top.Inst_IHP_SRAM_top_switch_matrix.W2BEG6 net178 VPWR
+ VGND sg13g2_buf_1
X_0386_ Tile_X0Y0_IHP_SRAM_top.Inst_IHP_SRAM_top_ConfigMem.Inst_frame0_bit6.Q Tile_X0Y0_IHP_SRAM_top.Inst_IHP_SRAM_top_switch_matrix.N1END3
+ Tile_X0Y1_N4END[7] Tile_X0Y0_S1END[3] Tile_X0Y0_S4END[3] Tile_X0Y0_IHP_SRAM_top.Inst_IHP_SRAM_top_ConfigMem.Inst_frame0_bit7.Q
+ Tile_X0Y0_IHP_SRAM_top.Inst_IHP_SRAM_top_switch_matrix.J_NS4_BEG15 VPWR VGND sg13g2_mux4_1
X_1007_ Tile_X0Y0_FrameData[15] Tile_X0Y1_FrameStrobe[4] Tile_X0Y0_IHP_SRAM_top.Inst_IHP_SRAM_top_ConfigMem.Inst_frame4_bit15.Q
+ VPWR VGND sg13g2_dlhq_1
XFILLER_13_0 VPWR VGND sg13g2_fill_1
XFILLER_103_133 VPWR VGND sg13g2_decap_8
XFILLER_17_117 VPWR VGND sg13g2_fill_1
XFILLER_17_128 VPWR VGND sg13g2_fill_2
Xoutput94 net94 Tile_X0Y0_FrameData_O[23] VPWR VGND sg13g2_buf_1
XFILLER_99_109 VPWR VGND sg13g2_decap_8
Xoutput83 net83 Tile_X0Y0_FrameData_O[13] VPWR VGND sg13g2_buf_1
Xoutput61 net61 A_DIN_SRAM24 VPWR VGND sg13g2_buf_1
Xoutput72 net72 A_DIN_SRAM6 VPWR VGND sg13g2_buf_1
Xoutput50 net50 A_DIN_SRAM14 VPWR VGND sg13g2_buf_1
Xoutput4 net4 A_ADDR_SRAM3 VPWR VGND sg13g2_buf_1
X_1556_ Tile_X0Y0_IHP_SRAM_top.N4BEG_outbuf_10.A net152 VPWR VGND sg13g2_buf_1
X_1625_ Tile_X0Y1_FrameData[14] net221 VPWR VGND sg13g2_buf_1
X_1487_ Tile_X0Y0_FrameData[13] net83 VPWR VGND sg13g2_buf_1
X_0369_ Tile_X0Y0_IHP_SRAM_top.Inst_IHP_SRAM_top_ConfigMem.Inst_frame0_bit28.Q Tile_X0Y0_IHP_SRAM_top.Inst_IHP_SRAM_top_ConfigMem.Inst_frame0_bit29.Q
+ Tile_X0Y0_IHP_SRAM_top.Inst_IHP_SRAM_top_switch_matrix.N1END2 _0065_ VPWR VGND sg13g2_nor3_1
X_0507_ Tile_X0Y0_IHP_SRAM_top.Inst_IHP_SRAM_top_ConfigMem.Inst_frame3_bit26.Q Tile_X0Y0_E1END[2]
+ Tile_X0Y0_EE4END[6] Tile_X0Y0_EE4END[14] Tile_X0Y0_IHP_SRAM_top.Inst_IHP_SRAM_top_switch_matrix.J_NS4_BEG14
+ Tile_X0Y0_IHP_SRAM_top.Inst_IHP_SRAM_top_ConfigMem.Inst_frame3_bit27.Q net68 VPWR
+ VGND sg13g2_mux4_1
X_0438_ Tile_X0Y0_IHP_SRAM_top.Inst_IHP_SRAM_top_ConfigMem.Inst_frame6_bit10.Q A_DOUT_SRAM18
+ A_DOUT_SRAM26 Tile_X0Y0_IHP_SRAM_top.Inst_IHP_SRAM_top_switch_matrix.J_NS2_BEG2
+ Tile_X0Y0_IHP_SRAM_top.Inst_IHP_SRAM_top_switch_matrix.J_NS2_BEG5 Tile_X0Y0_IHP_SRAM_top.Inst_IHP_SRAM_top_ConfigMem.Inst_frame6_bit11.Q
+ Tile_X0Y0_IHP_SRAM_top.Inst_IHP_SRAM_top_switch_matrix.W2BEG2 VPWR VGND sg13g2_mux4_1
XFILLER_89_197 VPWR VGND sg13g2_fill_1
XFILLER_77_68 VPWR VGND sg13g2_fill_2
XFILLER_93_67 VPWR VGND sg13g2_fill_2
X_1410_ Tile_X0Y1_FrameData[6] Tile_X0Y1_FrameStrobe[7] Tile_X0Y1_IHP_SRAM_bot.Inst_IHP_SRAM_bot_ConfigMem.Inst_frame7_bit6.Q
+ VPWR VGND sg13g2_dlhq_1
X_1341_ Tile_X0Y1_FrameData[11] Tile_X0Y1_FrameStrobe[5] Tile_X0Y1_IHP_SRAM_bot.Inst_IHP_SRAM_bot_ConfigMem.Inst_frame5_bit11.Q
+ VPWR VGND sg13g2_dlhq_1
XFILLER_3_76 VPWR VGND sg13g2_fill_2
X_1272_ Tile_X0Y1_FrameData[16] Tile_X0Y1_FrameStrobe[3] Tile_X0Y1_IHP_SRAM_bot.Inst_IHP_SRAM_bot_ConfigMem.Inst_frame3_bit16.Q
+ VPWR VGND sg13g2_dlhq_1
XFILLER_51_215 VPWR VGND sg13g2_fill_1
X_0987_ Tile_X0Y0_FrameData[3] Tile_X0Y1_FrameStrobe[3] Tile_X0Y0_IHP_SRAM_top.Inst_IHP_SRAM_top_ConfigMem.Inst_frame3_bit3.Q
+ VPWR VGND sg13g2_dlhq_1
X_1539_ Tile_X0Y0_IHP_SRAM_top.Inst_IHP_SRAM_top_switch_matrix.N2BEGb1 net144 VPWR
+ VGND sg13g2_buf_1
X_1608_ Tile_X0Y0_IHP_SRAM_top.Inst_IHP_SRAM_top_switch_matrix.WW4BEG13 net204 VPWR
+ VGND sg13g2_buf_1
XFILLER_47_27 VPWR VGND sg13g2_decap_4
XFILLER_42_215 VPWR VGND sg13g2_fill_1
XFILLER_92_115 VPWR VGND sg13g2_fill_1
XFILLER_92_104 VPWR VGND sg13g2_decap_8
XFILLER_88_67 VPWR VGND sg13g2_decap_8
X_0910_ Tile_X0Y0_FrameData[16] Tile_X0Y1_FrameStrobe[1] Tile_X0Y0_IHP_SRAM_top.Inst_IHP_SRAM_top_ConfigMem.Inst_frame1_bit16.Q
+ VPWR VGND sg13g2_dlhq_1
X_0841_ VPWR VGND Tile_X0Y1_IHP_SRAM_bot.Inst_IHP_SRAM_bot_ConfigMem.Inst_frame2_bit29.Q
+ _0276_ _0275_ _0002_ _0277_ Tile_X0Y1_IHP_SRAM_bot.Inst_IHP_SRAM_bot_ConfigMem.Inst_frame2_bit30.Q
+ sg13g2_a221oi_1
X_0772_ Tile_X0Y1_IHP_SRAM_bot.Inst_IHP_SRAM_bot_ConfigMem.Inst_frame8_bit12.Q VPWR
+ _0213_ VGND Tile_X0Y1_IHP_SRAM_bot.Inst_IHP_SRAM_bot_ConfigMem.Inst_frame8_bit11.Q
+ Tile_X0Y1_IHP_SRAM_bot.Inst_IHP_SRAM_bot_switch_matrix.J_NS4_BEG15 sg13g2_o21ai_1
X_1255_ Tile_X0Y1_FrameData[1] Tile_X0Y1_FrameStrobe[2] Tile_X0Y1_IHP_SRAM_bot.Inst_IHP_SRAM_bot_ConfigMem.Inst_frame2_bit1.Q
+ VPWR VGND sg13g2_dlhq_1
X_1324_ Tile_X0Y1_FrameData[28] Tile_X0Y1_FrameStrobe[5] Tile_X0Y1_IHP_SRAM_bot.Inst_IHP_SRAM_bot_ConfigMem.Inst_frame5_bit28.Q
+ VPWR VGND sg13g2_dlhq_1
X_1186_ Tile_X0Y1_FrameData[6] Tile_X0Y1_FrameStrobe[0] Tile_X0Y1_IHP_SRAM_bot.Inst_IHP_SRAM_bot_ConfigMem.Inst_frame0_bit6.Q
+ VPWR VGND sg13g2_dlhq_1
XFILLER_24_215 VPWR VGND sg13g2_fill_1
XFILLER_3_119 VPWR VGND sg13g2_fill_1
Xoutput240 net240 Tile_X0Y1_FrameData_O[31] VPWR VGND sg13g2_buf_1
XFILLER_59_156 VPWR VGND sg13g2_fill_2
Xoutput295 net295 Tile_X0Y1_W2BEG[7] VPWR VGND sg13g2_buf_1
Xoutput251 net251 Tile_X0Y1_S1BEG[3] VPWR VGND sg13g2_buf_1
Xoutput262 net262 Tile_X0Y1_S2BEGb[2] VPWR VGND sg13g2_buf_1
Xoutput273 net273 Tile_X0Y1_S4BEG[14] VPWR VGND sg13g2_buf_1
Xoutput284 net284 Tile_X0Y1_W1BEG[0] VPWR VGND sg13g2_buf_1
XFILLER_99_22 VPWR VGND sg13g2_fill_2
XFILLER_23_95 VPWR VGND sg13g2_decap_4
X_1040_ Tile_X0Y0_FrameData[14] Tile_X0Y1_FrameStrobe[5] Tile_X0Y0_IHP_SRAM_top.Inst_IHP_SRAM_top_ConfigMem.Inst_frame5_bit14.Q
+ VPWR VGND sg13g2_dlhq_1
XFILLER_24_8 VPWR VGND sg13g2_decap_4
XFILLER_73_192 VPWR VGND sg13g2_fill_2
X_0755_ Tile_X0Y1_IHP_SRAM_bot.Inst_IHP_SRAM_bot_ConfigMem.Inst_frame8_bit9.Q VPWR
+ _0197_ VGND Tile_X0Y1_E6END[10] Tile_X0Y1_IHP_SRAM_bot.Inst_IHP_SRAM_bot_ConfigMem.Inst_frame8_bit8.Q
+ sg13g2_o21ai_1
X_0824_ VGND VPWR _0260_ Tile_X0Y1_IHP_SRAM_bot.Inst_IHP_SRAM_bot_ConfigMem.Inst_frame2_bit30.Q
+ Tile_X0Y1_IHP_SRAM_bot.Inst_IHP_SRAM_bot_ConfigMem.Inst_frame2_bit29.Q sg13g2_or2_1
X_0686_ Tile_X0Y1_IHP_SRAM_bot.Inst_IHP_SRAM_bot_ConfigMem.Inst_frame4_bit20.Q Tile_X0Y1_E2MID[1]
+ _0166_ VPWR VGND sg13g2_nor2b_1
XFILLER_43_0 VPWR VGND sg13g2_decap_8
X_1169_ Tile_X0Y1_FrameData[23] Tile_X0Y1_FrameStrobe[0] Tile_X0Y1_IHP_SRAM_bot.Inst_IHP_SRAM_bot_ConfigMem.Inst_frame0_bit23.Q
+ VPWR VGND sg13g2_dlhq_1
X_1307_ Tile_X0Y1_FrameData[13] Tile_X0Y1_FrameStrobe[4] Tile_X0Y1_IHP_SRAM_bot.Inst_IHP_SRAM_bot_ConfigMem.Inst_frame4_bit13.Q
+ VPWR VGND sg13g2_dlhq_1
X_1238_ Tile_X0Y1_FrameData[18] Tile_X0Y1_FrameStrobe[2] Tile_X0Y1_IHP_SRAM_bot.Inst_IHP_SRAM_bot_ConfigMem.Inst_frame2_bit18.Q
+ VPWR VGND sg13g2_dlhq_1
XFILLER_109_87 VPWR VGND sg13g2_decap_8
XFILLER_18_51 VPWR VGND sg13g2_fill_2
XFILLER_55_170 VPWR VGND sg13g2_decap_4
XFILLER_55_192 VPWR VGND sg13g2_decap_8
XFILLER_109_172 VPWR VGND sg13g2_decap_8
X_0540_ Tile_X0Y0_IHP_SRAM_top.Inst_IHP_SRAM_top_switch_matrix.J_NS4_BEG4 Tile_X0Y0_IHP_SRAM_top.Inst_IHP_SRAM_top_switch_matrix.J_NS4_BEG8
+ Tile_X0Y0_IHP_SRAM_top.Inst_IHP_SRAM_top_ConfigMem.Inst_frame8_bit14.Q _0102_ VPWR
+ VGND sg13g2_mux2_1
X_0471_ Tile_X0Y0_IHP_SRAM_top.Inst_IHP_SRAM_top_ConfigMem.Inst_frame1_bit16.Q Tile_X0Y0_IHP_SRAM_top.Inst_IHP_SRAM_top_switch_matrix.N1END0
+ Tile_X0Y1_N4END[4] Tile_X0Y0_S1END[0] Tile_X0Y0_S4END[0] Tile_X0Y0_IHP_SRAM_top.Inst_IHP_SRAM_top_ConfigMem.Inst_frame1_bit17.Q
+ Tile_X0Y0_IHP_SRAM_top.Inst_IHP_SRAM_top_switch_matrix.J_NS4_BEG4 VPWR VGND sg13g2_mux4_1
X_1023_ Tile_X0Y0_FrameData[31] Tile_X0Y1_FrameStrobe[5] Tile_X0Y0_IHP_SRAM_top.Inst_IHP_SRAM_top_ConfigMem.Inst_frame5_bit31.Q
+ VPWR VGND sg13g2_dlhq_1
XFILLER_53_118 VPWR VGND sg13g2_decap_8
XFILLER_107_109 VPWR VGND sg13g2_decap_8
X_0738_ _0019_ _0043_ _0182_ VPWR VGND sg13g2_nor2_1
X_0807_ Tile_X0Y1_IHP_SRAM_bot.Inst_IHP_SRAM_bot_ConfigMem.Inst_frame7_bit14.Q VPWR
+ _0245_ VGND _0242_ _0243_ sg13g2_o21ai_1
X_0669_ Tile_X0Y1_IHP_SRAM_bot.Inst_IHP_SRAM_bot_ConfigMem.Inst_frame5_bit26.Q Tile_X0Y1_N4END[0]
+ Tile_X0Y0_S4END[4] Tile_X0Y1_IHP_SRAM_bot.Inst_IHP_SRAM_bot_switch_matrix.J_NS4_BEG11
+ Tile_X0Y1_IHP_SRAM_bot.Inst_IHP_SRAM_bot_switch_matrix.J_NS4_BEG15 Tile_X0Y1_IHP_SRAM_bot.Inst_IHP_SRAM_bot_ConfigMem.Inst_frame5_bit27.Q
+ Tile_X0Y1_IHP_SRAM_bot.Inst_IHP_SRAM_bot_switch_matrix.W6BEG0 VPWR VGND sg13g2_mux4_1
XFILLER_39_39 VPWR VGND sg13g2_fill_2
XFILLER_52_140 VPWR VGND sg13g2_fill_1
XFILLER_52_162 VPWR VGND sg13g2_decap_8
XFILLER_106_186 VPWR VGND sg13g2_decap_8
XFILLER_20_85 VPWR VGND sg13g2_decap_4
X_1572_ Tile_X0Y0_IHP_SRAM_top.Inst_IHP_SRAM_top_switch_matrix.W2BEG5 net177 VPWR
+ VGND sg13g2_buf_1
X_1710_ Tile_X0Y1_IHP_SRAM_bot.Inst_IHP_SRAM_bot_switch_matrix.W6BEG11 net306 VPWR
+ VGND sg13g2_buf_1
X_1641_ Tile_X0Y1_FrameData[30] net239 VPWR VGND sg13g2_buf_1
XANTENNA_3 VPWR VGND A_DOUT_SRAM18 sg13g2_antennanp
XFILLER_66_210 VPWR VGND sg13g2_fill_2
X_0454_ Tile_X0Y0_IHP_SRAM_top.Inst_IHP_SRAM_top_ConfigMem.Inst_frame5_bit10.Q A_DOUT_SRAM18
+ A_DOUT_SRAM30 Tile_X0Y0_IHP_SRAM_top.Inst_IHP_SRAM_top_switch_matrix.J_NS4_BEG13
+ Tile_X0Y0_IHP_SRAM_top.Inst_IHP_SRAM_top_switch_matrix.J_NS2_BEG5 Tile_X0Y0_IHP_SRAM_top.Inst_IHP_SRAM_top_ConfigMem.Inst_frame5_bit11.Q
+ Tile_X0Y0_IHP_SRAM_top.Inst_IHP_SRAM_top_switch_matrix.WW4BEG2 VPWR VGND sg13g2_mux4_1
X_0523_ Tile_X0Y0_IHP_SRAM_top.Inst_IHP_SRAM_top_ConfigMem.Inst_frame2_bit26.Q Tile_X0Y0_E1END[2]
+ Tile_X0Y0_EE4END[6] Tile_X0Y0_EE4END[14] Tile_X0Y0_IHP_SRAM_top.Inst_IHP_SRAM_top_switch_matrix.J_NS4_BEG14
+ Tile_X0Y0_IHP_SRAM_top.Inst_IHP_SRAM_top_ConfigMem.Inst_frame2_bit27.Q net35 VPWR
+ VGND sg13g2_mux4_1
X_0385_ Tile_X0Y1_IHP_SRAM_bot.Inst_IHP_SRAM_bot_ConfigMem.Inst_frame9_bit17.Q Tile_X0Y1_E1END[3]
+ Tile_X0Y1_IHP_SRAM_bot.Inst_IHP_SRAM_bot_switch_matrix.J_NS4_BEG15 Tile_X0Y1_E6END[7]
+ _0077_ Tile_X0Y1_IHP_SRAM_bot.Inst_IHP_SRAM_bot_ConfigMem.Inst_frame9_bit16.Q Tile_X0Y0_IHP_SRAM_top.Inst_IHP_SRAM_top_switch_matrix.N1END3
+ VPWR VGND sg13g2_mux4_1
X_1006_ Tile_X0Y0_FrameData[16] Tile_X0Y1_FrameStrobe[4] Tile_X0Y0_IHP_SRAM_top.Inst_IHP_SRAM_top_ConfigMem.Inst_frame4_bit16.Q
+ VPWR VGND sg13g2_dlhq_1
XFILLER_26_129 VPWR VGND sg13g2_fill_2
XFILLER_1_206 VPWR VGND sg13g2_decap_8
XFILLER_106_88 VPWR VGND sg13g2_decap_8
XFILLER_103_189 VPWR VGND sg13g2_decap_8
XFILLER_40_132 VPWR VGND sg13g2_fill_2
XFILLER_110_0 VPWR VGND sg13g2_fill_1
Xoutput5 net5 A_ADDR_SRAM4 VPWR VGND sg13g2_buf_1
Xoutput95 net95 Tile_X0Y0_FrameData_O[24] VPWR VGND sg13g2_buf_1
Xoutput84 net84 Tile_X0Y0_FrameData_O[14] VPWR VGND sg13g2_buf_1
Xoutput51 net51 A_DIN_SRAM15 VPWR VGND sg13g2_buf_1
Xoutput73 net73 A_DIN_SRAM7 VPWR VGND sg13g2_buf_1
Xoutput62 net62 A_DIN_SRAM25 VPWR VGND sg13g2_buf_1
Xoutput40 net40 A_BM_SRAM7 VPWR VGND sg13g2_buf_1
XFILLER_82_4 VPWR VGND sg13g2_fill_2
X_1555_ Tile_X0Y0_IHP_SRAM_top.N4BEG_outbuf_9.A net166 VPWR VGND sg13g2_buf_1
X_0506_ Tile_X0Y0_IHP_SRAM_top.Inst_IHP_SRAM_top_ConfigMem.Inst_frame3_bit24.Q Tile_X0Y0_E1END[1]
+ Tile_X0Y0_EE4END[5] Tile_X0Y0_EE4END[13] Tile_X0Y0_IHP_SRAM_top.Inst_IHP_SRAM_top_switch_matrix.J_NS4_BEG13
+ Tile_X0Y0_IHP_SRAM_top.Inst_IHP_SRAM_top_ConfigMem.Inst_frame3_bit25.Q net66 VPWR
+ VGND sg13g2_mux4_1
X_1624_ Tile_X0Y1_FrameData[13] net220 VPWR VGND sg13g2_buf_1
X_1486_ Tile_X0Y0_FrameData[12] net82 VPWR VGND sg13g2_buf_1
X_0368_ _0064_ Tile_X0Y0_S1END[2] Tile_X0Y0_IHP_SRAM_top.Inst_IHP_SRAM_top_ConfigMem.Inst_frame0_bit28.Q
+ VPWR VGND sg13g2_nand2b_1
XFILLER_39_210 VPWR VGND sg13g2_fill_2
X_0437_ Tile_X0Y0_IHP_SRAM_top.Inst_IHP_SRAM_top_ConfigMem.Inst_frame6_bit8.Q A_DOUT_SRAM17
+ A_DOUT_SRAM25 Tile_X0Y0_IHP_SRAM_top.Inst_IHP_SRAM_top_switch_matrix.J_NS2_BEG1
+ Tile_X0Y0_IHP_SRAM_top.Inst_IHP_SRAM_top_switch_matrix.J_NS2_BEG6 Tile_X0Y0_IHP_SRAM_top.Inst_IHP_SRAM_top_ConfigMem.Inst_frame6_bit9.Q
+ Tile_X0Y0_IHP_SRAM_top.Inst_IHP_SRAM_top_switch_matrix.W2BEG1 VPWR VGND sg13g2_mux4_1
X_0299_ VPWR _0002_ Tile_X0Y0_S2MID[2] VGND sg13g2_inv_1
XFILLER_89_121 VPWR VGND sg13g2_decap_8
XFILLER_45_213 VPWR VGND sg13g2_fill_2
XFILLER_9_169 VPWR VGND sg13g2_fill_2
X_1340_ Tile_X0Y1_FrameData[12] Tile_X0Y1_FrameStrobe[5] Tile_X0Y1_IHP_SRAM_bot.Inst_IHP_SRAM_bot_ConfigMem.Inst_frame5_bit12.Q
+ VPWR VGND sg13g2_dlhq_1
X_1271_ Tile_X0Y1_FrameData[17] Tile_X0Y1_FrameStrobe[3] Tile_X0Y1_IHP_SRAM_bot.Inst_IHP_SRAM_bot_ConfigMem.Inst_frame3_bit17.Q
+ VPWR VGND sg13g2_dlhq_1
XFILLER_36_213 VPWR VGND sg13g2_fill_2
Xclkbuf_0_Tile_X0Y1_UserCLK Tile_X0Y1_UserCLK clknet_0_Tile_X0Y1_UserCLK VPWR VGND
+ sg13g2_buf_8
X_0986_ Tile_X0Y0_FrameData[4] Tile_X0Y1_FrameStrobe[3] Tile_X0Y0_IHP_SRAM_top.Inst_IHP_SRAM_top_ConfigMem.Inst_frame3_bit4.Q
+ VPWR VGND sg13g2_dlhq_1
X_1538_ Tile_X0Y0_IHP_SRAM_top.Inst_IHP_SRAM_top_switch_matrix.N2BEGb0 net143 VPWR
+ VGND sg13g2_buf_1
X_1607_ Tile_X0Y0_IHP_SRAM_top.Inst_IHP_SRAM_top_switch_matrix.WW4BEG12 net203 VPWR
+ VGND sg13g2_buf_1
X_1469_ Tile_X0Y1_FrameData[11] Tile_X0Y1_FrameStrobe[9] Tile_X0Y1_IHP_SRAM_bot.Inst_IHP_SRAM_bot_ConfigMem.Inst_frame9_bit11.Q
+ VPWR VGND sg13g2_dlhq_1
XFILLER_12_42 VPWR VGND sg13g2_fill_2
X_0840_ Tile_X0Y1_E2END[3] Tile_X0Y1_IHP_SRAM_bot.Inst_IHP_SRAM_bot_ConfigMem.Inst_frame2_bit29.Q
+ Tile_X0Y1_IHP_SRAM_bot.Inst_IHP_SRAM_bot_ConfigMem.Inst_frame2_bit30.Q _0276_ VPWR
+ VGND sg13g2_nor3_1
X_0771_ _0025_ _0080_ _0212_ VPWR VGND sg13g2_nor2_1
XFILLER_110_210 VPWR VGND sg13g2_fill_2
X_1323_ Tile_X0Y1_FrameData[29] Tile_X0Y1_FrameStrobe[5] Tile_X0Y1_IHP_SRAM_bot.Inst_IHP_SRAM_bot_ConfigMem.Inst_frame5_bit29.Q
+ VPWR VGND sg13g2_dlhq_1
X_1254_ Tile_X0Y1_FrameData[2] Tile_X0Y1_FrameStrobe[2] Tile_X0Y1_IHP_SRAM_bot.Inst_IHP_SRAM_bot_ConfigMem.Inst_frame2_bit2.Q
+ VPWR VGND sg13g2_dlhq_1
X_1185_ Tile_X0Y1_FrameData[7] Tile_X0Y1_FrameStrobe[0] Tile_X0Y1_IHP_SRAM_bot.Inst_IHP_SRAM_bot_ConfigMem.Inst_frame0_bit7.Q
+ VPWR VGND sg13g2_dlhq_1
X_0969_ Tile_X0Y0_FrameData[21] Tile_X0Y1_FrameStrobe[3] Tile_X0Y0_IHP_SRAM_top.Inst_IHP_SRAM_top_ConfigMem.Inst_frame3_bit21.Q
+ VPWR VGND sg13g2_dlhq_1
Xoutput230 net230 Tile_X0Y1_FrameData_O[22] VPWR VGND sg13g2_buf_1
Xoutput252 net252 Tile_X0Y1_S2BEG[0] VPWR VGND sg13g2_buf_1
Xoutput241 net241 Tile_X0Y1_FrameData_O[3] VPWR VGND sg13g2_buf_1
XFILLER_59_113 VPWR VGND sg13g2_decap_8
Xoutput296 net296 Tile_X0Y1_W2BEGb[0] VPWR VGND sg13g2_buf_1
Xoutput263 net263 Tile_X0Y1_S2BEGb[3] VPWR VGND sg13g2_buf_1
Xoutput274 net274 Tile_X0Y1_S4BEG[15] VPWR VGND sg13g2_buf_1
Xoutput285 net285 Tile_X0Y1_W1BEG[1] VPWR VGND sg13g2_buf_1
XFILLER_3_0 VPWR VGND sg13g2_fill_2
X_0685_ Tile_X0Y1_IHP_SRAM_bot.Inst_IHP_SRAM_bot_ConfigMem.Inst_frame4_bit21.Q _0078_
+ _0165_ VPWR VGND Tile_X0Y1_IHP_SRAM_bot.Inst_IHP_SRAM_bot_ConfigMem.Inst_frame4_bit20.Q
+ sg13g2_nand3b_1
X_0823_ _0259_ Tile_X0Y1_N2END[2] Tile_X0Y1_IHP_SRAM_bot.Inst_IHP_SRAM_bot_ConfigMem.Inst_frame2_bit28.Q
+ VPWR VGND sg13g2_nand2_1
X_0754_ VGND VPWR _0189_ _0191_ Tile_X0Y0_IHP_SRAM_top.N4BEG_outbuf_9.A _0196_ sg13g2_a21oi_1
XFILLER_88_208 VPWR VGND sg13g2_decap_4
X_1306_ Tile_X0Y1_FrameData[14] Tile_X0Y1_FrameStrobe[4] Tile_X0Y1_IHP_SRAM_bot.Inst_IHP_SRAM_bot_ConfigMem.Inst_frame4_bit14.Q
+ VPWR VGND sg13g2_dlhq_1
X_1099_ Tile_X0Y0_FrameData[19] Tile_X0Y1_FrameStrobe[7] Tile_X0Y0_IHP_SRAM_top.Inst_IHP_SRAM_top_ConfigMem.Inst_frame7_bit19.Q
+ VPWR VGND sg13g2_dlhq_1
XFILLER_64_182 VPWR VGND sg13g2_decap_8
X_1168_ Tile_X0Y1_FrameData[24] Tile_X0Y1_FrameStrobe[0] Tile_X0Y1_IHP_SRAM_bot.Inst_IHP_SRAM_bot_ConfigMem.Inst_frame0_bit24.Q
+ VPWR VGND sg13g2_dlhq_1
XFILLER_44_18 VPWR VGND sg13g2_fill_2
X_1237_ Tile_X0Y1_FrameData[19] Tile_X0Y1_FrameStrobe[2] Tile_X0Y1_IHP_SRAM_bot.Inst_IHP_SRAM_bot_ConfigMem.Inst_frame2_bit19.Q
+ VPWR VGND sg13g2_dlhq_1
XFILLER_85_69 VPWR VGND sg13g2_decap_4
XFILLER_85_25 VPWR VGND sg13g2_fill_2
XFILLER_47_149 VPWR VGND sg13g2_fill_2
XFILLER_109_151 VPWR VGND sg13g2_decap_8
XFILLER_50_83 VPWR VGND sg13g2_fill_2
XFILLER_93_211 VPWR VGND sg13g2_fill_1
X_0470_ Tile_X0Y0_IHP_SRAM_top.Inst_IHP_SRAM_top_ConfigMem.Inst_frame5_bit26.Q A_DOUT_SRAM22
+ A_DOUT_SRAM26 Tile_X0Y0_IHP_SRAM_top.Inst_IHP_SRAM_top_switch_matrix.J_NS4_BEG5
+ Tile_X0Y0_IHP_SRAM_top.Inst_IHP_SRAM_top_switch_matrix.J_NS2_BEG5 Tile_X0Y0_IHP_SRAM_top.Inst_IHP_SRAM_top_ConfigMem.Inst_frame5_bit27.Q
+ Tile_X0Y0_IHP_SRAM_top.Inst_IHP_SRAM_top_switch_matrix.WW4BEG10 VPWR VGND sg13g2_mux4_1
X_1022_ Tile_X0Y0_FrameData[0] Tile_X0Y1_FrameStrobe[4] Tile_X0Y0_IHP_SRAM_top.Inst_IHP_SRAM_top_ConfigMem.Inst_frame4_bit0.Q
+ VPWR VGND sg13g2_dlhq_1
XFILLER_61_130 VPWR VGND sg13g2_decap_4
X_0668_ Tile_X0Y1_IHP_SRAM_bot.Inst_IHP_SRAM_bot_ConfigMem.Inst_frame5_bit24.Q A_DOUT_SRAM3
+ A_DOUT_SRAM15 _0161_ _0043_ Tile_X0Y1_IHP_SRAM_bot.Inst_IHP_SRAM_bot_ConfigMem.Inst_frame5_bit25.Q
+ Tile_X0Y1_IHP_SRAM_bot.Inst_IHP_SRAM_bot_switch_matrix.WW4BEG15 VPWR VGND sg13g2_mux4_1
X_0737_ VGND VPWR _0020_ _0180_ _0181_ Tile_X0Y1_IHP_SRAM_bot.Inst_IHP_SRAM_bot_ConfigMem.Inst_frame8_bit4.Q
+ sg13g2_a21oi_1
X_0806_ Tile_X0Y1_IHP_SRAM_bot.Inst_IHP_SRAM_bot_switch_matrix.J_NS4_BEG6 Tile_X0Y1_IHP_SRAM_bot.Inst_IHP_SRAM_bot_switch_matrix.J_NS4_BEG10
+ Tile_X0Y1_IHP_SRAM_bot.Inst_IHP_SRAM_bot_ConfigMem.Inst_frame7_bit12.Q _0244_ VPWR
+ VGND sg13g2_mux2_1
XFILLER_39_18 VPWR VGND sg13g2_fill_1
X_0599_ Tile_X0Y0_IHP_SRAM_top.Inst_IHP_SRAM_top_ConfigMem.Inst_frame7_bit29.Q VPWR
+ _0154_ VGND _0152_ _0153_ sg13g2_o21ai_1
XFILLER_84_200 VPWR VGND sg13g2_decap_4
XFILLER_29_127 VPWR VGND sg13g2_fill_1
XFILLER_111_89 VPWR VGND sg13g2_decap_8
XFILLER_106_165 VPWR VGND sg13g2_decap_8
XFILLER_29_95 VPWR VGND sg13g2_decap_4
XFILLER_43_152 VPWR VGND sg13g2_decap_4
X_1640_ Tile_X0Y1_FrameData[29] net237 VPWR VGND sg13g2_buf_1
X_0522_ Tile_X0Y0_IHP_SRAM_top.Inst_IHP_SRAM_top_ConfigMem.Inst_frame2_bit24.Q Tile_X0Y0_E1END[1]
+ Tile_X0Y0_EE4END[5] Tile_X0Y0_EE4END[13] Tile_X0Y0_IHP_SRAM_top.Inst_IHP_SRAM_top_switch_matrix.J_NS4_BEG13
+ Tile_X0Y0_IHP_SRAM_top.Inst_IHP_SRAM_top_ConfigMem.Inst_frame2_bit25.Q net33 VPWR
+ VGND sg13g2_mux4_1
X_1571_ Tile_X0Y0_IHP_SRAM_top.Inst_IHP_SRAM_top_switch_matrix.W2BEG4 net176 VPWR
+ VGND sg13g2_buf_1
XANTENNA_4 VPWR VGND A_DOUT_SRAM18 sg13g2_antennanp
X_0453_ Tile_X0Y0_IHP_SRAM_top.Inst_IHP_SRAM_top_ConfigMem.Inst_frame5_bit8.Q A_DOUT_SRAM17
+ A_DOUT_SRAM29 Tile_X0Y0_IHP_SRAM_top.Inst_IHP_SRAM_top_switch_matrix.J_NS4_BEG14
+ Tile_X0Y0_IHP_SRAM_top.Inst_IHP_SRAM_top_switch_matrix.J_NS2_BEG6 Tile_X0Y0_IHP_SRAM_top.Inst_IHP_SRAM_top_ConfigMem.Inst_frame5_bit9.Q
+ Tile_X0Y0_IHP_SRAM_top.Inst_IHP_SRAM_top_switch_matrix.WW4BEG1 VPWR VGND sg13g2_mux4_1
X_0384_ VPWR VGND _0076_ _0075_ Tile_X0Y1_IHP_SRAM_bot.Inst_IHP_SRAM_bot_ConfigMem.Inst_frame0_bit31.Q
+ _0007_ _0077_ Tile_X0Y1_IHP_SRAM_bot.Inst_IHP_SRAM_bot_ConfigMem.Inst_frame0_bit30.Q
+ sg13g2_a221oi_1
X_1005_ Tile_X0Y0_FrameData[17] Tile_X0Y1_FrameStrobe[4] Tile_X0Y0_IHP_SRAM_top.Inst_IHP_SRAM_top_ConfigMem.Inst_frame4_bit17.Q
+ VPWR VGND sg13g2_dlhq_1
XFILLER_106_67 VPWR VGND sg13g2_decap_8
XFILLER_103_168 VPWR VGND sg13g2_decap_8
XFILLER_66_38 VPWR VGND sg13g2_fill_2
XFILLER_40_177 VPWR VGND sg13g2_fill_2
XFILLER_40_188 VPWR VGND sg13g2_fill_1
XFILLER_103_0 VPWR VGND sg13g2_decap_8
Xoutput52 net52 A_DIN_SRAM16 VPWR VGND sg13g2_buf_1
Xoutput6 net6 A_ADDR_SRAM5 VPWR VGND sg13g2_buf_1
Xoutput41 net41 A_BM_SRAM8 VPWR VGND sg13g2_buf_1
Xoutput30 net30 A_BM_SRAM26 VPWR VGND sg13g2_buf_1
Xoutput96 net96 Tile_X0Y0_FrameData_O[25] VPWR VGND sg13g2_buf_1
Xoutput85 net85 Tile_X0Y0_FrameData_O[15] VPWR VGND sg13g2_buf_1
Xoutput74 net74 A_DIN_SRAM8 VPWR VGND sg13g2_buf_1
Xoutput63 net63 A_DIN_SRAM26 VPWR VGND sg13g2_buf_1
XFILLER_72_81 VPWR VGND sg13g2_decap_8
XFILLER_31_166 VPWR VGND sg13g2_fill_2
X_1554_ Tile_X0Y0_IHP_SRAM_top.N4BEG_outbuf_8.A net165 VPWR VGND sg13g2_buf_1
XFILLER_98_144 VPWR VGND sg13g2_fill_1
X_1485_ Tile_X0Y0_FrameData[11] net81 VPWR VGND sg13g2_buf_1
X_0436_ Tile_X0Y0_IHP_SRAM_top.Inst_IHP_SRAM_top_ConfigMem.Inst_frame6_bit6.Q A_DOUT_SRAM16
+ A_DOUT_SRAM24 Tile_X0Y0_IHP_SRAM_top.Inst_IHP_SRAM_top_switch_matrix.J_NS2_BEG0
+ Tile_X0Y0_IHP_SRAM_top.Inst_IHP_SRAM_top_switch_matrix.J_NS2_BEG7 Tile_X0Y0_IHP_SRAM_top.Inst_IHP_SRAM_top_ConfigMem.Inst_frame6_bit7.Q
+ Tile_X0Y0_IHP_SRAM_top.Inst_IHP_SRAM_top_switch_matrix.W2BEG0 VPWR VGND sg13g2_mux4_1
X_0505_ Tile_X0Y0_IHP_SRAM_top.Inst_IHP_SRAM_top_ConfigMem.Inst_frame3_bit22.Q Tile_X0Y0_E1END[0]
+ Tile_X0Y0_EE4END[4] Tile_X0Y0_EE4END[12] Tile_X0Y0_IHP_SRAM_top.Inst_IHP_SRAM_top_switch_matrix.J_NS4_BEG12
+ Tile_X0Y0_IHP_SRAM_top.Inst_IHP_SRAM_top_ConfigMem.Inst_frame3_bit23.Q net65 VPWR
+ VGND sg13g2_mux4_1
X_1623_ Tile_X0Y1_FrameData[12] net219 VPWR VGND sg13g2_buf_1
.ends
