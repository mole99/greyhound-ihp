* NGSPICE file created from S_OBI.ext - technology: ihp-sg13g2

* Black-box entry subcircuit for sg13g2_mux2_1 abstract view
.subckt sg13g2_mux2_1 A0 A1 S X VDD VSS
.ends

* Black-box entry subcircuit for sg13g2_o21ai_1 abstract view
.subckt sg13g2_o21ai_1 B1 VDD Y VSS A1 A2
.ends

* Black-box entry subcircuit for sg13g2_decap_8 abstract view
.subckt sg13g2_decap_8 VDD VSS
.ends

* Black-box entry subcircuit for sg13g2_fill_2 abstract view
.subckt sg13g2_fill_2 VDD VSS
.ends

* Black-box entry subcircuit for sg13g2_decap_4 abstract view
.subckt sg13g2_decap_4 VDD VSS
.ends

* Black-box entry subcircuit for sg13g2_buf_1 abstract view
.subckt sg13g2_buf_1 A X VDD VSS
.ends

* Black-box entry subcircuit for sg13g2_fill_1 abstract view
.subckt sg13g2_fill_1 VDD VSS
.ends

* Black-box entry subcircuit for sg13g2_dlhq_1 abstract view
.subckt sg13g2_dlhq_1 D GATE Q VDD VSS
.ends

* Black-box entry subcircuit for sg13g2_nor2_1 abstract view
.subckt sg13g2_nor2_1 A B Y VDD VSS
.ends

* Black-box entry subcircuit for sg13g2_nor3_1 abstract view
.subckt sg13g2_nor3_1 A B C Y VDD VSS
.ends

* Black-box entry subcircuit for sg13g2_antennanp abstract view
.subckt sg13g2_antennanp VDD VSS A
.ends

* Black-box entry subcircuit for sg13g2_a21o_1 abstract view
.subckt sg13g2_a21o_1 A2 A1 B1 X VDD VSS
.ends

* Black-box entry subcircuit for sg13g2_nand2b_1 abstract view
.subckt sg13g2_nand2b_1 Y B A_N VDD VSS
.ends

* Black-box entry subcircuit for sg13g2_inv_1 abstract view
.subckt sg13g2_inv_1 VDD Y A VSS
.ends

* Black-box entry subcircuit for sg13g2_a21oi_1 abstract view
.subckt sg13g2_a21oi_1 VSS VDD A1 A2 Y B1
.ends

* Black-box entry subcircuit for sg13g2_nor2b_1 abstract view
.subckt sg13g2_nor2b_1 A B_N Y VDD VSS
.ends

* Black-box entry subcircuit for sg13g2_a221oi_1 abstract view
.subckt sg13g2_a221oi_1 VDD VSS B2 C1 B1 A1 Y A2
.ends

* Black-box entry subcircuit for sg13g2_nand2_1 abstract view
.subckt sg13g2_nand2_1 Y A B VDD VSS
.ends

* Black-box entry subcircuit for sg13g2_mux4_1 abstract view
.subckt sg13g2_mux4_1 S0 A0 A1 A2 A3 S1 X VDD VSS
.ends

* Black-box entry subcircuit for sg13g2_tielo abstract view
.subckt sg13g2_tielo VDD VSS L_LO
.ends

.subckt S_OBI ADDR_top0 ADDR_top1 ADDR_top10 ADDR_top11 ADDR_top12 ADDR_top13 ADDR_top14
+ ADDR_top15 ADDR_top16 ADDR_top17 ADDR_top18 ADDR_top19 ADDR_top2 ADDR_top20 ADDR_top21
+ ADDR_top22 ADDR_top23 ADDR_top3 ADDR_top4 ADDR_top5 ADDR_top6 ADDR_top7 ADDR_top8
+ ADDR_top9 BE_top0 BE_top1 BE_top2 BE_top3 GNT_top RDATA_top0 RDATA_top1 RDATA_top10
+ RDATA_top11 RDATA_top12 RDATA_top13 RDATA_top14 RDATA_top15 RDATA_top16 RDATA_top17
+ RDATA_top18 RDATA_top19 RDATA_top2 RDATA_top20 RDATA_top21 RDATA_top22 RDATA_top23
+ RDATA_top24 RDATA_top25 RDATA_top26 RDATA_top27 RDATA_top28 RDATA_top29 RDATA_top3
+ RDATA_top30 RDATA_top31 RDATA_top4 RDATA_top5 RDATA_top6 RDATA_top7 RDATA_top8 RDATA_top9
+ REQ_top RVALID_top Tile_X0Y0_Co Tile_X0Y0_FrameData[0] Tile_X0Y0_FrameData[10] Tile_X0Y0_FrameData[11]
+ Tile_X0Y0_FrameData[12] Tile_X0Y0_FrameData[13] Tile_X0Y0_FrameData[14] Tile_X0Y0_FrameData[15]
+ Tile_X0Y0_FrameData[16] Tile_X0Y0_FrameData[17] Tile_X0Y0_FrameData[18] Tile_X0Y0_FrameData[19]
+ Tile_X0Y0_FrameData[1] Tile_X0Y0_FrameData[20] Tile_X0Y0_FrameData[21] Tile_X0Y0_FrameData[22]
+ Tile_X0Y0_FrameData[23] Tile_X0Y0_FrameData[24] Tile_X0Y0_FrameData[25] Tile_X0Y0_FrameData[26]
+ Tile_X0Y0_FrameData[27] Tile_X0Y0_FrameData[28] Tile_X0Y0_FrameData[29] Tile_X0Y0_FrameData[2]
+ Tile_X0Y0_FrameData[30] Tile_X0Y0_FrameData[31] Tile_X0Y0_FrameData[3] Tile_X0Y0_FrameData[4]
+ Tile_X0Y0_FrameData[5] Tile_X0Y0_FrameData[6] Tile_X0Y0_FrameData[7] Tile_X0Y0_FrameData[8]
+ Tile_X0Y0_FrameData[9] Tile_X0Y0_FrameStrobe[0] Tile_X0Y0_FrameStrobe[10] Tile_X0Y0_FrameStrobe[11]
+ Tile_X0Y0_FrameStrobe[12] Tile_X0Y0_FrameStrobe[13] Tile_X0Y0_FrameStrobe[14] Tile_X0Y0_FrameStrobe[15]
+ Tile_X0Y0_FrameStrobe[16] Tile_X0Y0_FrameStrobe[17] Tile_X0Y0_FrameStrobe[18] Tile_X0Y0_FrameStrobe[19]
+ Tile_X0Y0_FrameStrobe[1] Tile_X0Y0_FrameStrobe[2] Tile_X0Y0_FrameStrobe[3] Tile_X0Y0_FrameStrobe[4]
+ Tile_X0Y0_FrameStrobe[5] Tile_X0Y0_FrameStrobe[6] Tile_X0Y0_FrameStrobe[7] Tile_X0Y0_FrameStrobe[8]
+ Tile_X0Y0_FrameStrobe[9] Tile_X0Y0_FrameStrobe_O[0] Tile_X0Y0_FrameStrobe_O[10]
+ Tile_X0Y0_FrameStrobe_O[11] Tile_X0Y0_FrameStrobe_O[12] Tile_X0Y0_FrameStrobe_O[13]
+ Tile_X0Y0_FrameStrobe_O[14] Tile_X0Y0_FrameStrobe_O[15] Tile_X0Y0_FrameStrobe_O[16]
+ Tile_X0Y0_FrameStrobe_O[17] Tile_X0Y0_FrameStrobe_O[18] Tile_X0Y0_FrameStrobe_O[19]
+ Tile_X0Y0_FrameStrobe_O[1] Tile_X0Y0_FrameStrobe_O[2] Tile_X0Y0_FrameStrobe_O[3]
+ Tile_X0Y0_FrameStrobe_O[4] Tile_X0Y0_FrameStrobe_O[5] Tile_X0Y0_FrameStrobe_O[6]
+ Tile_X0Y0_FrameStrobe_O[7] Tile_X0Y0_FrameStrobe_O[8] Tile_X0Y0_FrameStrobe_O[9]
+ Tile_X0Y0_N1BEG[0] Tile_X0Y0_N1BEG[1] Tile_X0Y0_N1BEG[2] Tile_X0Y0_N1BEG[3] Tile_X0Y0_N2BEG[0]
+ Tile_X0Y0_N2BEG[1] Tile_X0Y0_N2BEG[2] Tile_X0Y0_N2BEG[3] Tile_X0Y0_N2BEG[4] Tile_X0Y0_N2BEG[5]
+ Tile_X0Y0_N2BEG[6] Tile_X0Y0_N2BEG[7] Tile_X0Y0_N2BEGb[0] Tile_X0Y0_N2BEGb[1] Tile_X0Y0_N2BEGb[2]
+ Tile_X0Y0_N2BEGb[3] Tile_X0Y0_N2BEGb[4] Tile_X0Y0_N2BEGb[5] Tile_X0Y0_N2BEGb[6]
+ Tile_X0Y0_N2BEGb[7] Tile_X0Y0_N4BEG[0] Tile_X0Y0_N4BEG[10] Tile_X0Y0_N4BEG[11] Tile_X0Y0_N4BEG[12]
+ Tile_X0Y0_N4BEG[13] Tile_X0Y0_N4BEG[14] Tile_X0Y0_N4BEG[15] Tile_X0Y0_N4BEG[1] Tile_X0Y0_N4BEG[2]
+ Tile_X0Y0_N4BEG[3] Tile_X0Y0_N4BEG[4] Tile_X0Y0_N4BEG[5] Tile_X0Y0_N4BEG[6] Tile_X0Y0_N4BEG[7]
+ Tile_X0Y0_N4BEG[8] Tile_X0Y0_N4BEG[9] Tile_X0Y0_NN4BEG[0] Tile_X0Y0_NN4BEG[10] Tile_X0Y0_NN4BEG[11]
+ Tile_X0Y0_NN4BEG[12] Tile_X0Y0_NN4BEG[13] Tile_X0Y0_NN4BEG[14] Tile_X0Y0_NN4BEG[15]
+ Tile_X0Y0_NN4BEG[1] Tile_X0Y0_NN4BEG[2] Tile_X0Y0_NN4BEG[3] Tile_X0Y0_NN4BEG[4]
+ Tile_X0Y0_NN4BEG[5] Tile_X0Y0_NN4BEG[6] Tile_X0Y0_NN4BEG[7] Tile_X0Y0_NN4BEG[8]
+ Tile_X0Y0_NN4BEG[9] Tile_X0Y0_S1END[0] Tile_X0Y0_S1END[1] Tile_X0Y0_S1END[2] Tile_X0Y0_S1END[3]
+ Tile_X0Y0_S2END[0] Tile_X0Y0_S2END[1] Tile_X0Y0_S2END[2] Tile_X0Y0_S2END[3] Tile_X0Y0_S2END[4]
+ Tile_X0Y0_S2END[5] Tile_X0Y0_S2END[6] Tile_X0Y0_S2END[7] Tile_X0Y0_S2MID[0] Tile_X0Y0_S2MID[1]
+ Tile_X0Y0_S2MID[2] Tile_X0Y0_S2MID[3] Tile_X0Y0_S2MID[4] Tile_X0Y0_S2MID[5] Tile_X0Y0_S2MID[6]
+ Tile_X0Y0_S2MID[7] Tile_X0Y0_S4END[0] Tile_X0Y0_S4END[10] Tile_X0Y0_S4END[11] Tile_X0Y0_S4END[12]
+ Tile_X0Y0_S4END[13] Tile_X0Y0_S4END[14] Tile_X0Y0_S4END[15] Tile_X0Y0_S4END[1] Tile_X0Y0_S4END[2]
+ Tile_X0Y0_S4END[3] Tile_X0Y0_S4END[4] Tile_X0Y0_S4END[5] Tile_X0Y0_S4END[6] Tile_X0Y0_S4END[7]
+ Tile_X0Y0_S4END[8] Tile_X0Y0_S4END[9] Tile_X0Y0_SS4END[0] Tile_X0Y0_SS4END[10] Tile_X0Y0_SS4END[11]
+ Tile_X0Y0_SS4END[12] Tile_X0Y0_SS4END[13] Tile_X0Y0_SS4END[14] Tile_X0Y0_SS4END[15]
+ Tile_X0Y0_SS4END[1] Tile_X0Y0_SS4END[2] Tile_X0Y0_SS4END[3] Tile_X0Y0_SS4END[4]
+ Tile_X0Y0_SS4END[5] Tile_X0Y0_SS4END[6] Tile_X0Y0_SS4END[7] Tile_X0Y0_SS4END[8]
+ Tile_X0Y0_SS4END[9] Tile_X0Y0_UserCLK Tile_X0Y0_UserCLKo Tile_X1Y0_Co Tile_X1Y0_FrameStrobe[0]
+ Tile_X1Y0_FrameStrobe[10] Tile_X1Y0_FrameStrobe[11] Tile_X1Y0_FrameStrobe[12] Tile_X1Y0_FrameStrobe[13]
+ Tile_X1Y0_FrameStrobe[14] Tile_X1Y0_FrameStrobe[15] Tile_X1Y0_FrameStrobe[16] Tile_X1Y0_FrameStrobe[17]
+ Tile_X1Y0_FrameStrobe[18] Tile_X1Y0_FrameStrobe[19] Tile_X1Y0_FrameStrobe[1] Tile_X1Y0_FrameStrobe[2]
+ Tile_X1Y0_FrameStrobe[3] Tile_X1Y0_FrameStrobe[4] Tile_X1Y0_FrameStrobe[5] Tile_X1Y0_FrameStrobe[6]
+ Tile_X1Y0_FrameStrobe[7] Tile_X1Y0_FrameStrobe[8] Tile_X1Y0_FrameStrobe[9] Tile_X1Y0_FrameStrobe_O[0]
+ Tile_X1Y0_FrameStrobe_O[10] Tile_X1Y0_FrameStrobe_O[11] Tile_X1Y0_FrameStrobe_O[12]
+ Tile_X1Y0_FrameStrobe_O[13] Tile_X1Y0_FrameStrobe_O[14] Tile_X1Y0_FrameStrobe_O[15]
+ Tile_X1Y0_FrameStrobe_O[16] Tile_X1Y0_FrameStrobe_O[17] Tile_X1Y0_FrameStrobe_O[18]
+ Tile_X1Y0_FrameStrobe_O[19] Tile_X1Y0_FrameStrobe_O[1] Tile_X1Y0_FrameStrobe_O[2]
+ Tile_X1Y0_FrameStrobe_O[3] Tile_X1Y0_FrameStrobe_O[4] Tile_X1Y0_FrameStrobe_O[5]
+ Tile_X1Y0_FrameStrobe_O[6] Tile_X1Y0_FrameStrobe_O[7] Tile_X1Y0_FrameStrobe_O[8]
+ Tile_X1Y0_FrameStrobe_O[9] Tile_X1Y0_N1BEG[0] Tile_X1Y0_N1BEG[1] Tile_X1Y0_N1BEG[2]
+ Tile_X1Y0_N1BEG[3] Tile_X1Y0_N2BEG[0] Tile_X1Y0_N2BEG[1] Tile_X1Y0_N2BEG[2] Tile_X1Y0_N2BEG[3]
+ Tile_X1Y0_N2BEG[4] Tile_X1Y0_N2BEG[5] Tile_X1Y0_N2BEG[6] Tile_X1Y0_N2BEG[7] Tile_X1Y0_N2BEGb[0]
+ Tile_X1Y0_N2BEGb[1] Tile_X1Y0_N2BEGb[2] Tile_X1Y0_N2BEGb[3] Tile_X1Y0_N2BEGb[4]
+ Tile_X1Y0_N2BEGb[5] Tile_X1Y0_N2BEGb[6] Tile_X1Y0_N2BEGb[7] Tile_X1Y0_N4BEG[0] Tile_X1Y0_N4BEG[10]
+ Tile_X1Y0_N4BEG[11] Tile_X1Y0_N4BEG[12] Tile_X1Y0_N4BEG[13] Tile_X1Y0_N4BEG[14]
+ Tile_X1Y0_N4BEG[15] Tile_X1Y0_N4BEG[1] Tile_X1Y0_N4BEG[2] Tile_X1Y0_N4BEG[3] Tile_X1Y0_N4BEG[4]
+ Tile_X1Y0_N4BEG[5] Tile_X1Y0_N4BEG[6] Tile_X1Y0_N4BEG[7] Tile_X1Y0_N4BEG[8] Tile_X1Y0_N4BEG[9]
+ Tile_X1Y0_NN4BEG[0] Tile_X1Y0_NN4BEG[10] Tile_X1Y0_NN4BEG[11] Tile_X1Y0_NN4BEG[12]
+ Tile_X1Y0_NN4BEG[13] Tile_X1Y0_NN4BEG[14] Tile_X1Y0_NN4BEG[15] Tile_X1Y0_NN4BEG[1]
+ Tile_X1Y0_NN4BEG[2] Tile_X1Y0_NN4BEG[3] Tile_X1Y0_NN4BEG[4] Tile_X1Y0_NN4BEG[5]
+ Tile_X1Y0_NN4BEG[6] Tile_X1Y0_NN4BEG[7] Tile_X1Y0_NN4BEG[8] Tile_X1Y0_NN4BEG[9]
+ Tile_X1Y0_S1END[0] Tile_X1Y0_S1END[1] Tile_X1Y0_S1END[2] Tile_X1Y0_S1END[3] Tile_X1Y0_S2END[0]
+ Tile_X1Y0_S2END[1] Tile_X1Y0_S2END[2] Tile_X1Y0_S2END[3] Tile_X1Y0_S2END[4] Tile_X1Y0_S2END[5]
+ Tile_X1Y0_S2END[6] Tile_X1Y0_S2END[7] Tile_X1Y0_S2MID[0] Tile_X1Y0_S2MID[1] Tile_X1Y0_S2MID[2]
+ Tile_X1Y0_S2MID[3] Tile_X1Y0_S2MID[4] Tile_X1Y0_S2MID[5] Tile_X1Y0_S2MID[6] Tile_X1Y0_S2MID[7]
+ Tile_X1Y0_S4END[0] Tile_X1Y0_S4END[10] Tile_X1Y0_S4END[11] Tile_X1Y0_S4END[12] Tile_X1Y0_S4END[13]
+ Tile_X1Y0_S4END[14] Tile_X1Y0_S4END[15] Tile_X1Y0_S4END[1] Tile_X1Y0_S4END[2] Tile_X1Y0_S4END[3]
+ Tile_X1Y0_S4END[4] Tile_X1Y0_S4END[5] Tile_X1Y0_S4END[6] Tile_X1Y0_S4END[7] Tile_X1Y0_S4END[8]
+ Tile_X1Y0_S4END[9] Tile_X1Y0_SS4END[0] Tile_X1Y0_SS4END[10] Tile_X1Y0_SS4END[11]
+ Tile_X1Y0_SS4END[12] Tile_X1Y0_SS4END[13] Tile_X1Y0_SS4END[14] Tile_X1Y0_SS4END[15]
+ Tile_X1Y0_SS4END[1] Tile_X1Y0_SS4END[2] Tile_X1Y0_SS4END[3] Tile_X1Y0_SS4END[4]
+ Tile_X1Y0_SS4END[5] Tile_X1Y0_SS4END[6] Tile_X1Y0_SS4END[7] Tile_X1Y0_SS4END[8]
+ Tile_X1Y0_SS4END[9] Tile_X1Y0_UserCLK Tile_X1Y0_UserCLKo Tile_X2Y0_Co Tile_X2Y0_FrameData_O[0]
+ Tile_X2Y0_FrameData_O[10] Tile_X2Y0_FrameData_O[11] Tile_X2Y0_FrameData_O[12] Tile_X2Y0_FrameData_O[13]
+ Tile_X2Y0_FrameData_O[14] Tile_X2Y0_FrameData_O[15] Tile_X2Y0_FrameData_O[16] Tile_X2Y0_FrameData_O[17]
+ Tile_X2Y0_FrameData_O[18] Tile_X2Y0_FrameData_O[19] Tile_X2Y0_FrameData_O[1] Tile_X2Y0_FrameData_O[20]
+ Tile_X2Y0_FrameData_O[21] Tile_X2Y0_FrameData_O[22] Tile_X2Y0_FrameData_O[23] Tile_X2Y0_FrameData_O[24]
+ Tile_X2Y0_FrameData_O[25] Tile_X2Y0_FrameData_O[26] Tile_X2Y0_FrameData_O[27] Tile_X2Y0_FrameData_O[28]
+ Tile_X2Y0_FrameData_O[29] Tile_X2Y0_FrameData_O[2] Tile_X2Y0_FrameData_O[30] Tile_X2Y0_FrameData_O[31]
+ Tile_X2Y0_FrameData_O[3] Tile_X2Y0_FrameData_O[4] Tile_X2Y0_FrameData_O[5] Tile_X2Y0_FrameData_O[6]
+ Tile_X2Y0_FrameData_O[7] Tile_X2Y0_FrameData_O[8] Tile_X2Y0_FrameData_O[9] Tile_X2Y0_FrameStrobe[0]
+ Tile_X2Y0_FrameStrobe[10] Tile_X2Y0_FrameStrobe[11] Tile_X2Y0_FrameStrobe[12] Tile_X2Y0_FrameStrobe[13]
+ Tile_X2Y0_FrameStrobe[14] Tile_X2Y0_FrameStrobe[15] Tile_X2Y0_FrameStrobe[16] Tile_X2Y0_FrameStrobe[17]
+ Tile_X2Y0_FrameStrobe[18] Tile_X2Y0_FrameStrobe[19] Tile_X2Y0_FrameStrobe[1] Tile_X2Y0_FrameStrobe[2]
+ Tile_X2Y0_FrameStrobe[3] Tile_X2Y0_FrameStrobe[4] Tile_X2Y0_FrameStrobe[5] Tile_X2Y0_FrameStrobe[6]
+ Tile_X2Y0_FrameStrobe[7] Tile_X2Y0_FrameStrobe[8] Tile_X2Y0_FrameStrobe[9] Tile_X2Y0_FrameStrobe_O[0]
+ Tile_X2Y0_FrameStrobe_O[10] Tile_X2Y0_FrameStrobe_O[11] Tile_X2Y0_FrameStrobe_O[12]
+ Tile_X2Y0_FrameStrobe_O[13] Tile_X2Y0_FrameStrobe_O[14] Tile_X2Y0_FrameStrobe_O[15]
+ Tile_X2Y0_FrameStrobe_O[16] Tile_X2Y0_FrameStrobe_O[17] Tile_X2Y0_FrameStrobe_O[18]
+ Tile_X2Y0_FrameStrobe_O[19] Tile_X2Y0_FrameStrobe_O[1] Tile_X2Y0_FrameStrobe_O[2]
+ Tile_X2Y0_FrameStrobe_O[3] Tile_X2Y0_FrameStrobe_O[4] Tile_X2Y0_FrameStrobe_O[5]
+ Tile_X2Y0_FrameStrobe_O[6] Tile_X2Y0_FrameStrobe_O[7] Tile_X2Y0_FrameStrobe_O[8]
+ Tile_X2Y0_FrameStrobe_O[9] Tile_X2Y0_N1BEG[0] Tile_X2Y0_N1BEG[1] Tile_X2Y0_N1BEG[2]
+ Tile_X2Y0_N1BEG[3] Tile_X2Y0_N2BEG[0] Tile_X2Y0_N2BEG[1] Tile_X2Y0_N2BEG[2] Tile_X2Y0_N2BEG[3]
+ Tile_X2Y0_N2BEG[4] Tile_X2Y0_N2BEG[5] Tile_X2Y0_N2BEG[6] Tile_X2Y0_N2BEG[7] Tile_X2Y0_N2BEGb[0]
+ Tile_X2Y0_N2BEGb[1] Tile_X2Y0_N2BEGb[2] Tile_X2Y0_N2BEGb[3] Tile_X2Y0_N2BEGb[4]
+ Tile_X2Y0_N2BEGb[5] Tile_X2Y0_N2BEGb[6] Tile_X2Y0_N2BEGb[7] Tile_X2Y0_N4BEG[0] Tile_X2Y0_N4BEG[10]
+ Tile_X2Y0_N4BEG[11] Tile_X2Y0_N4BEG[12] Tile_X2Y0_N4BEG[13] Tile_X2Y0_N4BEG[14]
+ Tile_X2Y0_N4BEG[15] Tile_X2Y0_N4BEG[1] Tile_X2Y0_N4BEG[2] Tile_X2Y0_N4BEG[3] Tile_X2Y0_N4BEG[4]
+ Tile_X2Y0_N4BEG[5] Tile_X2Y0_N4BEG[6] Tile_X2Y0_N4BEG[7] Tile_X2Y0_N4BEG[8] Tile_X2Y0_N4BEG[9]
+ Tile_X2Y0_NN4BEG[0] Tile_X2Y0_NN4BEG[10] Tile_X2Y0_NN4BEG[11] Tile_X2Y0_NN4BEG[12]
+ Tile_X2Y0_NN4BEG[13] Tile_X2Y0_NN4BEG[14] Tile_X2Y0_NN4BEG[15] Tile_X2Y0_NN4BEG[1]
+ Tile_X2Y0_NN4BEG[2] Tile_X2Y0_NN4BEG[3] Tile_X2Y0_NN4BEG[4] Tile_X2Y0_NN4BEG[5]
+ Tile_X2Y0_NN4BEG[6] Tile_X2Y0_NN4BEG[7] Tile_X2Y0_NN4BEG[8] Tile_X2Y0_NN4BEG[9]
+ Tile_X2Y0_S1END[0] Tile_X2Y0_S1END[1] Tile_X2Y0_S1END[2] Tile_X2Y0_S1END[3] Tile_X2Y0_S2END[0]
+ Tile_X2Y0_S2END[1] Tile_X2Y0_S2END[2] Tile_X2Y0_S2END[3] Tile_X2Y0_S2END[4] Tile_X2Y0_S2END[5]
+ Tile_X2Y0_S2END[6] Tile_X2Y0_S2END[7] Tile_X2Y0_S2MID[0] Tile_X2Y0_S2MID[1] Tile_X2Y0_S2MID[2]
+ Tile_X2Y0_S2MID[3] Tile_X2Y0_S2MID[4] Tile_X2Y0_S2MID[5] Tile_X2Y0_S2MID[6] Tile_X2Y0_S2MID[7]
+ Tile_X2Y0_S4END[0] Tile_X2Y0_S4END[10] Tile_X2Y0_S4END[11] Tile_X2Y0_S4END[12] Tile_X2Y0_S4END[13]
+ Tile_X2Y0_S4END[14] Tile_X2Y0_S4END[15] Tile_X2Y0_S4END[1] Tile_X2Y0_S4END[2] Tile_X2Y0_S4END[3]
+ Tile_X2Y0_S4END[4] Tile_X2Y0_S4END[5] Tile_X2Y0_S4END[6] Tile_X2Y0_S4END[7] Tile_X2Y0_S4END[8]
+ Tile_X2Y0_S4END[9] Tile_X2Y0_SS4END[0] Tile_X2Y0_SS4END[10] Tile_X2Y0_SS4END[11]
+ Tile_X2Y0_SS4END[12] Tile_X2Y0_SS4END[13] Tile_X2Y0_SS4END[14] Tile_X2Y0_SS4END[15]
+ Tile_X2Y0_SS4END[1] Tile_X2Y0_SS4END[2] Tile_X2Y0_SS4END[3] Tile_X2Y0_SS4END[4]
+ Tile_X2Y0_SS4END[5] Tile_X2Y0_SS4END[6] Tile_X2Y0_SS4END[7] Tile_X2Y0_SS4END[8]
+ Tile_X2Y0_SS4END[9] Tile_X2Y0_UserCLK Tile_X2Y0_UserCLKo VGND VPWR WDATA_top0 WDATA_top1
+ WDATA_top10 WDATA_top11 WDATA_top12 WDATA_top13 WDATA_top14 WDATA_top15 WDATA_top16
+ WDATA_top17 WDATA_top18 WDATA_top19 WDATA_top2 WDATA_top20 WDATA_top21 WDATA_top22
+ WDATA_top23 WDATA_top24 WDATA_top25 WDATA_top26 WDATA_top27 WDATA_top28 WDATA_top29
+ WDATA_top3 WDATA_top30 WDATA_top31 WDATA_top4 WDATA_top5 WDATA_top6 WDATA_top7 WDATA_top8
+ WDATA_top9 WE_top
X_0298_ Tile_X0Y0_S1END[3] WDATA_top9 Tile_X0Y0_S_OBI_left.Inst_S_OBI_left_ConfigMem.Inst_frame2_bit26.Q
+ Tile_X0Y0_S_OBI_left.Inst_S_OBI_left_switch_matrix.N1BEG0 VPWR VGND sg13g2_mux2_1
X_0367_ Tile_X1Y0_S_OBI_middle.Inst_S_OBI_middle_ConfigMem.Inst_frame0_bit18.Q VPWR
+ _0083_ VGND Tile_X1Y0_SS4END[5] Tile_X1Y0_S_OBI_middle.Inst_S_OBI_middle_ConfigMem.Inst_frame0_bit19.Q
+ sg13g2_o21ai_1
XFILLER_2_527 VPWR VGND sg13g2_decap_8
XFILLER_7_7 VPWR VGND sg13g2_decap_8
XFILLER_2_1232 VPWR VGND sg13g2_decap_8
XFILLER_10_840 VPWR VGND sg13g2_fill_2
XFILLER_3_56 VPWR VGND sg13g2_decap_8
XFILLER_5_365 VPWR VGND sg13g2_decap_8
XFILLER_6_888 VPWR VGND sg13g2_decap_8
XFILLER_7_1132 VPWR VGND sg13g2_fill_2
XFILLER_3_1007 VPWR VGND sg13g2_decap_4
X_0985_ Tile_X1Y0_FrameStrobe[9] Tile_X1Y0_FrameStrobe_O[9] VPWR VGND sg13g2_buf_1
X_0419_ Tile_X2Y0_S2END[6] ADDR_top16 Tile_X2Y0_S_OBI_right.Inst_S_OBI_right_ConfigMem.Inst_frame1_bit7.Q
+ Tile_X2Y0_S_OBI_right.Inst_S_OBI_right_switch_matrix.N2BEGb1 VPWR VGND sg13g2_mux2_1
XFILLER_2_324 VPWR VGND sg13g2_decap_8
XFILLER_3_825 VPWR VGND sg13g2_decap_8
XFILLER_4_1305 VPWR VGND sg13g2_decap_4
XFILLER_2_1073 VPWR VGND sg13g2_fill_1
X_0770_ Tile_X0Y0_FrameData[21] Tile_X2Y0_FrameStrobe[0] Tile_X2Y0_S_OBI_right.Inst_S_OBI_right_ConfigMem.Inst_frame0_bit21.Q
+ VPWR VGND sg13g2_dlhq_1
X_0968_ Tile_X0Y0_S_OBI_left.Inst_S_OBI_left_switch_matrix.NN4BEG9 Tile_X0Y0_NN4BEG[9]
+ VPWR VGND sg13g2_buf_1
X_0899_ Tile_X0Y0_FrameData[26] Tile_X0Y0_FrameStrobe[2] Tile_X0Y0_S_OBI_left.Inst_S_OBI_left_ConfigMem.Inst_frame2_bit26.Q
+ VPWR VGND sg13g2_dlhq_1
XFILLER_11_423 VPWR VGND sg13g2_decap_8
XFILLER_8_939 VPWR VGND sg13g2_decap_8
XFILLER_3_611 VPWR VGND sg13g2_decap_8
XFILLER_2_154 VPWR VGND sg13g2_decap_8
XFILLER_2_176 VPWR VGND sg13g2_decap_8
XFILLER_8_1293 VPWR VGND sg13g2_decap_8
XFILLER_0_35 VPWR VGND sg13g2_decap_8
XFILLER_4_1168 VPWR VGND sg13g2_fill_2
X_0822_ Tile_X0Y0_FrameData[1] Tile_X2Y0_FrameStrobe[1] Tile_X2Y0_S_OBI_right.Inst_S_OBI_right_ConfigMem.Inst_frame1_bit1.Q
+ VPWR VGND sg13g2_dlhq_1
X_0753_ Tile_X0Y0_FrameData[16] Tile_X1Y0_FrameStrobe[2] Tile_X1Y0_S_OBI_middle.Inst_S_OBI_middle_ConfigMem.Inst_frame2_bit16.Q
+ VPWR VGND sg13g2_dlhq_1
XFILLER_7_950 VPWR VGND sg13g2_decap_8
X_0684_ Tile_X0Y0_FrameData[21] Tile_X1Y0_FrameStrobe[0] Tile_X1Y0_S_OBI_middle.Inst_S_OBI_middle_ConfigMem.Inst_frame0_bit21.Q
+ VPWR VGND sg13g2_dlhq_1
X_1098_ Tile_X2Y0_FrameStrobe[17] Tile_X2Y0_FrameStrobe_O[17] VPWR VGND sg13g2_buf_1
XFILLER_10_1118 VPWR VGND sg13g2_fill_2
XFILLER_4_419 VPWR VGND sg13g2_decap_8
XFILLER_0_669 VPWR VGND sg13g2_decap_8
XFILLER_11_253 VPWR VGND sg13g2_fill_1
XFILLER_8_758 VPWR VGND sg13g2_fill_1
XFILLER_4_986 VPWR VGND sg13g2_decap_8
XFILLER_3_485 VPWR VGND sg13g2_decap_8
X_1021_ Tile_X1Y0_S_OBI_middle.Inst_S_OBI_middle_switch_matrix.N4BEG5 Tile_X1Y0_N4BEG[5]
+ VPWR VGND sg13g2_buf_1
X_0805_ Tile_X0Y0_FrameData[18] Tile_X2Y0_FrameStrobe[1] Tile_X2Y0_S_OBI_right.Inst_S_OBI_right_ConfigMem.Inst_frame1_bit18.Q
+ VPWR VGND sg13g2_dlhq_1
X_0667_ Tile_X0Y0_SS4END[15] Tile_X0Y0_S_OBI_left.Inst_S_OBI_left_ConfigMem.Inst_frame0_bit30.Q
+ _0021_ VPWR VGND sg13g2_nor2_1
X_0736_ Tile_X0Y0_FrameData[1] Tile_X1Y0_FrameStrobe[1] Tile_X1Y0_S_OBI_middle.Inst_S_OBI_middle_ConfigMem.Inst_frame1_bit1.Q
+ VPWR VGND sg13g2_dlhq_1
X_0598_ Tile_X0Y0_S2MID[1] Tile_X0Y0_S_OBI_left.Inst_S_OBI_left_ConfigMem.Inst_frame0_bit6.Q
+ Tile_X0Y0_S_OBI_left.Inst_S_OBI_left_ConfigMem.Inst_frame0_bit7.Q _0214_ VPWR VGND
+ sg13g2_nor3_1
XFILLER_0_1330 VPWR VGND sg13g2_fill_2
XFILLER_0_466 VPWR VGND sg13g2_decap_8
XFILLER_5_1230 VPWR VGND sg13g2_decap_8
XFILLER_5_1241 VPWR VGND sg13g2_decap_8
XFILLER_1_1138 VPWR VGND sg13g2_decap_8
XANTENNA_5 VPWR VGND ADDR_top23 sg13g2_antennanp
X_0452_ Tile_X2Y0_SS4END[6] Tile_X2Y0_S_OBI_right.Inst_S_OBI_right_ConfigMem.Inst_frame0_bit3.Q
+ _0119_ VPWR VGND sg13g2_nor2_1
XFILLER_6_56 VPWR VGND sg13g2_decap_8
X_0521_ _0180_ _0178_ _0176_ RDATA_top17 VPWR VGND sg13g2_a21o_1
X_0383_ _0094_ Tile_X1Y0_S4END[10] Tile_X1Y0_S_OBI_middle.Inst_S_OBI_middle_ConfigMem.Inst_frame0_bit28.Q
+ VPWR VGND sg13g2_nand2b_1
XFILLER_6_1027 VPWR VGND sg13g2_fill_1
X_1004_ Tile_X1Y0_S_OBI_middle.Inst_S_OBI_middle_switch_matrix.N2BEG4 Tile_X1Y0_N2BEG[4]
+ VPWR VGND sg13g2_buf_1
X_0719_ Tile_X0Y0_FrameData[18] Tile_X1Y0_FrameStrobe[1] Tile_X1Y0_S_OBI_middle.Inst_S_OBI_middle_ConfigMem.Inst_frame1_bit18.Q
+ VPWR VGND sg13g2_dlhq_1
XFILLER_0_1193 VPWR VGND sg13g2_decap_8
XFILLER_1_720 VPWR VGND sg13g2_decap_8
XFILLER_7_1303 VPWR VGND sg13g2_decap_4
XFILLER_0_296 VPWR VGND sg13g2_decap_8
XFILLER_8_396 VPWR VGND sg13g2_decap_8
X_0435_ Tile_X2Y0_S4END[6] WDATA_top10 Tile_X2Y0_S_OBI_right.Inst_S_OBI_right_ConfigMem.Inst_frame1_bit23.Q
+ Tile_X2Y0_S_OBI_right.Inst_S_OBI_right_switch_matrix.N4BEG9 VPWR VGND sg13g2_mux2_1
X_0504_ _0165_ Tile_X2Y0_S2END[6] Tile_X2Y0_S_OBI_right.Inst_S_OBI_right_ConfigMem.Inst_frame0_bit21.Q
+ VPWR VGND sg13g2_nand2b_1
X_0297_ VPWR _0070_ Tile_X0Y0_S_OBI_left.Inst_S_OBI_left_ConfigMem.Inst_frame0_bit29.Q
+ VGND sg13g2_inv_1
XFILLER_11_0 VPWR VGND sg13g2_decap_8
X_0366_ _0081_ VPWR RDATA_top24 VGND Tile_X1Y0_S_OBI_middle.Inst_S_OBI_middle_ConfigMem.Inst_frame0_bit17.Q
+ _0082_ sg13g2_o21ai_1
XFILLER_2_506 VPWR VGND sg13g2_decap_8
XFILLER_2_1211 VPWR VGND sg13g2_decap_8
XFILLER_2_1288 VPWR VGND sg13g2_decap_8
XFILLER_5_311 VPWR VGND sg13g2_fill_2
XFILLER_5_355 VPWR VGND sg13g2_decap_4
XFILLER_6_867 VPWR VGND sg13g2_decap_8
XFILLER_3_35 VPWR VGND sg13g2_decap_8
XFILLER_7_1166 VPWR VGND sg13g2_fill_1
X_0984_ Tile_X1Y0_FrameStrobe[8] Tile_X1Y0_FrameStrobe_O[8] VPWR VGND sg13g2_buf_1
X_0418_ Tile_X2Y0_S2END[7] ADDR_top17 Tile_X2Y0_S_OBI_right.Inst_S_OBI_right_ConfigMem.Inst_frame1_bit6.Q
+ Tile_X2Y0_S_OBI_right.Inst_S_OBI_right_switch_matrix.N2BEGb0 VPWR VGND sg13g2_mux2_1
X_0349_ Tile_X1Y0_SS4END[2] WDATA_top22 Tile_X1Y0_S_OBI_middle.Inst_S_OBI_middle_ConfigMem.Inst_frame1_bit31.Q
+ Tile_X1Y0_S_OBI_middle.Inst_S_OBI_middle_switch_matrix.NN4BEG13 VPWR VGND sg13g2_mux2_1
XFILLER_10_159 VPWR VGND sg13g2_fill_2
XFILLER_3_804 VPWR VGND sg13g2_decap_8
XFILLER_9_1239 VPWR VGND sg13g2_fill_2
XFILLER_1_391 VPWR VGND sg13g2_decap_8
XFILLER_2_892 VPWR VGND sg13g2_decap_8
X_0967_ Tile_X0Y0_S_OBI_left.Inst_S_OBI_left_switch_matrix.NN4BEG8 Tile_X0Y0_NN4BEG[8]
+ VPWR VGND sg13g2_buf_1
X_0898_ Tile_X0Y0_FrameData[27] Tile_X0Y0_FrameStrobe[2] Tile_X0Y0_S_OBI_left.Inst_S_OBI_left_ConfigMem.Inst_frame2_bit27.Q
+ VPWR VGND sg13g2_dlhq_1
XFILLER_8_918 VPWR VGND sg13g2_decap_8
XFILLER_11_479 VPWR VGND sg13g2_decap_8
XFILLER_8_1272 VPWR VGND sg13g2_decap_8
XFILLER_2_133 VPWR VGND sg13g2_decap_8
XFILLER_0_14 VPWR VGND sg13g2_decap_8
X_0821_ Tile_X0Y0_FrameData[2] Tile_X2Y0_FrameStrobe[1] Tile_X2Y0_S_OBI_right.Inst_S_OBI_right_ConfigMem.Inst_frame1_bit2.Q
+ VPWR VGND sg13g2_dlhq_1
X_0752_ Tile_X0Y0_FrameData[17] Tile_X1Y0_FrameStrobe[2] Tile_X1Y0_S_OBI_middle.Inst_S_OBI_middle_ConfigMem.Inst_frame2_bit17.Q
+ VPWR VGND sg13g2_dlhq_1
X_0683_ Tile_X0Y0_FrameData[22] Tile_X1Y0_FrameStrobe[0] Tile_X1Y0_S_OBI_middle.Inst_S_OBI_middle_ConfigMem.Inst_frame0_bit22.Q
+ VPWR VGND sg13g2_dlhq_1
XFILLER_9_1058 VPWR VGND sg13g2_fill_1
X_1097_ Tile_X2Y0_FrameStrobe[16] Tile_X2Y0_FrameStrobe_O[16] VPWR VGND sg13g2_buf_1
XFILLER_0_648 VPWR VGND sg13g2_decap_8
XFILLER_8_737 VPWR VGND sg13g2_fill_1
XFILLER_3_464 VPWR VGND sg13g2_decap_8
XFILLER_4_965 VPWR VGND sg13g2_decap_8
X_1020_ Tile_X1Y0_S_OBI_middle.Inst_S_OBI_middle_switch_matrix.N4BEG4 Tile_X1Y0_N4BEG[4]
+ VPWR VGND sg13g2_buf_1
X_0804_ Tile_X0Y0_FrameData[19] Tile_X2Y0_FrameStrobe[1] Tile_X2Y0_S_OBI_right.Inst_S_OBI_right_ConfigMem.Inst_frame1_bit19.Q
+ VPWR VGND sg13g2_dlhq_1
X_0735_ Tile_X0Y0_FrameData[2] Tile_X1Y0_FrameStrobe[1] Tile_X1Y0_S_OBI_middle.Inst_S_OBI_middle_ConfigMem.Inst_frame1_bit2.Q
+ VPWR VGND sg13g2_dlhq_1
X_0666_ VGND VPWR Tile_X0Y0_S4END[15] Tile_X0Y0_S_OBI_left.Inst_S_OBI_left_ConfigMem.Inst_frame0_bit30.Q
+ _0020_ Tile_X0Y0_S_OBI_left.Inst_S_OBI_left_ConfigMem.Inst_frame0_bit31.Q sg13g2_a21oi_1
X_0597_ Tile_X0Y0_S_OBI_left.Inst_S_OBI_left_ConfigMem.Inst_frame0_bit7.Q VPWR _0213_
+ VGND Tile_X0Y0_S_OBI_left.Inst_S_OBI_left_ConfigMem.Inst_frame0_bit6.Q _0058_ sg13g2_o21ai_1
X_1149_ Tile_X2Y0_SS4END[3] Tile_X2Y0_NN4BEG[12] VPWR VGND sg13g2_buf_1
XFILLER_1_935 VPWR VGND sg13g2_fill_2
XFILLER_1_924 VPWR VGND sg13g2_decap_8
XFILLER_1_979 VPWR VGND sg13g2_decap_4
XFILLER_1_957 VPWR VGND sg13g2_decap_8
XFILLER_0_445 VPWR VGND sg13g2_decap_8
XFILLER_5_1297 VPWR VGND sg13g2_decap_8
XFILLER_8_589 VPWR VGND sg13g2_decap_8
XFILLER_8_501 VPWR VGND sg13g2_decap_8
XANTENNA_6 VPWR VGND ADDR_top23 sg13g2_antennanp
XFILLER_6_35 VPWR VGND sg13g2_decap_8
X_0382_ Tile_X1Y0_S_OBI_middle.Inst_S_OBI_middle_ConfigMem.Inst_frame0_bit28.Q VPWR
+ _0093_ VGND Tile_X1Y0_SS4END[10] Tile_X1Y0_S_OBI_middle.Inst_S_OBI_middle_ConfigMem.Inst_frame0_bit29.Q
+ sg13g2_o21ai_1
X_0451_ VGND VPWR Tile_X2Y0_S4END[6] Tile_X2Y0_S_OBI_right.Inst_S_OBI_right_ConfigMem.Inst_frame0_bit3.Q
+ _0118_ Tile_X2Y0_S_OBI_right.Inst_S_OBI_right_ConfigMem.Inst_frame0_bit4.Q sg13g2_a21oi_1
X_0520_ Tile_X2Y0_S_OBI_right.Inst_S_OBI_right_ConfigMem.Inst_frame0_bit23.Q _0177_
+ _0179_ _0180_ VPWR VGND sg13g2_nor3_1
X_1003_ Tile_X1Y0_S_OBI_middle.Inst_S_OBI_middle_switch_matrix.N2BEG3 Tile_X1Y0_N2BEG[3]
+ VPWR VGND sg13g2_buf_1
X_0718_ Tile_X0Y0_FrameData[19] Tile_X1Y0_FrameStrobe[1] Tile_X1Y0_S_OBI_middle.Inst_S_OBI_middle_ConfigMem.Inst_frame1_bit19.Q
+ VPWR VGND sg13g2_dlhq_1
X_0649_ Tile_X0Y0_S4END[7] Tile_X0Y0_S_OBI_left.Inst_S_OBI_left_ConfigMem.Inst_frame0_bit24.Q
+ _0005_ VPWR VGND sg13g2_nor2b_1
XFILLER_0_1172 VPWR VGND sg13g2_decap_8
XFILLER_1_765 VPWR VGND sg13g2_decap_8
XFILLER_0_275 VPWR VGND sg13g2_decap_8
X_0503_ _0164_ _0162_ _0160_ RDATA_top15 VPWR VGND sg13g2_a21o_1
X_0365_ _0082_ Tile_X1Y0_S4END[4] Tile_X1Y0_S_OBI_middle.Inst_S_OBI_middle_ConfigMem.Inst_frame0_bit16.Q
+ VPWR VGND sg13g2_nand2b_1
XFILLER_4_581 VPWR VGND sg13g2_decap_8
XFILLER_4_592 VPWR VGND sg13g2_fill_2
X_0434_ Tile_X2Y0_S4END[7] WDATA_top11 Tile_X2Y0_S_OBI_right.Inst_S_OBI_right_ConfigMem.Inst_frame1_bit22.Q
+ Tile_X2Y0_S_OBI_right.Inst_S_OBI_right_switch_matrix.N4BEG8 VPWR VGND sg13g2_mux2_1
X_0296_ VPWR _0069_ Tile_X0Y0_S_OBI_left.Inst_S_OBI_left_ConfigMem.Inst_frame0_bit26.Q
+ VGND sg13g2_inv_1
XFILLER_11_1044 VPWR VGND sg13g2_fill_2
XFILLER_11_1033 VPWR VGND sg13g2_fill_2
XFILLER_2_1267 VPWR VGND sg13g2_decap_8
XFILLER_7_1134 VPWR VGND sg13g2_fill_1
XFILLER_1_584 VPWR VGND sg13g2_fill_1
XFILLER_1_573 VPWR VGND sg13g2_decap_8
XFILLER_3_14 VPWR VGND sg13g2_decap_8
XFILLER_9_684 VPWR VGND sg13g2_fill_2
XFILLER_9_673 VPWR VGND sg13g2_fill_1
XFILLER_8_172 VPWR VGND sg13g2_fill_2
X_0983_ Tile_X1Y0_FrameStrobe[7] Tile_X1Y0_FrameStrobe_O[7] VPWR VGND sg13g2_buf_1
XFILLER_8_194 VPWR VGND sg13g2_fill_1
X_0348_ Tile_X1Y0_SS4END[3] WDATA_top23 Tile_X1Y0_S_OBI_middle.Inst_S_OBI_middle_ConfigMem.Inst_frame1_bit30.Q
+ Tile_X1Y0_S_OBI_middle.Inst_S_OBI_middle_switch_matrix.NN4BEG12 VPWR VGND sg13g2_mux2_1
X_0417_ Tile_X2Y0_S2MID[0] WDATA_top10 Tile_X2Y0_S_OBI_right.Inst_S_OBI_right_ConfigMem.Inst_frame1_bit5.Q
+ Tile_X2Y0_S_OBI_right.Inst_S_OBI_right_switch_matrix.N2BEG7 VPWR VGND sg13g2_mux2_1
XFILLER_11_606 VPWR VGND sg13g2_fill_2
X_0279_ VPWR _0052_ Tile_X0Y0_SS4END[8] VGND sg13g2_inv_1
XFILLER_2_359 VPWR VGND sg13g2_decap_8
XFILLER_9_1207 VPWR VGND sg13g2_fill_1
XFILLER_1_370 VPWR VGND sg13g2_decap_8
XFILLER_2_871 VPWR VGND sg13g2_decap_8
XFILLER_9_492 VPWR VGND sg13g2_decap_8
X_0897_ Tile_X0Y0_FrameData[28] Tile_X0Y0_FrameStrobe[2] Tile_X0Y0_S_OBI_left.Inst_S_OBI_left_ConfigMem.Inst_frame2_bit28.Q
+ VPWR VGND sg13g2_dlhq_1
X_0966_ Tile_X0Y0_S_OBI_left.Inst_S_OBI_left_switch_matrix.NN4BEG7 Tile_X0Y0_NN4BEG[7]
+ VPWR VGND sg13g2_buf_1
XFILLER_11_458 VPWR VGND sg13g2_decap_8
XFILLER_7_429 VPWR VGND sg13g2_decap_8
XFILLER_2_112 VPWR VGND sg13g2_decap_8
XFILLER_9_35 VPWR VGND sg13g2_decap_8
X_0751_ Tile_X0Y0_FrameData[18] Tile_X1Y0_FrameStrobe[2] Tile_X1Y0_S_OBI_middle.Inst_S_OBI_middle_ConfigMem.Inst_frame2_bit18.Q
+ VPWR VGND sg13g2_dlhq_1
XFILLER_9_46 VPWR VGND sg13g2_fill_1
XFILLER_7_985 VPWR VGND sg13g2_decap_8
X_0820_ Tile_X0Y0_FrameData[3] Tile_X2Y0_FrameStrobe[1] Tile_X2Y0_S_OBI_right.Inst_S_OBI_right_ConfigMem.Inst_frame1_bit3.Q
+ VPWR VGND sg13g2_dlhq_1
XFILLER_6_484 VPWR VGND sg13g2_decap_8
X_0682_ Tile_X0Y0_FrameData[23] Tile_X1Y0_FrameStrobe[0] Tile_X1Y0_S_OBI_middle.Inst_S_OBI_middle_ConfigMem.Inst_frame0_bit23.Q
+ VPWR VGND sg13g2_dlhq_1
X_1096_ Tile_X2Y0_FrameStrobe[15] Tile_X2Y0_FrameStrobe_O[15] VPWR VGND sg13g2_buf_1
X_0949_ Tile_X0Y0_S_OBI_left.Inst_S_OBI_left_switch_matrix.N4BEG6 Tile_X0Y0_N4BEG[6]
+ VPWR VGND sg13g2_buf_1
XFILLER_0_627 VPWR VGND sg13g2_decap_8
XFILLER_11_222 VPWR VGND sg13g2_fill_1
XFILLER_11_211 VPWR VGND sg13g2_fill_2
XFILLER_1_0 VPWR VGND sg13g2_decap_8
XFILLER_3_443 VPWR VGND sg13g2_decap_8
XFILLER_4_944 VPWR VGND sg13g2_decap_8
X_0665_ _0019_ Tile_X0Y0_S1END[3] Tile_X0Y0_S_OBI_left.Inst_S_OBI_left_ConfigMem.Inst_frame0_bit30.Q
+ VPWR VGND sg13g2_nand2b_1
X_0803_ Tile_X0Y0_FrameData[20] Tile_X2Y0_FrameStrobe[1] Tile_X2Y0_S_OBI_right.Inst_S_OBI_right_ConfigMem.Inst_frame1_bit20.Q
+ VPWR VGND sg13g2_dlhq_1
X_0734_ Tile_X0Y0_FrameData[3] Tile_X1Y0_FrameStrobe[1] Tile_X1Y0_S_OBI_middle.Inst_S_OBI_middle_ConfigMem.Inst_frame1_bit3.Q
+ VPWR VGND sg13g2_dlhq_1
X_0596_ VPWR VGND Tile_X0Y0_S_OBI_left.Inst_S_OBI_left_ConfigMem.Inst_frame0_bit7.Q
+ _0057_ _0211_ _0209_ _0212_ _0210_ sg13g2_a221oi_1
X_1148_ Tile_X2Y0_SS4END[4] Tile_X2Y0_NN4BEG[11] VPWR VGND sg13g2_buf_1
X_1079_ Tile_X0Y0_FrameData[30] Tile_X2Y0_FrameData_O[30] VPWR VGND sg13g2_buf_1
XFILLER_0_1310 VPWR VGND sg13g2_fill_2
XFILLER_0_424 VPWR VGND sg13g2_decap_8
XFILLER_1_1107 VPWR VGND sg13g2_fill_2
XFILLER_5_1276 VPWR VGND sg13g2_decap_8
XANTENNA_7 VPWR VGND ADDR_top23 sg13g2_antennanp
XFILLER_6_14 VPWR VGND sg13g2_decap_8
X_0381_ _0091_ VPWR RDATA_top29 VGND Tile_X1Y0_S_OBI_middle.Inst_S_OBI_middle_ConfigMem.Inst_frame0_bit27.Q
+ _0092_ sg13g2_o21ai_1
XFILLER_0_991 VPWR VGND sg13g2_decap_8
XFILLER_3_295 VPWR VGND sg13g2_decap_8
X_0450_ _0117_ Tile_X2Y0_S2END[0] Tile_X2Y0_S_OBI_right.Inst_S_OBI_right_ConfigMem.Inst_frame0_bit3.Q
+ VPWR VGND sg13g2_nand2b_1
XFILLER_4_763 VPWR VGND sg13g2_decap_8
X_1002_ Tile_X1Y0_S_OBI_middle.Inst_S_OBI_middle_switch_matrix.N2BEG2 Tile_X1Y0_N2BEG[2]
+ VPWR VGND sg13g2_buf_1
X_0717_ Tile_X0Y0_FrameData[20] Tile_X1Y0_FrameStrobe[1] Tile_X1Y0_S_OBI_middle.Inst_S_OBI_middle_ConfigMem.Inst_frame1_bit20.Q
+ VPWR VGND sg13g2_dlhq_1
X_0648_ Tile_X0Y0_S_OBI_left.Inst_S_OBI_left_ConfigMem.Inst_frame0_bit25.Q VPWR _0004_
+ VGND _0053_ Tile_X0Y0_S_OBI_left.Inst_S_OBI_left_ConfigMem.Inst_frame0_bit24.Q sg13g2_o21ai_1
X_0579_ _0198_ VPWR Tile_X0Y0_S_OBI_left.Inst_S_OBI_left_switch_matrix.NN4BEG7 VGND
+ _0052_ Tile_X0Y0_S_OBI_left.Inst_S_OBI_left_ConfigMem.Inst_frame1_bit31.Q sg13g2_o21ai_1
XFILLER_0_1151 VPWR VGND sg13g2_decap_8
XFILLER_5_505 VPWR VGND sg13g2_decap_8
XFILLER_1_788 VPWR VGND sg13g2_decap_4
XFILLER_0_210 VPWR VGND sg13g2_decap_4
XFILLER_0_254 VPWR VGND sg13g2_decap_8
X_0502_ Tile_X2Y0_S_OBI_right.Inst_S_OBI_right_ConfigMem.Inst_frame0_bit17.Q _0161_
+ _0163_ _0164_ VPWR VGND sg13g2_nor3_1
X_0295_ VPWR _0068_ Tile_X0Y0_S_OBI_left.Inst_S_OBI_left_ConfigMem.Inst_frame0_bit23.Q
+ VGND sg13g2_inv_1
X_0433_ Tile_X2Y0_S4END[8] WDATA_top12 Tile_X2Y0_S_OBI_right.Inst_S_OBI_right_ConfigMem.Inst_frame1_bit21.Q
+ Tile_X2Y0_S_OBI_right.Inst_S_OBI_right_switch_matrix.N4BEG7 VPWR VGND sg13g2_mux2_1
X_0364_ Tile_X1Y0_S_OBI_middle.Inst_S_OBI_middle_ConfigMem.Inst_frame0_bit16.Q VPWR
+ _0081_ VGND Tile_X1Y0_SS4END[4] Tile_X1Y0_S_OBI_middle.Inst_S_OBI_middle_ConfigMem.Inst_frame0_bit17.Q
+ sg13g2_o21ai_1
XFILLER_7_90 VPWR VGND sg13g2_fill_1
XFILLER_2_1246 VPWR VGND sg13g2_decap_8
XFILLER_5_379 VPWR VGND sg13g2_decap_8
XFILLER_1_596 VPWR VGND sg13g2_decap_4
XFILLER_1_552 VPWR VGND sg13g2_fill_2
XFILLER_1_541 VPWR VGND sg13g2_decap_8
X_0982_ Tile_X1Y0_FrameStrobe[6] Tile_X1Y0_FrameStrobe_O[6] VPWR VGND sg13g2_buf_1
X_0347_ Tile_X1Y0_SS4END[4] WDATA_top24 Tile_X1Y0_S_OBI_middle.Inst_S_OBI_middle_ConfigMem.Inst_frame1_bit29.Q
+ Tile_X1Y0_S_OBI_middle.Inst_S_OBI_middle_switch_matrix.NN4BEG11 VPWR VGND sg13g2_mux2_1
X_0416_ Tile_X2Y0_S2MID[1] WDATA_top11 Tile_X2Y0_S_OBI_right.Inst_S_OBI_right_ConfigMem.Inst_frame1_bit4.Q
+ Tile_X2Y0_S_OBI_right.Inst_S_OBI_right_switch_matrix.N2BEG6 VPWR VGND sg13g2_mux2_1
X_0278_ VPWR _0051_ Tile_X0Y0_SS4END[9] VGND sg13g2_inv_1
XFILLER_2_338 VPWR VGND sg13g2_decap_8
XFILLER_3_839 VPWR VGND sg13g2_decap_8
XFILLER_5_7 VPWR VGND sg13g2_decap_8
XFILLER_2_1032 VPWR VGND sg13g2_decap_8
XFILLER_2_1043 VPWR VGND sg13g2_fill_1
XFILLER_2_1054 VPWR VGND sg13g2_fill_1
XFILLER_2_850 VPWR VGND sg13g2_decap_8
XFILLER_5_143 VPWR VGND sg13g2_fill_2
X_0896_ Tile_X0Y0_FrameData[29] Tile_X0Y0_FrameStrobe[2] Tile_X0Y0_S_OBI_left.Inst_S_OBI_left_ConfigMem.Inst_frame2_bit29.Q
+ VPWR VGND sg13g2_dlhq_1
XFILLER_9_471 VPWR VGND sg13g2_decap_8
X_0965_ Tile_X0Y0_S_OBI_left.Inst_S_OBI_left_switch_matrix.NN4BEG6 Tile_X0Y0_NN4BEG[6]
+ VPWR VGND sg13g2_buf_1
XFILLER_0_809 VPWR VGND sg13g2_decap_8
XFILLER_4_91 VPWR VGND sg13g2_decap_8
XFILLER_3_1330 VPWR VGND sg13g2_fill_2
XFILLER_11_437 VPWR VGND sg13g2_decap_8
XFILLER_7_408 VPWR VGND sg13g2_decap_8
XFILLER_3_625 VPWR VGND sg13g2_decap_4
XFILLER_8_1230 VPWR VGND sg13g2_fill_2
XFILLER_0_49 VPWR VGND sg13g2_decap_8
XFILLER_4_1105 VPWR VGND sg13g2_decap_4
XFILLER_4_1127 VPWR VGND sg13g2_fill_2
XFILLER_9_14 VPWR VGND sg13g2_decap_8
X_0750_ Tile_X0Y0_FrameData[19] Tile_X1Y0_FrameStrobe[2] Tile_X1Y0_S_OBI_middle.Inst_S_OBI_middle_ConfigMem.Inst_frame2_bit19.Q
+ VPWR VGND sg13g2_dlhq_1
XFILLER_10_481 VPWR VGND sg13g2_decap_8
X_0681_ Tile_X0Y0_FrameData[24] Tile_X1Y0_FrameStrobe[0] Tile_X1Y0_S_OBI_middle.Inst_S_OBI_middle_ConfigMem.Inst_frame0_bit24.Q
+ VPWR VGND sg13g2_dlhq_1
XFILLER_7_964 VPWR VGND sg13g2_decap_8
XFILLER_6_463 VPWR VGND sg13g2_decap_8
X_1095_ Tile_X2Y0_FrameStrobe[14] Tile_X2Y0_FrameStrobe_O[14] VPWR VGND sg13g2_buf_1
X_0948_ Tile_X0Y0_S_OBI_left.Inst_S_OBI_left_switch_matrix.N4BEG5 Tile_X0Y0_N4BEG[5]
+ VPWR VGND sg13g2_buf_1
X_0879_ Tile_X0Y0_FrameData[14] Tile_X0Y0_FrameStrobe[1] Tile_X0Y0_S_OBI_left.Inst_S_OBI_left_ConfigMem.Inst_frame1_bit14.Q
+ VPWR VGND sg13g2_dlhq_1
XFILLER_0_606 VPWR VGND sg13g2_decap_8
XFILLER_8_717 VPWR VGND sg13g2_fill_2
XFILLER_4_923 VPWR VGND sg13g2_decap_8
XFILLER_3_422 VPWR VGND sg13g2_decap_8
XFILLER_3_499 VPWR VGND sg13g2_decap_8
X_0802_ Tile_X0Y0_FrameData[21] Tile_X2Y0_FrameStrobe[1] Tile_X2Y0_S_OBI_right.Inst_S_OBI_right_ConfigMem.Inst_frame1_bit21.Q
+ VPWR VGND sg13g2_dlhq_1
X_0664_ _0014_ _0011_ _0018_ RDATA_top8 VPWR VGND sg13g2_a21o_1
XFILLER_7_794 VPWR VGND sg13g2_decap_8
X_0733_ Tile_X0Y0_FrameData[4] Tile_X1Y0_FrameStrobe[1] Tile_X1Y0_S_OBI_middle.Inst_S_OBI_middle_ConfigMem.Inst_frame1_bit4.Q
+ VPWR VGND sg13g2_dlhq_1
X_0595_ Tile_X0Y0_SS4END[7] Tile_X0Y0_S_OBI_left.Inst_S_OBI_left_ConfigMem.Inst_frame0_bit6.Q
+ _0211_ VPWR VGND sg13g2_nor2_1
X_1147_ Tile_X2Y0_SS4END[5] Tile_X2Y0_NN4BEG[10] VPWR VGND sg13g2_buf_1
X_1078_ Tile_X0Y0_FrameData[29] Tile_X2Y0_FrameData_O[29] VPWR VGND sg13g2_buf_1
XFILLER_1_70 VPWR VGND sg13g2_fill_2
XFILLER_5_709 VPWR VGND sg13g2_decap_4
XFILLER_1_948 VPWR VGND sg13g2_decap_4
XFILLER_1_904 VPWR VGND sg13g2_fill_1
XFILLER_0_403 VPWR VGND sg13g2_decap_8
XFILLER_5_1255 VPWR VGND sg13g2_decap_8
XANTENNA_8 VPWR VGND Tile_X0Y0_FrameData[0] sg13g2_antennanp
X_0380_ _0092_ Tile_X1Y0_S4END[9] Tile_X1Y0_S_OBI_middle.Inst_S_OBI_middle_ConfigMem.Inst_frame0_bit26.Q
+ VPWR VGND sg13g2_nand2b_1
XFILLER_0_970 VPWR VGND sg13g2_decap_8
X_1001_ Tile_X1Y0_S_OBI_middle.Inst_S_OBI_middle_switch_matrix.N2BEG1 Tile_X1Y0_N2BEG[1]
+ VPWR VGND sg13g2_buf_1
X_0716_ Tile_X0Y0_FrameData[21] Tile_X1Y0_FrameStrobe[1] Tile_X1Y0_S_OBI_middle.Inst_S_OBI_middle_ConfigMem.Inst_frame1_bit21.Q
+ VPWR VGND sg13g2_dlhq_1
X_0578_ _0198_ ADDR_top2 Tile_X0Y0_S_OBI_left.Inst_S_OBI_left_ConfigMem.Inst_frame1_bit31.Q
+ VPWR VGND sg13g2_nand2_1
X_0647_ Tile_X0Y0_S2MID[7] Tile_X0Y0_S_OBI_left.Inst_S_OBI_left_ConfigMem.Inst_frame0_bit24.Q
+ Tile_X0Y0_S_OBI_left.Inst_S_OBI_left_ConfigMem.Inst_frame0_bit25.Q _0003_ VPWR VGND
+ sg13g2_nor3_1
XFILLER_1_756 VPWR VGND sg13g2_decap_4
XFILLER_1_734 VPWR VGND sg13g2_decap_8
XFILLER_0_233 VPWR VGND sg13g2_decap_8
X_0501_ Tile_X2Y0_S4END[5] Tile_X2Y0_S_OBI_right.Inst_S_OBI_right_ConfigMem.Inst_frame0_bit18.Q
+ _0163_ VPWR VGND sg13g2_nor2b_1
X_0432_ Tile_X2Y0_S4END[9] WDATA_top13 Tile_X2Y0_S_OBI_right.Inst_S_OBI_right_ConfigMem.Inst_frame1_bit20.Q
+ Tile_X2Y0_S_OBI_right.Inst_S_OBI_right_switch_matrix.N4BEG6 VPWR VGND sg13g2_mux2_1
X_0363_ _0079_ VPWR RDATA_top23 VGND Tile_X1Y0_S_OBI_middle.Inst_S_OBI_middle_ConfigMem.Inst_frame0_bit15.Q
+ _0080_ sg13g2_o21ai_1
X_0294_ VPWR _0067_ Tile_X0Y0_S_OBI_left.Inst_S_OBI_left_ConfigMem.Inst_frame0_bit20.Q
+ VGND sg13g2_inv_1
XFILLER_11_1035 VPWR VGND sg13g2_fill_1
XFILLER_2_1225 VPWR VGND sg13g2_decap_8
XFILLER_1_531 VPWR VGND sg13g2_decap_4
XFILLER_3_49 VPWR VGND sg13g2_decap_8
X_0981_ Tile_X1Y0_FrameStrobe[5] Tile_X1Y0_FrameStrobe_O[5] VPWR VGND sg13g2_buf_1
XFILLER_9_686 VPWR VGND sg13g2_fill_1
XFILLER_10_1090 VPWR VGND sg13g2_fill_1
X_0415_ Tile_X2Y0_S2MID[2] WDATA_top12 Tile_X2Y0_S_OBI_right.Inst_S_OBI_right_ConfigMem.Inst_frame1_bit3.Q
+ Tile_X2Y0_S_OBI_right.Inst_S_OBI_right_switch_matrix.N2BEG5 VPWR VGND sg13g2_mux2_1
XFILLER_4_391 VPWR VGND sg13g2_decap_8
XFILLER_5_892 VPWR VGND sg13g2_decap_8
X_0346_ Tile_X1Y0_SS4END[5] WDATA_top25 Tile_X1Y0_S_OBI_middle.Inst_S_OBI_middle_ConfigMem.Inst_frame1_bit28.Q
+ Tile_X1Y0_S_OBI_middle.Inst_S_OBI_middle_switch_matrix.NN4BEG10 VPWR VGND sg13g2_mux2_1
X_0277_ VPWR _0050_ Tile_X2Y0_S_OBI_right.Inst_S_OBI_right_ConfigMem.Inst_frame0_bit29.Q
+ VGND sg13g2_inv_1
XFILLER_10_107 VPWR VGND sg13g2_fill_1
XFILLER_2_317 VPWR VGND sg13g2_decap_8
XFILLER_3_818 VPWR VGND sg13g2_decap_8
XFILLER_2_1011 VPWR VGND sg13g2_decap_8
XFILLER_4_1309 VPWR VGND sg13g2_fill_2
XFILLER_6_623 VPWR VGND sg13g2_fill_1
X_0964_ Tile_X0Y0_S_OBI_left.Inst_S_OBI_left_switch_matrix.NN4BEG5 Tile_X0Y0_NN4BEG[5]
+ VPWR VGND sg13g2_buf_1
XFILLER_9_450 VPWR VGND sg13g2_decap_8
X_0895_ Tile_X0Y0_FrameData[30] Tile_X0Y0_FrameStrobe[2] Tile_X0Y0_S_OBI_left.Inst_S_OBI_left_ConfigMem.Inst_frame2_bit30.Q
+ VPWR VGND sg13g2_dlhq_1
X_0329_ Tile_X1Y0_S4END[6] WDATA_top26 Tile_X1Y0_S_OBI_middle.Inst_S_OBI_middle_ConfigMem.Inst_frame1_bit11.Q
+ Tile_X1Y0_S_OBI_middle.Inst_S_OBI_middle_switch_matrix.N4BEG9 VPWR VGND sg13g2_mux2_1
XFILLER_4_70 VPWR VGND sg13g2_decap_8
XFILLER_11_416 VPWR VGND sg13g2_decap_8
XFILLER_2_147 VPWR VGND sg13g2_decap_8
XFILLER_2_169 VPWR VGND sg13g2_decap_8
XFILLER_3_604 VPWR VGND sg13g2_decap_8
XFILLER_8_1286 VPWR VGND sg13g2_decap_8
XFILLER_0_28 VPWR VGND sg13g2_decap_8
X_0680_ Tile_X0Y0_FrameData[25] Tile_X1Y0_FrameStrobe[0] Tile_X1Y0_S_OBI_middle.Inst_S_OBI_middle_ConfigMem.Inst_frame0_bit25.Q
+ VPWR VGND sg13g2_dlhq_1
XFILLER_10_460 VPWR VGND sg13g2_decap_8
XFILLER_7_943 VPWR VGND sg13g2_decap_8
XFILLER_6_442 VPWR VGND sg13g2_decap_8
XFILLER_2_681 VPWR VGND sg13g2_fill_2
X_1094_ Tile_X2Y0_FrameStrobe[13] Tile_X2Y0_FrameStrobe_O[13] VPWR VGND sg13g2_buf_1
X_0947_ Tile_X0Y0_S_OBI_left.Inst_S_OBI_left_switch_matrix.N4BEG4 Tile_X0Y0_N4BEG[4]
+ VPWR VGND sg13g2_buf_1
X_0878_ Tile_X0Y0_FrameData[15] Tile_X0Y0_FrameStrobe[1] Tile_X0Y0_S_OBI_left.Inst_S_OBI_left_ConfigMem.Inst_frame1_bit15.Q
+ VPWR VGND sg13g2_dlhq_1
XFILLER_11_213 VPWR VGND sg13g2_fill_1
XFILLER_3_401 VPWR VGND sg13g2_decap_8
XFILLER_4_902 VPWR VGND sg13g2_decap_8
XFILLER_3_478 VPWR VGND sg13g2_decap_8
XFILLER_4_979 VPWR VGND sg13g2_decap_8
X_0801_ Tile_X0Y0_FrameData[22] Tile_X2Y0_FrameStrobe[1] Tile_X2Y0_S_OBI_right.Inst_S_OBI_right_ConfigMem.Inst_frame1_bit22.Q
+ VPWR VGND sg13g2_dlhq_1
X_0663_ VPWR VGND Tile_X0Y0_S_OBI_left.Inst_S_OBI_left_ConfigMem.Inst_frame0_bit28.Q
+ _0069_ _0017_ _0015_ _0018_ _0016_ sg13g2_a221oi_1
X_0732_ Tile_X0Y0_FrameData[5] Tile_X1Y0_FrameStrobe[1] Tile_X1Y0_S_OBI_middle.Inst_S_OBI_middle_ConfigMem.Inst_frame1_bit5.Q
+ VPWR VGND sg13g2_dlhq_1
X_0594_ VGND VPWR Tile_X0Y0_S4END[7] Tile_X0Y0_S_OBI_left.Inst_S_OBI_left_ConfigMem.Inst_frame0_bit6.Q
+ _0210_ Tile_X0Y0_S_OBI_left.Inst_S_OBI_left_ConfigMem.Inst_frame0_bit7.Q sg13g2_a21oi_1
X_1146_ Tile_X2Y0_S_OBI_right.Inst_S_OBI_right_switch_matrix.NN4BEG9 Tile_X2Y0_NN4BEG[9]
+ VPWR VGND sg13g2_buf_1
X_1077_ Tile_X0Y0_FrameData[28] Tile_X2Y0_FrameData_O[28] VPWR VGND sg13g2_buf_1
XFILLER_1_93 VPWR VGND sg13g2_decap_8
XFILLER_4_209 VPWR VGND sg13g2_fill_1
XFILLER_1_916 VPWR VGND sg13g2_decap_4
XFILLER_0_459 VPWR VGND sg13g2_decap_8
XFILLER_8_548 VPWR VGND sg13g2_fill_2
XANTENNA_9 VPWR VGND Tile_X0Y0_FrameData[0] sg13g2_antennanp
XFILLER_6_49 VPWR VGND sg13g2_decap_8
X_1000_ Tile_X1Y0_S_OBI_middle.Inst_S_OBI_middle_switch_matrix.N2BEG0 Tile_X1Y0_N2BEG[0]
+ VPWR VGND sg13g2_buf_1
X_0715_ Tile_X0Y0_FrameData[22] Tile_X1Y0_FrameStrobe[1] Tile_X1Y0_S_OBI_middle.Inst_S_OBI_middle_ConfigMem.Inst_frame1_bit22.Q
+ VPWR VGND sg13g2_dlhq_1
X_0577_ _0197_ VPWR Tile_X0Y0_S_OBI_left.Inst_S_OBI_left_switch_matrix.NN4BEG6 VGND
+ _0051_ Tile_X0Y0_S_OBI_left.Inst_S_OBI_left_ConfigMem.Inst_frame1_bit30.Q sg13g2_o21ai_1
X_0646_ _0252_ _0249_ _0002_ RDATA_top6 VPWR VGND sg13g2_a21o_1
X_1129_ Tile_X2Y0_S_OBI_right.Inst_S_OBI_right_switch_matrix.N4BEG8 Tile_X2Y0_N4BEG[8]
+ VPWR VGND sg13g2_buf_1
XFILLER_0_1186 VPWR VGND sg13g2_decap_8
XFILLER_1_713 VPWR VGND sg13g2_decap_8
XFILLER_7_1329 VPWR VGND sg13g2_fill_2
XFILLER_7_1307 VPWR VGND sg13g2_fill_1
XFILLER_0_289 VPWR VGND sg13g2_decap_8
X_0500_ Tile_X2Y0_S_OBI_right.Inst_S_OBI_right_ConfigMem.Inst_frame0_bit19.Q VPWR
+ _0162_ VGND Tile_X2Y0_S_OBI_right.Inst_S_OBI_right_ConfigMem.Inst_frame0_bit18.Q
+ _0046_ sg13g2_o21ai_1
X_0362_ _0080_ Tile_X1Y0_S4END[3] Tile_X1Y0_S_OBI_middle.Inst_S_OBI_middle_ConfigMem.Inst_frame0_bit14.Q
+ VPWR VGND sg13g2_nand2b_1
X_0431_ Tile_X2Y0_S4END[10] WDATA_top14 Tile_X2Y0_S_OBI_right.Inst_S_OBI_right_ConfigMem.Inst_frame1_bit19.Q
+ Tile_X2Y0_S_OBI_right.Inst_S_OBI_right_switch_matrix.N4BEG5 VPWR VGND sg13g2_mux2_1
X_0293_ VPWR _0066_ Tile_X0Y0_SS4END[5] VGND sg13g2_inv_1
XFILLER_7_70 VPWR VGND sg13g2_fill_1
X_0629_ Tile_X0Y0_S2MID[5] Tile_X0Y0_S_OBI_left.Inst_S_OBI_left_ConfigMem.Inst_frame0_bit18.Q
+ Tile_X0Y0_S_OBI_left.Inst_S_OBI_left_ConfigMem.Inst_frame0_bit19.Q _0241_ VPWR VGND
+ sg13g2_nor3_1
XFILLER_2_1204 VPWR VGND sg13g2_decap_8
XFILLER_5_304 VPWR VGND sg13g2_decap_8
XFILLER_1_565 VPWR VGND sg13g2_decap_4
XFILLER_3_28 VPWR VGND sg13g2_decap_8
XFILLER_5_348 VPWR VGND sg13g2_decap_4
XFILLER_5_359 VPWR VGND sg13g2_fill_1
X_0980_ Tile_X1Y0_FrameStrobe[4] Tile_X1Y0_FrameStrobe_O[4] VPWR VGND sg13g2_buf_1
XFILLER_4_370 VPWR VGND sg13g2_decap_8
XFILLER_5_871 VPWR VGND sg13g2_decap_8
X_0414_ Tile_X2Y0_S2MID[3] WDATA_top13 Tile_X2Y0_S_OBI_right.Inst_S_OBI_right_ConfigMem.Inst_frame1_bit2.Q
+ Tile_X2Y0_S_OBI_right.Inst_S_OBI_right_switch_matrix.N2BEG4 VPWR VGND sg13g2_mux2_1
X_0345_ Tile_X1Y0_SS4END[6] WDATA_top26 Tile_X1Y0_S_OBI_middle.Inst_S_OBI_middle_ConfigMem.Inst_frame1_bit27.Q
+ Tile_X1Y0_S_OBI_middle.Inst_S_OBI_middle_switch_matrix.NN4BEG9 VPWR VGND sg13g2_mux2_1
X_0276_ VPWR _0049_ Tile_X2Y0_S_OBI_right.Inst_S_OBI_right_ConfigMem.Inst_frame0_bit26.Q
+ VGND sg13g2_inv_1
XFILLER_1_1292 VPWR VGND sg13g2_decap_8
XFILLER_6_668 VPWR VGND sg13g2_decap_8
XFILLER_1_384 VPWR VGND sg13g2_decap_8
XFILLER_2_885 VPWR VGND sg13g2_decap_8
X_0963_ Tile_X0Y0_S_OBI_left.Inst_S_OBI_left_switch_matrix.NN4BEG4 Tile_X0Y0_NN4BEG[4]
+ VPWR VGND sg13g2_buf_1
X_0894_ Tile_X0Y0_FrameData[31] Tile_X0Y0_FrameStrobe[2] Tile_X0Y0_S_OBI_left.Inst_S_OBI_left_ConfigMem.Inst_frame2_bit31.Q
+ VPWR VGND sg13g2_dlhq_1
X_0328_ Tile_X1Y0_S4END[7] WDATA_top27 Tile_X1Y0_S_OBI_middle.Inst_S_OBI_middle_ConfigMem.Inst_frame1_bit10.Q
+ Tile_X1Y0_S_OBI_middle.Inst_S_OBI_middle_switch_matrix.N4BEG8 VPWR VGND sg13g2_mux2_1
X_0259_ VPWR _0032_ Tile_X2Y0_SS4END[8] VGND sg13g2_inv_1
XFILLER_2_126 VPWR VGND sg13g2_decap_8
XFILLER_7_922 VPWR VGND sg13g2_decap_8
XFILLER_2_660 VPWR VGND sg13g2_decap_8
XFILLER_6_421 VPWR VGND sg13g2_decap_8
XFILLER_6_498 VPWR VGND sg13g2_decap_8
X_1093_ Tile_X2Y0_FrameStrobe[12] Tile_X2Y0_FrameStrobe_O[12] VPWR VGND sg13g2_buf_1
X_0877_ Tile_X0Y0_FrameData[16] Tile_X0Y0_FrameStrobe[1] Tile_X0Y0_S_OBI_left.Inst_S_OBI_left_ConfigMem.Inst_frame1_bit16.Q
+ VPWR VGND sg13g2_dlhq_1
X_0946_ Tile_X0Y0_S_OBI_left.Inst_S_OBI_left_switch_matrix.N4BEG3 Tile_X0Y0_N4BEG[3]
+ VPWR VGND sg13g2_buf_1
XFILLER_3_1195 VPWR VGND sg13g2_decap_8
XFILLER_8_719 VPWR VGND sg13g2_fill_1
XFILLER_3_457 VPWR VGND sg13g2_decap_8
XFILLER_4_958 VPWR VGND sg13g2_decap_8
XFILLER_8_1040 VPWR VGND sg13g2_fill_1
XFILLER_11_770 VPWR VGND sg13g2_fill_1
X_0731_ Tile_X0Y0_FrameData[6] Tile_X1Y0_FrameStrobe[1] Tile_X1Y0_S_OBI_middle.Inst_S_OBI_middle_ConfigMem.Inst_frame1_bit6.Q
+ VPWR VGND sg13g2_dlhq_1
X_0800_ Tile_X0Y0_FrameData[23] Tile_X2Y0_FrameStrobe[1] Tile_X2Y0_S_OBI_right.Inst_S_OBI_right_ConfigMem.Inst_frame1_bit23.Q
+ VPWR VGND sg13g2_dlhq_1
X_0662_ Tile_X0Y0_SS4END[14] Tile_X0Y0_S_OBI_left.Inst_S_OBI_left_ConfigMem.Inst_frame0_bit27.Q
+ _0017_ VPWR VGND sg13g2_nor2_1
X_0593_ _0209_ Tile_X0Y0_S2END[1] Tile_X0Y0_S_OBI_left.Inst_S_OBI_left_ConfigMem.Inst_frame0_bit6.Q
+ VPWR VGND sg13g2_nand2b_1
XFILLER_1_83 VPWR VGND sg13g2_decap_4
X_1145_ Tile_X2Y0_S_OBI_right.Inst_S_OBI_right_switch_matrix.NN4BEG8 Tile_X2Y0_NN4BEG[8]
+ VPWR VGND sg13g2_buf_1
X_1076_ Tile_X0Y0_FrameData[27] Tile_X2Y0_FrameData_O[27] VPWR VGND sg13g2_buf_1
X_0929_ Tile_X0Y0_S_OBI_left.Inst_S_OBI_left_switch_matrix.N2BEG2 Tile_X0Y0_N2BEG[2]
+ VPWR VGND sg13g2_buf_1
XFILLER_0_438 VPWR VGND sg13g2_decap_8
XFILLER_6_28 VPWR VGND sg13g2_decap_8
XFILLER_4_799 VPWR VGND sg13g2_decap_4
X_0714_ Tile_X0Y0_FrameData[23] Tile_X1Y0_FrameStrobe[1] Tile_X1Y0_S_OBI_middle.Inst_S_OBI_middle_ConfigMem.Inst_frame1_bit23.Q
+ VPWR VGND sg13g2_dlhq_1
X_0645_ VPWR VGND Tile_X0Y0_S_OBI_left.Inst_S_OBI_left_ConfigMem.Inst_frame0_bit22.Q
+ _0067_ _0001_ _0253_ _0002_ _0000_ sg13g2_a221oi_1
X_0576_ _0197_ ADDR_top3 Tile_X0Y0_S_OBI_left.Inst_S_OBI_left_ConfigMem.Inst_frame1_bit30.Q
+ VPWR VGND sg13g2_nand2_1
X_1128_ Tile_X2Y0_S_OBI_right.Inst_S_OBI_right_switch_matrix.N4BEG7 Tile_X2Y0_N4BEG[7]
+ VPWR VGND sg13g2_buf_1
XFILLER_0_1165 VPWR VGND sg13g2_decap_8
X_1059_ Tile_X0Y0_FrameData[10] Tile_X2Y0_FrameData_O[10] VPWR VGND sg13g2_buf_1
XFILLER_5_519 VPWR VGND sg13g2_decap_8
XFILLER_0_268 VPWR VGND sg13g2_decap_8
XFILLER_9_803 VPWR VGND sg13g2_fill_2
X_0430_ Tile_X2Y0_S4END[11] WDATA_top15 Tile_X2Y0_S_OBI_right.Inst_S_OBI_right_ConfigMem.Inst_frame1_bit18.Q
+ Tile_X2Y0_S_OBI_right.Inst_S_OBI_right_switch_matrix.N4BEG4 VPWR VGND sg13g2_mux2_1
X_0361_ Tile_X1Y0_S_OBI_middle.Inst_S_OBI_middle_ConfigMem.Inst_frame0_bit14.Q VPWR
+ _0079_ VGND Tile_X1Y0_SS4END[3] Tile_X1Y0_S_OBI_middle.Inst_S_OBI_middle_ConfigMem.Inst_frame0_bit15.Q
+ sg13g2_o21ai_1
XFILLER_4_574 VPWR VGND sg13g2_decap_8
X_0292_ VPWR _0065_ Tile_X0Y0_S_OBI_left.Inst_S_OBI_left_ConfigMem.Inst_frame0_bit17.Q
+ VGND sg13g2_inv_1
X_0628_ _0240_ _0237_ _0236_ RDATA_top4 VPWR VGND sg13g2_a21o_1
X_0559_ Tile_X0Y0_S2END[0] ADDR_top0 Tile_X0Y0_S_OBI_left.Inst_S_OBI_left_ConfigMem.Inst_frame1_bit13.Q
+ Tile_X0Y0_S_OBI_left.Inst_S_OBI_left_switch_matrix.N2BEGb7 VPWR VGND sg13g2_mux2_1
XFILLER_6_1330 VPWR VGND sg13g2_fill_2
XFILLER_6_817 VPWR VGND sg13g2_decap_4
XFILLER_7_1138 VPWR VGND sg13g2_fill_1
XFILLER_1_500 VPWR VGND sg13g2_decap_4
X_0344_ Tile_X1Y0_SS4END[7] WDATA_top27 Tile_X1Y0_S_OBI_middle.Inst_S_OBI_middle_ConfigMem.Inst_frame1_bit26.Q
+ Tile_X1Y0_S_OBI_middle.Inst_S_OBI_middle_switch_matrix.NN4BEG8 VPWR VGND sg13g2_mux2_1
X_0413_ Tile_X2Y0_S2MID[4] WDATA_top14 Tile_X2Y0_S_OBI_right.Inst_S_OBI_right_ConfigMem.Inst_frame1_bit1.Q
+ Tile_X2Y0_S_OBI_right.Inst_S_OBI_right_switch_matrix.N2BEG3 VPWR VGND sg13g2_mux2_1
X_0275_ VPWR _0048_ Tile_X2Y0_S_OBI_right.Inst_S_OBI_right_ConfigMem.Inst_frame0_bit23.Q
+ VGND sg13g2_inv_1
XFILLER_1_1271 VPWR VGND sg13g2_decap_8
XFILLER_2_308 VPWR VGND sg13g2_decap_4
XFILLER_6_614 VPWR VGND sg13g2_fill_1
XFILLER_1_363 VPWR VGND sg13g2_decap_8
XFILLER_1_341 VPWR VGND sg13g2_decap_4
XFILLER_2_864 VPWR VGND sg13g2_decap_8
X_0962_ Tile_X0Y0_S_OBI_left.Inst_S_OBI_left_switch_matrix.NN4BEG3 Tile_X0Y0_NN4BEG[3]
+ VPWR VGND sg13g2_buf_1
XFILLER_9_485 VPWR VGND sg13g2_decap_8
X_0893_ Tile_X0Y0_FrameData[0] Tile_X0Y0_FrameStrobe[1] Tile_X0Y0_S_OBI_left.Inst_S_OBI_left_ConfigMem.Inst_frame1_bit0.Q
+ VPWR VGND sg13g2_dlhq_1
X_0327_ Tile_X1Y0_S4END[8] WDATA_top28 Tile_X1Y0_S_OBI_middle.Inst_S_OBI_middle_ConfigMem.Inst_frame1_bit9.Q
+ Tile_X1Y0_S_OBI_middle.Inst_S_OBI_middle_switch_matrix.N4BEG7 VPWR VGND sg13g2_mux2_1
XFILLER_3_1300 VPWR VGND sg13g2_decap_8
X_0258_ VPWR _0031_ Tile_X2Y0_SS4END[9] VGND sg13g2_inv_1
XFILLER_2_105 VPWR VGND sg13g2_decap_8
XFILLER_3_7 VPWR VGND sg13g2_decap_8
XFILLER_10_440 VPWR VGND sg13g2_fill_1
XFILLER_9_28 VPWR VGND sg13g2_decap_8
XFILLER_7_901 VPWR VGND sg13g2_decap_8
XFILLER_6_400 VPWR VGND sg13g2_decap_8
XFILLER_7_978 VPWR VGND sg13g2_decap_8
XFILLER_6_477 VPWR VGND sg13g2_decap_8
X_1092_ Tile_X2Y0_FrameStrobe[11] Tile_X2Y0_FrameStrobe_O[11] VPWR VGND sg13g2_buf_1
XFILLER_1_182 VPWR VGND sg13g2_decap_8
X_0945_ Tile_X0Y0_S_OBI_left.Inst_S_OBI_left_switch_matrix.N4BEG2 Tile_X0Y0_N4BEG[2]
+ VPWR VGND sg13g2_buf_1
X_0876_ Tile_X0Y0_FrameData[17] Tile_X0Y0_FrameStrobe[1] Tile_X0Y0_S_OBI_left.Inst_S_OBI_left_ConfigMem.Inst_frame1_bit17.Q
+ VPWR VGND sg13g2_dlhq_1
XFILLER_3_436 VPWR VGND sg13g2_decap_8
XFILLER_4_937 VPWR VGND sg13g2_decap_8
XFILLER_11_793 VPWR VGND sg13g2_decap_8
X_0661_ VGND VPWR Tile_X0Y0_S4END[14] Tile_X0Y0_S_OBI_left.Inst_S_OBI_left_ConfigMem.Inst_frame0_bit27.Q
+ _0016_ Tile_X0Y0_S_OBI_left.Inst_S_OBI_left_ConfigMem.Inst_frame0_bit28.Q sg13g2_a21oi_1
X_0730_ Tile_X0Y0_FrameData[7] Tile_X1Y0_FrameStrobe[1] Tile_X1Y0_S_OBI_middle.Inst_S_OBI_middle_ConfigMem.Inst_frame1_bit7.Q
+ VPWR VGND sg13g2_dlhq_1
XFILLER_6_241 VPWR VGND sg13g2_fill_1
X_0592_ _0208_ _0205_ _0204_ RDATA_top0 VPWR VGND sg13g2_a21o_1
X_1144_ Tile_X2Y0_S_OBI_right.Inst_S_OBI_right_switch_matrix.NN4BEG7 Tile_X2Y0_NN4BEG[7]
+ VPWR VGND sg13g2_buf_1
X_1075_ Tile_X0Y0_FrameData[26] Tile_X2Y0_FrameData_O[26] VPWR VGND sg13g2_buf_1
XFILLER_0_417 VPWR VGND sg13g2_decap_8
X_0859_ Tile_X0Y0_FrameData[2] Tile_X0Y0_FrameStrobe[0] Tile_X0Y0_S_OBI_left.Inst_S_OBI_left_ConfigMem.Inst_frame0_bit2.Q
+ VPWR VGND sg13g2_dlhq_1
X_0928_ Tile_X0Y0_S_OBI_left.Inst_S_OBI_left_switch_matrix.N2BEG1 Tile_X0Y0_N2BEG[1]
+ VPWR VGND sg13g2_buf_1
XFILLER_5_1269 VPWR VGND sg13g2_decap_8
XFILLER_0_984 VPWR VGND sg13g2_decap_8
X_0713_ Tile_X0Y0_FrameData[24] Tile_X1Y0_FrameStrobe[1] Tile_X1Y0_S_OBI_middle.Inst_S_OBI_middle_ConfigMem.Inst_frame1_bit24.Q
+ VPWR VGND sg13g2_dlhq_1
X_0644_ Tile_X0Y0_SS4END[12] Tile_X0Y0_S_OBI_left.Inst_S_OBI_left_ConfigMem.Inst_frame0_bit21.Q
+ _0001_ VPWR VGND sg13g2_nor2_1
X_0575_ Tile_X0Y0_SS4END[10] ADDR_top4 Tile_X0Y0_S_OBI_left.Inst_S_OBI_left_ConfigMem.Inst_frame1_bit29.Q
+ Tile_X0Y0_S_OBI_left.Inst_S_OBI_left_switch_matrix.NN4BEG5 VPWR VGND sg13g2_mux2_1
X_1127_ Tile_X2Y0_S_OBI_right.Inst_S_OBI_right_switch_matrix.N4BEG6 Tile_X2Y0_N4BEG[6]
+ VPWR VGND sg13g2_buf_1
XFILLER_0_1144 VPWR VGND sg13g2_decap_8
X_1058_ Tile_X0Y0_FrameData[9] Tile_X2Y0_FrameData_O[9] VPWR VGND sg13g2_buf_1
XFILLER_4_1291 VPWR VGND sg13g2_decap_8
XFILLER_0_203 VPWR VGND sg13g2_decap_8
XFILLER_0_214 VPWR VGND sg13g2_fill_2
XFILLER_0_247 VPWR VGND sg13g2_decap_8
XFILLER_10_1296 VPWR VGND sg13g2_decap_8
X_0291_ VPWR _0064_ Tile_X0Y0_SS4END[4] VGND sg13g2_inv_1
XFILLER_0_781 VPWR VGND sg13g2_decap_8
X_0360_ _0077_ VPWR RDATA_top22 VGND Tile_X1Y0_S_OBI_middle.Inst_S_OBI_middle_ConfigMem.Inst_frame0_bit13.Q
+ _0078_ sg13g2_o21ai_1
X_0627_ Tile_X0Y0_S_OBI_left.Inst_S_OBI_left_ConfigMem.Inst_frame0_bit14.Q _0238_
+ _0239_ _0240_ VPWR VGND sg13g2_nor3_1
X_0558_ Tile_X0Y0_S2END[1] ADDR_top1 Tile_X0Y0_S_OBI_left.Inst_S_OBI_left_ConfigMem.Inst_frame1_bit12.Q
+ Tile_X0Y0_S_OBI_left.Inst_S_OBI_left_switch_matrix.N2BEGb6 VPWR VGND sg13g2_mux2_1
XFILLER_7_380 VPWR VGND sg13g2_decap_8
X_0489_ Tile_X2Y0_S_OBI_right.Inst_S_OBI_right_ConfigMem.Inst_frame0_bit14.Q _0150_
+ _0151_ _0152_ VPWR VGND sg13g2_nor3_1
XFILLER_2_1239 VPWR VGND sg13g2_decap_8
XFILLER_10_869 VPWR VGND sg13g2_fill_2
XFILLER_1_589 VPWR VGND sg13g2_decap_8
X_0412_ Tile_X2Y0_S2MID[5] WDATA_top15 Tile_X2Y0_S_OBI_right.Inst_S_OBI_right_ConfigMem.Inst_frame1_bit0.Q
+ Tile_X2Y0_S_OBI_right.Inst_S_OBI_right_switch_matrix.N2BEG2 VPWR VGND sg13g2_mux2_1
XFILLER_10_1082 VPWR VGND sg13g2_fill_2
XFILLER_8_199 VPWR VGND sg13g2_decap_8
X_0343_ Tile_X1Y0_SS4END[8] WDATA_top28 Tile_X1Y0_S_OBI_middle.Inst_S_OBI_middle_ConfigMem.Inst_frame1_bit25.Q
+ Tile_X1Y0_S_OBI_middle.Inst_S_OBI_middle_switch_matrix.NN4BEG7 VPWR VGND sg13g2_mux2_1
X_0274_ VPWR _0047_ Tile_X2Y0_S_OBI_right.Inst_S_OBI_right_ConfigMem.Inst_frame0_bit20.Q
+ VGND sg13g2_inv_1
XFILLER_1_1250 VPWR VGND sg13g2_decap_8
XFILLER_2_1025 VPWR VGND sg13g2_decap_8
XFILLER_2_1047 VPWR VGND sg13g2_decap_8
XFILLER_2_1069 VPWR VGND sg13g2_decap_4
XFILLER_6_1150 VPWR VGND sg13g2_decap_8
XFILLER_5_103 VPWR VGND sg13g2_fill_2
XFILLER_10_688 VPWR VGND sg13g2_fill_2
XFILLER_2_843 VPWR VGND sg13g2_decap_8
X_0961_ Tile_X0Y0_S_OBI_left.Inst_S_OBI_left_switch_matrix.NN4BEG2 Tile_X0Y0_NN4BEG[2]
+ VPWR VGND sg13g2_buf_1
XFILLER_9_464 VPWR VGND sg13g2_decap_8
X_0892_ Tile_X0Y0_FrameData[1] Tile_X0Y0_FrameStrobe[1] Tile_X0Y0_S_OBI_left.Inst_S_OBI_left_ConfigMem.Inst_frame1_bit1.Q
+ VPWR VGND sg13g2_dlhq_1
XFILLER_4_84 VPWR VGND sg13g2_decap_8
XFILLER_5_670 VPWR VGND sg13g2_fill_1
X_0326_ Tile_X1Y0_S4END[9] WDATA_top29 Tile_X1Y0_S_OBI_middle.Inst_S_OBI_middle_ConfigMem.Inst_frame1_bit8.Q
+ Tile_X1Y0_S_OBI_middle.Inst_S_OBI_middle_switch_matrix.N4BEG6 VPWR VGND sg13g2_mux2_1
X_0257_ VPWR _0030_ Tile_X1Y0_S_OBI_middle.Inst_S_OBI_middle_ConfigMem.Inst_frame0_bit5.Q
+ VGND sg13g2_inv_1
XFILLER_3_618 VPWR VGND sg13g2_decap_8
XFILLER_3_629 VPWR VGND sg13g2_fill_2
XFILLER_8_1212 VPWR VGND sg13g2_fill_2
XFILLER_4_1109 VPWR VGND sg13g2_fill_1
XFILLER_11_942 VPWR VGND sg13g2_fill_1
XFILLER_11_931 VPWR VGND sg13g2_decap_8
XFILLER_10_474 VPWR VGND sg13g2_decap_8
XFILLER_10_452 VPWR VGND sg13g2_decap_4
XFILLER_7_957 VPWR VGND sg13g2_decap_8
XFILLER_6_456 VPWR VGND sg13g2_decap_8
XFILLER_1_161 VPWR VGND sg13g2_decap_8
X_1091_ Tile_X2Y0_FrameStrobe[10] Tile_X2Y0_FrameStrobe_O[10] VPWR VGND sg13g2_buf_1
X_0944_ Tile_X0Y0_S_OBI_left.Inst_S_OBI_left_switch_matrix.N4BEG1 Tile_X0Y0_N4BEG[1]
+ VPWR VGND sg13g2_buf_1
X_0875_ Tile_X0Y0_FrameData[18] Tile_X0Y0_FrameStrobe[1] Tile_X0Y0_S_OBI_left.Inst_S_OBI_left_ConfigMem.Inst_frame1_bit18.Q
+ VPWR VGND sg13g2_dlhq_1
X_0309_ Tile_X1Y0_S2MID[1] BE_top2 Tile_X1Y0_S_OBI_middle.Inst_S_OBI_middle_ConfigMem.Inst_frame2_bit24.Q
+ Tile_X1Y0_S_OBI_middle.Inst_S_OBI_middle_switch_matrix.N2BEG6 VPWR VGND sg13g2_mux2_1
XFILLER_4_916 VPWR VGND sg13g2_decap_8
XFILLER_3_415 VPWR VGND sg13g2_decap_8
X_0660_ _0015_ Tile_X0Y0_S1END[2] Tile_X0Y0_S_OBI_left.Inst_S_OBI_left_ConfigMem.Inst_frame0_bit27.Q
+ VPWR VGND sg13g2_nand2b_1
XFILLER_7_787 VPWR VGND sg13g2_decap_8
X_0591_ Tile_X0Y0_S_OBI_left.Inst_S_OBI_left_ConfigMem.Inst_frame0_bit2.Q _0206_ _0207_
+ _0208_ VPWR VGND sg13g2_nor3_1
XFILLER_6_264 VPWR VGND sg13g2_fill_2
XFILLER_2_492 VPWR VGND sg13g2_decap_8
XFILLER_3_993 VPWR VGND sg13g2_decap_8
X_1074_ Tile_X0Y0_FrameData[25] Tile_X2Y0_FrameData_O[25] VPWR VGND sg13g2_buf_1
X_1143_ Tile_X2Y0_S_OBI_right.Inst_S_OBI_right_switch_matrix.NN4BEG6 Tile_X2Y0_NN4BEG[6]
+ VPWR VGND sg13g2_buf_1
XFILLER_1_52 VPWR VGND sg13g2_decap_8
XFILLER_0_1326 VPWR VGND sg13g2_decap_4
X_0927_ Tile_X0Y0_S_OBI_left.Inst_S_OBI_left_switch_matrix.N2BEG0 Tile_X0Y0_N2BEG[0]
+ VPWR VGND sg13g2_buf_1
X_0789_ Tile_X0Y0_FrameData[2] Tile_X2Y0_FrameStrobe[0] Tile_X2Y0_S_OBI_right.Inst_S_OBI_right_ConfigMem.Inst_frame0_bit2.Q
+ VPWR VGND sg13g2_dlhq_1
X_0858_ Tile_X0Y0_FrameData[3] Tile_X0Y0_FrameStrobe[0] Tile_X0Y0_S_OBI_left.Inst_S_OBI_left_ConfigMem.Inst_frame0_bit3.Q
+ VPWR VGND sg13g2_dlhq_1
XFILLER_5_1237 VPWR VGND sg13g2_fill_1
XFILLER_5_1248 VPWR VGND sg13g2_decap_8
XFILLER_0_963 VPWR VGND sg13g2_decap_8
XFILLER_11_1209 VPWR VGND sg13g2_fill_2
X_0712_ Tile_X0Y0_FrameData[25] Tile_X1Y0_FrameStrobe[1] Tile_X1Y0_S_OBI_middle.Inst_S_OBI_middle_ConfigMem.Inst_frame1_bit25.Q
+ VPWR VGND sg13g2_dlhq_1
X_0574_ Tile_X0Y0_SS4END[11] ADDR_top5 Tile_X0Y0_S_OBI_left.Inst_S_OBI_left_ConfigMem.Inst_frame1_bit28.Q
+ Tile_X0Y0_S_OBI_left.Inst_S_OBI_left_switch_matrix.NN4BEG4 VPWR VGND sg13g2_mux2_1
XFILLER_3_790 VPWR VGND sg13g2_decap_8
X_0643_ VGND VPWR Tile_X0Y0_S4END[12] Tile_X0Y0_S_OBI_left.Inst_S_OBI_left_ConfigMem.Inst_frame0_bit21.Q
+ _0000_ Tile_X0Y0_S_OBI_left.Inst_S_OBI_left_ConfigMem.Inst_frame0_bit22.Q sg13g2_a21oi_1
X_1126_ Tile_X2Y0_S_OBI_right.Inst_S_OBI_right_switch_matrix.N4BEG5 Tile_X2Y0_N4BEG[5]
+ VPWR VGND sg13g2_buf_1
XFILLER_4_1270 VPWR VGND sg13g2_decap_8
X_1057_ Tile_X0Y0_FrameData[8] Tile_X2Y0_FrameData_O[8] VPWR VGND sg13g2_buf_1
XFILLER_1_749 VPWR VGND sg13g2_decap_8
XFILLER_1_727 VPWR VGND sg13g2_decap_8
XFILLER_0_226 VPWR VGND sg13g2_decap_8
XFILLER_4_510 VPWR VGND sg13g2_decap_8
XFILLER_11_7 VPWR VGND sg13g2_decap_8
X_0290_ VPWR _0063_ Tile_X0Y0_S_OBI_left.Inst_S_OBI_left_ConfigMem.Inst_frame0_bit14.Q
+ VGND sg13g2_inv_1
XFILLER_0_760 VPWR VGND sg13g2_decap_8
XFILLER_8_871 VPWR VGND sg13g2_decap_8
X_0626_ Tile_X0Y0_S4END[4] Tile_X0Y0_S_OBI_left.Inst_S_OBI_left_ConfigMem.Inst_frame0_bit15.Q
+ _0239_ VPWR VGND sg13g2_nor2b_1
X_0557_ Tile_X0Y0_S2END[2] ADDR_top2 Tile_X0Y0_S_OBI_left.Inst_S_OBI_left_ConfigMem.Inst_frame1_bit11.Q
+ Tile_X0Y0_S_OBI_left.Inst_S_OBI_left_switch_matrix.N2BEGb5 VPWR VGND sg13g2_mux2_1
X_1109_ Tile_X2Y0_S_OBI_right.Inst_S_OBI_right_switch_matrix.N2BEG4 Tile_X2Y0_N2BEG[4]
+ VPWR VGND sg13g2_buf_1
X_0488_ Tile_X2Y0_S4END[4] Tile_X2Y0_S_OBI_right.Inst_S_OBI_right_ConfigMem.Inst_frame0_bit15.Q
+ _0151_ VPWR VGND sg13g2_nor2b_1
XFILLER_2_1218 VPWR VGND sg13g2_decap_8
XFILLER_1_535 VPWR VGND sg13g2_fill_2
XFILLER_1_524 VPWR VGND sg13g2_decap_8
X_0342_ Tile_X1Y0_SS4END[9] WDATA_top29 Tile_X1Y0_S_OBI_middle.Inst_S_OBI_middle_ConfigMem.Inst_frame1_bit24.Q
+ Tile_X1Y0_S_OBI_middle.Inst_S_OBI_middle_switch_matrix.NN4BEG6 VPWR VGND sg13g2_mux2_1
XFILLER_4_384 VPWR VGND sg13g2_decap_8
XFILLER_5_885 VPWR VGND sg13g2_decap_8
X_0411_ Tile_X2Y0_S2MID[6] WDATA_top16 Tile_X2Y0_S_OBI_right.Inst_S_OBI_right_ConfigMem.Inst_frame2_bit31.Q
+ Tile_X2Y0_S_OBI_right.Inst_S_OBI_right_switch_matrix.N2BEG1 VPWR VGND sg13g2_mux2_1
X_0273_ VPWR _0046_ Tile_X2Y0_SS4END[5] VGND sg13g2_inv_1
XFILLER_2_1004 VPWR VGND sg13g2_decap_8
X_0609_ VPWR VGND Tile_X0Y0_S_OBI_left.Inst_S_OBI_left_ConfigMem.Inst_frame0_bit10.Q
+ _0059_ _0223_ _0221_ _0224_ _0222_ sg13g2_a221oi_1
XFILLER_6_627 VPWR VGND sg13g2_fill_1
XFILLER_2_822 VPWR VGND sg13g2_decap_8
XFILLER_2_899 VPWR VGND sg13g2_decap_8
XFILLER_1_398 VPWR VGND sg13g2_decap_8
XFILLER_9_443 VPWR VGND sg13g2_decap_8
X_0960_ Tile_X0Y0_S_OBI_left.Inst_S_OBI_left_switch_matrix.NN4BEG1 Tile_X0Y0_NN4BEG[1]
+ VPWR VGND sg13g2_buf_1
X_0891_ Tile_X0Y0_FrameData[2] Tile_X0Y0_FrameStrobe[1] Tile_X0Y0_S_OBI_left.Inst_S_OBI_left_ConfigMem.Inst_frame1_bit2.Q
+ VPWR VGND sg13g2_dlhq_1
X_0325_ Tile_X1Y0_S4END[10] WDATA_top30 Tile_X1Y0_S_OBI_middle.Inst_S_OBI_middle_ConfigMem.Inst_frame1_bit7.Q
+ Tile_X1Y0_S_OBI_middle.Inst_S_OBI_middle_switch_matrix.N4BEG5 VPWR VGND sg13g2_mux2_1
XFILLER_4_63 VPWR VGND sg13g2_decap_8
XFILLER_4_181 VPWR VGND sg13g2_fill_1
X_0256_ VPWR _0029_ Tile_X1Y0_S_OBI_middle.Inst_S_OBI_middle_ConfigMem.Inst_frame0_bit2.Q
+ VGND sg13g2_inv_1
XFILLER_11_409 VPWR VGND sg13g2_decap_8
XFILLER_8_1279 VPWR VGND sg13g2_decap_8
XFILLER_7_936 VPWR VGND sg13g2_decap_8
XFILLER_6_435 VPWR VGND sg13g2_decap_8
XFILLER_1_140 VPWR VGND sg13g2_decap_8
X_1090_ Tile_X2Y0_FrameStrobe[9] Tile_X2Y0_FrameStrobe_O[9] VPWR VGND sg13g2_buf_1
X_0943_ Tile_X0Y0_S_OBI_left.Inst_S_OBI_left_switch_matrix.N4BEG0 Tile_X0Y0_N4BEG[0]
+ VPWR VGND sg13g2_buf_1
XFILLER_9_273 VPWR VGND sg13g2_fill_1
X_0874_ Tile_X0Y0_FrameData[19] Tile_X0Y0_FrameStrobe[1] Tile_X0Y0_S_OBI_left.Inst_S_OBI_left_ConfigMem.Inst_frame1_bit19.Q
+ VPWR VGND sg13g2_dlhq_1
X_0308_ _0071_ VPWR Tile_X1Y0_S_OBI_middle.Inst_S_OBI_middle_switch_matrix.N2BEG5
+ VGND _0027_ Tile_X1Y0_S_OBI_middle.Inst_S_OBI_middle_ConfigMem.Inst_frame2_bit23.Q
+ sg13g2_o21ai_1
XFILLER_7_733 VPWR VGND sg13g2_fill_1
XFILLER_7_711 VPWR VGND sg13g2_fill_1
XFILLER_3_972 VPWR VGND sg13g2_decap_8
X_0590_ Tile_X0Y0_S4END[0] Tile_X0Y0_S_OBI_left.Inst_S_OBI_left_ConfigMem.Inst_frame0_bit3.Q
+ _0207_ VPWR VGND sg13g2_nor2b_1
XFILLER_6_298 VPWR VGND sg13g2_decap_4
X_1142_ Tile_X2Y0_S_OBI_right.Inst_S_OBI_right_switch_matrix.NN4BEG5 Tile_X2Y0_NN4BEG[5]
+ VPWR VGND sg13g2_buf_1
XFILLER_1_31 VPWR VGND sg13g2_decap_8
XFILLER_2_471 VPWR VGND sg13g2_decap_8
X_1073_ Tile_X0Y0_FrameData[24] Tile_X2Y0_FrameData_O[24] VPWR VGND sg13g2_buf_1
XFILLER_0_1305 VPWR VGND sg13g2_fill_2
X_0926_ Tile_X0Y0_S_OBI_left.Inst_S_OBI_left_switch_matrix.N1BEG3 Tile_X0Y0_N1BEG[3]
+ VPWR VGND sg13g2_buf_1
X_0857_ Tile_X0Y0_FrameData[4] Tile_X0Y0_FrameStrobe[0] Tile_X0Y0_S_OBI_left.Inst_S_OBI_left_ConfigMem.Inst_frame0_bit4.Q
+ VPWR VGND sg13g2_dlhq_1
XFILLER_9_1330 VPWR VGND sg13g2_fill_2
XFILLER_1_909 VPWR VGND sg13g2_decap_8
X_0788_ Tile_X0Y0_FrameData[3] Tile_X2Y0_FrameStrobe[0] Tile_X2Y0_S_OBI_right.Inst_S_OBI_right_ConfigMem.Inst_frame0_bit3.Q
+ VPWR VGND sg13g2_dlhq_1
XFILLER_8_508 VPWR VGND sg13g2_fill_2
XFILLER_0_942 VPWR VGND sg13g2_decap_8
XFILLER_11_592 VPWR VGND sg13g2_decap_8
X_0711_ Tile_X0Y0_FrameData[26] Tile_X1Y0_FrameStrobe[1] Tile_X1Y0_S_OBI_middle.Inst_S_OBI_middle_ConfigMem.Inst_frame1_bit26.Q
+ VPWR VGND sg13g2_dlhq_1
XFILLER_7_585 VPWR VGND sg13g2_decap_4
XFILLER_7_563 VPWR VGND sg13g2_decap_4
X_0573_ Tile_X0Y0_SS4END[12] ADDR_top6 Tile_X0Y0_S_OBI_left.Inst_S_OBI_left_ConfigMem.Inst_frame1_bit27.Q
+ Tile_X0Y0_S_OBI_left.Inst_S_OBI_left_switch_matrix.NN4BEG3 VPWR VGND sg13g2_mux2_1
X_0642_ _0253_ Tile_X0Y0_S2END[6] Tile_X0Y0_S_OBI_left.Inst_S_OBI_left_ConfigMem.Inst_frame0_bit21.Q
+ VPWR VGND sg13g2_nand2b_1
X_1125_ Tile_X2Y0_S_OBI_right.Inst_S_OBI_right_switch_matrix.N4BEG4 Tile_X2Y0_N4BEG[4]
+ VPWR VGND sg13g2_buf_1
XFILLER_0_1179 VPWR VGND sg13g2_decap_8
X_1056_ Tile_X0Y0_FrameData[7] Tile_X2Y0_FrameData_O[7] VPWR VGND sg13g2_buf_1
XFILLER_1_706 VPWR VGND sg13g2_decap_8
X_0909_ Tile_X0Y0_FrameStrobe[6] Tile_X0Y0_FrameStrobe_O[6] VPWR VGND sg13g2_buf_1
XFILLER_9_839 VPWR VGND sg13g2_fill_2
XANTENNA_90 VPWR VGND Tile_X0Y0_FrameData[18] sg13g2_antennanp
XFILLER_8_316 VPWR VGND sg13g2_decap_4
XFILLER_4_588 VPWR VGND sg13g2_decap_4
X_0625_ Tile_X0Y0_S2MID[4] Tile_X0Y0_S_OBI_left.Inst_S_OBI_left_ConfigMem.Inst_frame0_bit15.Q
+ Tile_X0Y0_S_OBI_left.Inst_S_OBI_left_ConfigMem.Inst_frame0_bit16.Q _0238_ VPWR VGND
+ sg13g2_nor3_1
XFILLER_7_63 VPWR VGND sg13g2_decap_8
XFILLER_7_96 VPWR VGND sg13g2_fill_2
X_0487_ Tile_X2Y0_S2MID[4] Tile_X2Y0_S_OBI_right.Inst_S_OBI_right_ConfigMem.Inst_frame0_bit15.Q
+ Tile_X2Y0_S_OBI_right.Inst_S_OBI_right_ConfigMem.Inst_frame0_bit16.Q _0150_ VPWR
+ VGND sg13g2_nor3_1
X_0556_ Tile_X0Y0_S2END[3] ADDR_top3 Tile_X0Y0_S_OBI_left.Inst_S_OBI_left_ConfigMem.Inst_frame1_bit10.Q
+ Tile_X0Y0_S_OBI_left.Inst_S_OBI_left_switch_matrix.N2BEGb4 VPWR VGND sg13g2_mux2_1
X_1108_ Tile_X2Y0_S_OBI_right.Inst_S_OBI_right_switch_matrix.N2BEG3 Tile_X2Y0_N2BEG[3]
+ VPWR VGND sg13g2_buf_1
X_1039_ Tile_X1Y0_S_OBI_middle.Inst_S_OBI_middle_switch_matrix.NN4BEG7 Tile_X1Y0_NN4BEG[7]
+ VPWR VGND sg13g2_buf_1
XFILLER_4_1090 VPWR VGND sg13g2_fill_2
XFILLER_1_558 VPWR VGND sg13g2_decap_8
XFILLER_8_157 VPWR VGND sg13g2_fill_1
XFILLER_5_864 VPWR VGND sg13g2_decap_8
X_0341_ Tile_X1Y0_SS4END[10] WDATA_top30 Tile_X1Y0_S_OBI_middle.Inst_S_OBI_middle_ConfigMem.Inst_frame1_bit23.Q
+ Tile_X1Y0_S_OBI_middle.Inst_S_OBI_middle_switch_matrix.NN4BEG5 VPWR VGND sg13g2_mux2_1
XFILLER_10_1084 VPWR VGND sg13g2_fill_1
X_0410_ Tile_X2Y0_S2MID[7] WDATA_top17 Tile_X2Y0_S_OBI_right.Inst_S_OBI_right_ConfigMem.Inst_frame2_bit30.Q
+ Tile_X2Y0_S_OBI_right.Inst_S_OBI_right_switch_matrix.N2BEG0 VPWR VGND sg13g2_mux2_1
XFILLER_4_363 VPWR VGND sg13g2_decap_8
X_0272_ VPWR _0045_ Tile_X2Y0_S_OBI_right.Inst_S_OBI_right_ConfigMem.Inst_frame0_bit17.Q
+ VGND sg13g2_inv_1
XFILLER_1_1285 VPWR VGND sg13g2_decap_8
X_0608_ Tile_X0Y0_SS4END[8] Tile_X0Y0_S_OBI_left.Inst_S_OBI_left_ConfigMem.Inst_frame0_bit9.Q
+ _0223_ VPWR VGND sg13g2_nor2_1
X_0539_ _0196_ _0193_ _0192_ RDATA_top19 VPWR VGND sg13g2_a21o_1
XFILLER_1_377 VPWR VGND sg13g2_decap_8
XFILLER_2_801 VPWR VGND sg13g2_decap_8
XFILLER_2_878 VPWR VGND sg13g2_decap_8
XFILLER_9_422 VPWR VGND sg13g2_decap_8
X_0890_ Tile_X0Y0_FrameData[3] Tile_X0Y0_FrameStrobe[1] Tile_X0Y0_S_OBI_left.Inst_S_OBI_left_ConfigMem.Inst_frame1_bit3.Q
+ VPWR VGND sg13g2_dlhq_1
XFILLER_9_499 VPWR VGND sg13g2_decap_8
XFILLER_4_42 VPWR VGND sg13g2_decap_8
XFILLER_5_661 VPWR VGND sg13g2_decap_8
X_0324_ Tile_X1Y0_S4END[11] WDATA_top31 Tile_X1Y0_S_OBI_middle.Inst_S_OBI_middle_ConfigMem.Inst_frame1_bit6.Q
+ Tile_X1Y0_S_OBI_middle.Inst_S_OBI_middle_switch_matrix.N4BEG4 VPWR VGND sg13g2_mux2_1
X_0255_ VPWR _0028_ Tile_X1Y0_S2MID[0] VGND sg13g2_inv_1
XFILLER_1_1082 VPWR VGND sg13g2_decap_8
XFILLER_2_119 VPWR VGND sg13g2_decap_8
XFILLER_11_977 VPWR VGND sg13g2_fill_2
XFILLER_7_915 VPWR VGND sg13g2_decap_8
XFILLER_8_0 VPWR VGND sg13g2_decap_8
XFILLER_6_414 VPWR VGND sg13g2_decap_8
XFILLER_1_196 VPWR VGND sg13g2_decap_8
XFILLER_2_653 VPWR VGND sg13g2_decap_8
X_0942_ Tile_X0Y0_S_OBI_left.Inst_S_OBI_left_switch_matrix.N2BEGb7 Tile_X0Y0_N2BEGb[7]
+ VPWR VGND sg13g2_buf_1
X_0873_ Tile_X0Y0_FrameData[20] Tile_X0Y0_FrameStrobe[1] Tile_X0Y0_S_OBI_left.Inst_S_OBI_left_ConfigMem.Inst_frame1_bit20.Q
+ VPWR VGND sg13g2_dlhq_1
XFILLER_5_491 VPWR VGND sg13g2_decap_8
X_0307_ _0071_ BE_top1 Tile_X1Y0_S_OBI_middle.Inst_S_OBI_middle_ConfigMem.Inst_frame2_bit23.Q
+ VPWR VGND sg13g2_nand2_1
XFILLER_3_1166 VPWR VGND sg13g2_fill_1
XFILLER_11_218 VPWR VGND sg13g2_decap_4
XFILLER_1_7 VPWR VGND sg13g2_decap_4
XFILLER_2_450 VPWR VGND sg13g2_decap_8
XFILLER_3_951 VPWR VGND sg13g2_decap_8
XFILLER_6_266 VPWR VGND sg13g2_fill_1
X_1141_ Tile_X2Y0_S_OBI_right.Inst_S_OBI_right_switch_matrix.NN4BEG4 Tile_X2Y0_NN4BEG[4]
+ VPWR VGND sg13g2_buf_1
X_1072_ Tile_X0Y0_FrameData[23] Tile_X2Y0_FrameData_O[23] VPWR VGND sg13g2_buf_1
XFILLER_1_76 VPWR VGND sg13g2_decap_8
XFILLER_1_87 VPWR VGND sg13g2_fill_2
X_0925_ Tile_X0Y0_S_OBI_left.Inst_S_OBI_left_switch_matrix.N1BEG2 Tile_X0Y0_N1BEG[2]
+ VPWR VGND sg13g2_buf_1
X_0787_ Tile_X0Y0_FrameData[4] Tile_X2Y0_FrameStrobe[0] Tile_X2Y0_S_OBI_right.Inst_S_OBI_right_ConfigMem.Inst_frame0_bit4.Q
+ VPWR VGND sg13g2_dlhq_1
X_0856_ Tile_X0Y0_FrameData[5] Tile_X0Y0_FrameStrobe[0] Tile_X0Y0_S_OBI_left.Inst_S_OBI_left_ConfigMem.Inst_frame0_bit5.Q
+ VPWR VGND sg13g2_dlhq_1
XFILLER_0_921 VPWR VGND sg13g2_decap_8
XFILLER_0_998 VPWR VGND sg13g2_decap_8
X_0641_ Tile_X0Y0_S_OBI_left.Inst_S_OBI_left_ConfigMem.Inst_frame0_bit20.Q _0250_
+ _0251_ _0252_ VPWR VGND sg13g2_nor3_1
X_0710_ Tile_X0Y0_FrameData[27] Tile_X1Y0_FrameStrobe[1] Tile_X1Y0_S_OBI_middle.Inst_S_OBI_middle_ConfigMem.Inst_frame1_bit27.Q
+ VPWR VGND sg13g2_dlhq_1
X_0572_ Tile_X0Y0_SS4END[13] ADDR_top7 Tile_X0Y0_S_OBI_left.Inst_S_OBI_left_ConfigMem.Inst_frame1_bit26.Q
+ Tile_X0Y0_S_OBI_left.Inst_S_OBI_left_switch_matrix.NN4BEG2 VPWR VGND sg13g2_mux2_1
XFILLER_0_1103 VPWR VGND sg13g2_decap_4
XFILLER_0_1158 VPWR VGND sg13g2_decap_8
X_1055_ Tile_X0Y0_FrameData[6] Tile_X2Y0_FrameData_O[6] VPWR VGND sg13g2_buf_1
X_1124_ Tile_X2Y0_S_OBI_right.Inst_S_OBI_right_switch_matrix.N4BEG3 Tile_X2Y0_N4BEG[3]
+ VPWR VGND sg13g2_buf_1
X_0908_ Tile_X0Y0_FrameStrobe[5] Tile_X0Y0_FrameStrobe_O[5] VPWR VGND sg13g2_buf_1
X_0839_ Tile_X0Y0_FrameData[22] Tile_X0Y0_FrameStrobe[0] Tile_X0Y0_S_OBI_left.Inst_S_OBI_left_ConfigMem.Inst_frame0_bit22.Q
+ VPWR VGND sg13g2_dlhq_1
XANTENNA_91 VPWR VGND Tile_X0Y0_FrameData[18] sg13g2_antennanp
XANTENNA_80 VPWR VGND WDATA_top6 sg13g2_antennanp
XFILLER_4_567 VPWR VGND sg13g2_decap_8
XFILLER_0_795 VPWR VGND sg13g2_decap_8
X_0624_ Tile_X0Y0_S_OBI_left.Inst_S_OBI_left_ConfigMem.Inst_frame0_bit16.Q VPWR _0237_
+ VGND Tile_X0Y0_S_OBI_left.Inst_S_OBI_left_ConfigMem.Inst_frame0_bit15.Q _0064_ sg13g2_o21ai_1
XFILLER_7_42 VPWR VGND sg13g2_decap_8
XFILLER_7_394 VPWR VGND sg13g2_decap_8
X_0555_ Tile_X0Y0_S2END[4] ADDR_top4 Tile_X0Y0_S_OBI_left.Inst_S_OBI_left_ConfigMem.Inst_frame1_bit9.Q
+ Tile_X0Y0_S_OBI_left.Inst_S_OBI_left_switch_matrix.N2BEGb3 VPWR VGND sg13g2_mux2_1
X_0486_ Tile_X2Y0_S_OBI_right.Inst_S_OBI_right_ConfigMem.Inst_frame0_bit16.Q VPWR
+ _0149_ VGND Tile_X2Y0_S_OBI_right.Inst_S_OBI_right_ConfigMem.Inst_frame0_bit15.Q
+ _0044_ sg13g2_o21ai_1
XFILLER_6_1323 VPWR VGND sg13g2_decap_8
X_1107_ Tile_X2Y0_S_OBI_right.Inst_S_OBI_right_switch_matrix.N2BEG2 Tile_X2Y0_N2BEG[2]
+ VPWR VGND sg13g2_buf_1
X_1038_ Tile_X1Y0_S_OBI_middle.Inst_S_OBI_middle_switch_matrix.NN4BEG6 Tile_X1Y0_NN4BEG[6]
+ VPWR VGND sg13g2_buf_1
XFILLER_1_548 VPWR VGND sg13g2_decap_4
XFILLER_1_504 VPWR VGND sg13g2_fill_1
XFILLER_4_342 VPWR VGND sg13g2_decap_8
X_0340_ Tile_X1Y0_SS4END[11] WDATA_top31 Tile_X1Y0_S_OBI_middle.Inst_S_OBI_middle_ConfigMem.Inst_frame1_bit22.Q
+ Tile_X1Y0_S_OBI_middle.Inst_S_OBI_middle_switch_matrix.NN4BEG4 VPWR VGND sg13g2_mux2_1
X_0271_ VPWR _0044_ Tile_X2Y0_SS4END[4] VGND sg13g2_inv_1
XFILLER_0_592 VPWR VGND sg13g2_decap_8
XFILLER_1_1264 VPWR VGND sg13g2_decap_8
X_0538_ Tile_X2Y0_S_OBI_right.Inst_S_OBI_right_ConfigMem.Inst_frame0_bit29.Q _0194_
+ _0195_ _0196_ VPWR VGND sg13g2_nor3_1
X_0607_ VGND VPWR Tile_X0Y0_S4END[8] Tile_X0Y0_S_OBI_left.Inst_S_OBI_left_ConfigMem.Inst_frame0_bit9.Q
+ _0222_ Tile_X0Y0_S_OBI_left.Inst_S_OBI_left_ConfigMem.Inst_frame0_bit10.Q sg13g2_a21oi_1
X_0469_ VGND VPWR Tile_X2Y0_S4END[8] Tile_X2Y0_S_OBI_right.Inst_S_OBI_right_ConfigMem.Inst_frame0_bit9.Q
+ _0134_ Tile_X2Y0_S_OBI_right.Inst_S_OBI_right_ConfigMem.Inst_frame0_bit10.Q sg13g2_a21oi_1
XFILLER_2_1039 VPWR VGND sg13g2_decap_4
XFILLER_6_1164 VPWR VGND sg13g2_fill_2
XFILLER_1_356 VPWR VGND sg13g2_decap_8
XFILLER_1_334 VPWR VGND sg13g2_decap_8
XFILLER_2_857 VPWR VGND sg13g2_decap_8
XFILLER_9_478 VPWR VGND sg13g2_decap_8
XFILLER_4_21 VPWR VGND sg13g2_decap_8
X_0323_ Tile_X1Y0_S4END[12] ADDR_top20 Tile_X1Y0_S_OBI_middle.Inst_S_OBI_middle_ConfigMem.Inst_frame1_bit5.Q
+ Tile_X1Y0_S_OBI_middle.Inst_S_OBI_middle_switch_matrix.N4BEG3 VPWR VGND sg13g2_mux2_1
X_0254_ VPWR _0027_ Tile_X1Y0_S2MID[2] VGND sg13g2_inv_1
XFILLER_3_1326 VPWR VGND sg13g2_decap_4
XFILLER_4_98 VPWR VGND sg13g2_decap_8
XFILLER_1_1061 VPWR VGND sg13g2_decap_8
XFILLER_10_488 VPWR VGND sg13g2_decap_4
XFILLER_1_120 VPWR VGND sg13g2_fill_1
XFILLER_2_632 VPWR VGND sg13g2_decap_8
XFILLER_1_175 VPWR VGND sg13g2_decap_8
X_0941_ Tile_X0Y0_S_OBI_left.Inst_S_OBI_left_switch_matrix.N2BEGb6 Tile_X0Y0_N2BEGb[6]
+ VPWR VGND sg13g2_buf_1
X_0872_ Tile_X0Y0_FrameData[21] Tile_X0Y0_FrameStrobe[1] Tile_X0Y0_S_OBI_left.Inst_S_OBI_left_ConfigMem.Inst_frame1_bit21.Q
+ VPWR VGND sg13g2_dlhq_1
XFILLER_5_470 VPWR VGND sg13g2_decap_8
XFILLER_6_993 VPWR VGND sg13g2_fill_2
X_0306_ Tile_X1Y0_S2MID[3] BE_top0 Tile_X1Y0_S_OBI_middle.Inst_S_OBI_middle_ConfigMem.Inst_frame2_bit22.Q
+ Tile_X1Y0_S_OBI_middle.Inst_S_OBI_middle_switch_matrix.N2BEG4 VPWR VGND sg13g2_mux2_1
XFILLER_3_429 VPWR VGND sg13g2_decap_8
XFILLER_3_930 VPWR VGND sg13g2_decap_8
X_1140_ Tile_X2Y0_S_OBI_right.Inst_S_OBI_right_switch_matrix.NN4BEG3 Tile_X2Y0_NN4BEG[3]
+ VPWR VGND sg13g2_buf_1
X_1071_ Tile_X0Y0_FrameData[22] Tile_X2Y0_FrameData_O[22] VPWR VGND sg13g2_buf_1
XFILLER_1_11 VPWR VGND sg13g2_fill_2
XFILLER_1_66 VPWR VGND sg13g2_decap_4
X_0924_ Tile_X0Y0_S_OBI_left.Inst_S_OBI_left_switch_matrix.N1BEG1 Tile_X0Y0_N1BEG[1]
+ VPWR VGND sg13g2_buf_1
X_0786_ Tile_X0Y0_FrameData[5] Tile_X2Y0_FrameStrobe[0] Tile_X2Y0_S_OBI_right.Inst_S_OBI_right_ConfigMem.Inst_frame0_bit5.Q
+ VPWR VGND sg13g2_dlhq_1
X_0855_ Tile_X0Y0_FrameData[6] Tile_X0Y0_FrameStrobe[0] Tile_X0Y0_S_OBI_left.Inst_S_OBI_left_ConfigMem.Inst_frame0_bit6.Q
+ VPWR VGND sg13g2_dlhq_1
XFILLER_9_1310 VPWR VGND sg13g2_fill_1
XFILLER_10_75 VPWR VGND sg13g2_fill_2
XFILLER_0_900 VPWR VGND sg13g2_decap_8
XFILLER_3_248 VPWR VGND sg13g2_fill_2
XFILLER_0_977 VPWR VGND sg13g2_decap_8
X_0571_ Tile_X0Y0_SS4END[14] ADDR_top8 Tile_X0Y0_S_OBI_left.Inst_S_OBI_left_ConfigMem.Inst_frame1_bit25.Q
+ Tile_X0Y0_S_OBI_left.Inst_S_OBI_left_switch_matrix.NN4BEG1 VPWR VGND sg13g2_mux2_1
X_0640_ Tile_X0Y0_S4END[6] Tile_X0Y0_S_OBI_left.Inst_S_OBI_left_ConfigMem.Inst_frame0_bit21.Q
+ _0251_ VPWR VGND sg13g2_nor2b_1
X_1123_ Tile_X2Y0_S_OBI_right.Inst_S_OBI_right_switch_matrix.N4BEG2 Tile_X2Y0_N4BEG[2]
+ VPWR VGND sg13g2_buf_1
XFILLER_0_1126 VPWR VGND sg13g2_fill_2
XFILLER_0_1137 VPWR VGND sg13g2_decap_8
X_1054_ Tile_X0Y0_FrameData[5] Tile_X2Y0_FrameData_O[5] VPWR VGND sg13g2_buf_1
XFILLER_4_1284 VPWR VGND sg13g2_decap_8
X_0907_ Tile_X0Y0_FrameStrobe[4] Tile_X0Y0_FrameStrobe_O[4] VPWR VGND sg13g2_buf_1
X_0769_ Tile_X0Y0_FrameData[22] Tile_X2Y0_FrameStrobe[0] Tile_X2Y0_S_OBI_right.Inst_S_OBI_right_ConfigMem.Inst_frame0_bit22.Q
+ VPWR VGND sg13g2_dlhq_1
X_0838_ Tile_X0Y0_FrameData[23] Tile_X0Y0_FrameStrobe[0] Tile_X0Y0_S_OBI_left.Inst_S_OBI_left_ConfigMem.Inst_frame0_bit23.Q
+ VPWR VGND sg13g2_dlhq_1
XFILLER_5_1026 VPWR VGND sg13g2_fill_2
XANTENNA_70 VPWR VGND Tile_X0Y0_FrameData[9] sg13g2_antennanp
XANTENNA_92 VPWR VGND Tile_X0Y0_FrameData[18] sg13g2_antennanp
XFILLER_4_524 VPWR VGND sg13g2_decap_8
XANTENNA_81 VPWR VGND WDATA_top6 sg13g2_antennanp
XFILLER_10_1289 VPWR VGND sg13g2_decap_8
XFILLER_0_774 VPWR VGND sg13g2_decap_8
XFILLER_7_21 VPWR VGND sg13g2_decap_8
XFILLER_7_340 VPWR VGND sg13g2_decap_4
X_0554_ Tile_X0Y0_S2END[5] ADDR_top5 Tile_X0Y0_S_OBI_left.Inst_S_OBI_left_ConfigMem.Inst_frame1_bit8.Q
+ Tile_X0Y0_S_OBI_left.Inst_S_OBI_left_switch_matrix.N2BEGb2 VPWR VGND sg13g2_mux2_1
X_0623_ VPWR VGND Tile_X0Y0_S_OBI_left.Inst_S_OBI_left_ConfigMem.Inst_frame0_bit16.Q
+ _0063_ _0235_ _0233_ _0236_ _0234_ sg13g2_a221oi_1
XFILLER_8_885 VPWR VGND sg13g2_decap_4
XFILLER_3_590 VPWR VGND sg13g2_decap_8
XFILLER_7_98 VPWR VGND sg13g2_fill_1
X_0485_ _0148_ _0145_ _0144_ RDATA_top13 VPWR VGND sg13g2_a21o_1
X_1106_ Tile_X2Y0_S_OBI_right.Inst_S_OBI_right_switch_matrix.N2BEG1 Tile_X2Y0_N2BEG[1]
+ VPWR VGND sg13g2_buf_1
XFILLER_6_1302 VPWR VGND sg13g2_decap_8
X_1037_ Tile_X1Y0_S_OBI_middle.Inst_S_OBI_middle_switch_matrix.NN4BEG5 Tile_X1Y0_NN4BEG[5]
+ VPWR VGND sg13g2_buf_1
XFILLER_4_1092 VPWR VGND sg13g2_fill_1
XFILLER_1_516 VPWR VGND sg13g2_decap_4
XFILLER_8_148 VPWR VGND sg13g2_fill_1
XFILLER_8_104 VPWR VGND sg13g2_fill_1
XFILLER_4_310 VPWR VGND sg13g2_decap_8
XFILLER_4_398 VPWR VGND sg13g2_decap_8
XFILLER_5_800 VPWR VGND sg13g2_decap_4
XFILLER_5_899 VPWR VGND sg13g2_decap_8
X_0270_ VPWR _0043_ Tile_X2Y0_S_OBI_right.Inst_S_OBI_right_ConfigMem.Inst_frame0_bit14.Q
+ VGND sg13g2_inv_1
XFILLER_0_571 VPWR VGND sg13g2_decap_8
XFILLER_1_1243 VPWR VGND sg13g2_decap_8
X_0537_ Tile_X2Y0_S4END[9] Tile_X2Y0_S_OBI_right.Inst_S_OBI_right_ConfigMem.Inst_frame0_bit30.Q
+ _0195_ VPWR VGND sg13g2_nor2b_1
X_0606_ _0221_ Tile_X0Y0_S2END[2] Tile_X0Y0_S_OBI_left.Inst_S_OBI_left_ConfigMem.Inst_frame0_bit9.Q
+ VPWR VGND sg13g2_nand2b_1
X_0399_ Tile_X1Y0_S2MID[3] Tile_X1Y0_S_OBI_middle.Inst_S_OBI_middle_ConfigMem.Inst_frame0_bit6.Q
+ _0107_ VPWR VGND sg13g2_nor2_1
XFILLER_2_1018 VPWR VGND sg13g2_decap_8
X_0468_ _0133_ Tile_X2Y0_S2END[2] Tile_X2Y0_S_OBI_right.Inst_S_OBI_right_ConfigMem.Inst_frame0_bit9.Q
+ VPWR VGND sg13g2_nand2b_1
XFILLER_2_836 VPWR VGND sg13g2_decap_8
XFILLER_9_457 VPWR VGND sg13g2_decap_8
X_0322_ Tile_X1Y0_S4END[13] ADDR_top21 Tile_X1Y0_S_OBI_middle.Inst_S_OBI_middle_ConfigMem.Inst_frame1_bit4.Q
+ Tile_X1Y0_S_OBI_middle.Inst_S_OBI_middle_switch_matrix.N4BEG2 VPWR VGND sg13g2_mux2_1
XFILLER_4_77 VPWR VGND sg13g2_decap_8
XFILLER_1_1040 VPWR VGND sg13g2_decap_8
XFILLER_11_924 VPWR VGND sg13g2_decap_8
XFILLER_10_467 VPWR VGND sg13g2_decap_8
XFILLER_10_445 VPWR VGND sg13g2_decap_8
XFILLER_10_423 VPWR VGND sg13g2_fill_2
XFILLER_10_412 VPWR VGND sg13g2_decap_8
XFILLER_6_449 VPWR VGND sg13g2_decap_8
XFILLER_1_132 VPWR VGND sg13g2_decap_4
XFILLER_1_154 VPWR VGND sg13g2_decap_8
XFILLER_2_611 VPWR VGND sg13g2_decap_8
X_0940_ Tile_X0Y0_S_OBI_left.Inst_S_OBI_left_switch_matrix.N2BEGb5 Tile_X0Y0_N2BEGb[5]
+ VPWR VGND sg13g2_buf_1
X_0871_ Tile_X0Y0_FrameData[22] Tile_X0Y0_FrameStrobe[1] Tile_X0Y0_S_OBI_left.Inst_S_OBI_left_ConfigMem.Inst_frame1_bit22.Q
+ VPWR VGND sg13g2_dlhq_1
XFILLER_6_972 VPWR VGND sg13g2_decap_8
X_0305_ Tile_X1Y0_S2MID[4] BE_top3 Tile_X1Y0_S_OBI_middle.Inst_S_OBI_middle_ConfigMem.Inst_frame2_bit21.Q
+ Tile_X1Y0_S_OBI_middle.Inst_S_OBI_middle_switch_matrix.N2BEG3 VPWR VGND sg13g2_mux2_1
XFILLER_7_1282 VPWR VGND sg13g2_decap_8
XFILLER_3_408 VPWR VGND sg13g2_decap_8
XFILLER_4_909 VPWR VGND sg13g2_decap_8
XFILLER_11_721 VPWR VGND sg13g2_decap_4
XFILLER_11_710 VPWR VGND sg13g2_fill_1
XFILLER_2_485 VPWR VGND sg13g2_decap_8
XFILLER_3_986 VPWR VGND sg13g2_decap_8
X_1070_ Tile_X0Y0_FrameData[21] Tile_X2Y0_FrameData_O[21] VPWR VGND sg13g2_buf_1
XFILLER_1_45 VPWR VGND sg13g2_decap_8
XFILLER_0_1319 VPWR VGND sg13g2_decap_8
XFILLER_2_1190 VPWR VGND sg13g2_decap_8
X_0923_ Tile_X0Y0_S_OBI_left.Inst_S_OBI_left_switch_matrix.N1BEG0 Tile_X0Y0_N1BEG[0]
+ VPWR VGND sg13g2_buf_1
X_0854_ Tile_X0Y0_FrameData[7] Tile_X0Y0_FrameStrobe[0] Tile_X0Y0_S_OBI_left.Inst_S_OBI_left_ConfigMem.Inst_frame0_bit7.Q
+ VPWR VGND sg13g2_dlhq_1
X_0785_ Tile_X0Y0_FrameData[6] Tile_X2Y0_FrameStrobe[0] Tile_X2Y0_S_OBI_right.Inst_S_OBI_right_ConfigMem.Inst_frame0_bit6.Q
+ VPWR VGND sg13g2_dlhq_1
XFILLER_10_21 VPWR VGND sg13g2_decap_8
XFILLER_3_216 VPWR VGND sg13g2_fill_2
XFILLER_0_956 VPWR VGND sg13g2_decap_8
X_0570_ Tile_X0Y0_SS4END[15] ADDR_top9 Tile_X0Y0_S_OBI_left.Inst_S_OBI_left_ConfigMem.Inst_frame1_bit24.Q
+ Tile_X0Y0_S_OBI_left.Inst_S_OBI_left_switch_matrix.NN4BEG0 VPWR VGND sg13g2_mux2_1
X_1122_ Tile_X2Y0_S_OBI_right.Inst_S_OBI_right_switch_matrix.N4BEG1 Tile_X2Y0_N4BEG[1]
+ VPWR VGND sg13g2_buf_1
X_1053_ Tile_X0Y0_FrameData[4] Tile_X2Y0_FrameData_O[4] VPWR VGND sg13g2_buf_1
XFILLER_4_1263 VPWR VGND sg13g2_decap_8
X_0837_ Tile_X0Y0_FrameData[24] Tile_X0Y0_FrameStrobe[0] Tile_X0Y0_S_OBI_left.Inst_S_OBI_left_ConfigMem.Inst_frame0_bit24.Q
+ VPWR VGND sg13g2_dlhq_1
X_0906_ Tile_X0Y0_FrameStrobe[3] Tile_X0Y0_FrameStrobe_O[3] VPWR VGND sg13g2_buf_1
XFILLER_0_219 VPWR VGND sg13g2_decap_8
X_0699_ Tile_X0Y0_FrameData[6] Tile_X1Y0_FrameStrobe[0] Tile_X1Y0_S_OBI_middle.Inst_S_OBI_middle_ConfigMem.Inst_frame0_bit6.Q
+ VPWR VGND sg13g2_dlhq_1
X_0768_ Tile_X0Y0_FrameData[23] Tile_X2Y0_FrameStrobe[0] Tile_X2Y0_S_OBI_right.Inst_S_OBI_right_ConfigMem.Inst_frame0_bit23.Q
+ VPWR VGND sg13g2_dlhq_1
XANTENNA_82 VPWR VGND WDATA_top9 sg13g2_antennanp
XANTENNA_93 VPWR VGND Tile_X0Y0_FrameData[18] sg13g2_antennanp
XANTENNA_71 VPWR VGND Tile_X0Y0_FrameData[9] sg13g2_antennanp
XFILLER_4_503 VPWR VGND sg13g2_decap_8
XANTENNA_60 VPWR VGND Tile_X0Y0_FrameData[6] sg13g2_antennanp
XFILLER_0_753 VPWR VGND sg13g2_decap_8
XFILLER_8_864 VPWR VGND sg13g2_decap_8
XFILLER_7_88 VPWR VGND sg13g2_fill_2
X_0622_ Tile_X0Y0_SS4END[10] Tile_X0Y0_S_OBI_left.Inst_S_OBI_left_ConfigMem.Inst_frame0_bit15.Q
+ _0235_ VPWR VGND sg13g2_nor2_1
X_0484_ Tile_X2Y0_S_OBI_right.Inst_S_OBI_right_ConfigMem.Inst_frame0_bit11.Q _0146_
+ _0147_ _0148_ VPWR VGND sg13g2_nor3_1
X_0553_ Tile_X0Y0_S2END[6] ADDR_top6 Tile_X0Y0_S_OBI_left.Inst_S_OBI_left_ConfigMem.Inst_frame1_bit7.Q
+ Tile_X0Y0_S_OBI_left.Inst_S_OBI_left_switch_matrix.N2BEGb1 VPWR VGND sg13g2_mux2_1
X_1105_ Tile_X2Y0_S_OBI_right.Inst_S_OBI_right_switch_matrix.N2BEG0 Tile_X2Y0_N2BEG[0]
+ VPWR VGND sg13g2_buf_1
X_1036_ Tile_X1Y0_S_OBI_middle.Inst_S_OBI_middle_switch_matrix.NN4BEG4 Tile_X1Y0_NN4BEG[4]
+ VPWR VGND sg13g2_buf_1
XFILLER_4_377 VPWR VGND sg13g2_decap_8
XFILLER_5_878 VPWR VGND sg13g2_decap_8
XFILLER_0_550 VPWR VGND sg13g2_decap_8
XFILLER_1_1222 VPWR VGND sg13g2_decap_8
XFILLER_1_1299 VPWR VGND sg13g2_decap_4
X_0536_ Tile_X2Y0_S1END[1] Tile_X2Y0_S_OBI_right.Inst_S_OBI_right_ConfigMem.Inst_frame0_bit30.Q
+ Tile_X2Y0_S_OBI_right.Inst_S_OBI_right_ConfigMem.Inst_frame0_bit31.Q _0194_ VPWR
+ VGND sg13g2_nor3_1
X_0467_ _0132_ _0129_ _0128_ RDATA_top11 VPWR VGND sg13g2_a21o_1
X_0605_ Tile_X0Y0_S_OBI_left.Inst_S_OBI_left_ConfigMem.Inst_frame0_bit8.Q _0218_ _0219_
+ _0220_ VPWR VGND sg13g2_nor3_1
X_1019_ Tile_X1Y0_S_OBI_middle.Inst_S_OBI_middle_switch_matrix.N4BEG3 Tile_X1Y0_N4BEG[3]
+ VPWR VGND sg13g2_buf_1
X_0398_ VGND VPWR Tile_X1Y0_S1END[3] Tile_X1Y0_S_OBI_middle.Inst_S_OBI_middle_ConfigMem.Inst_frame0_bit6.Q
+ _0106_ Tile_X1Y0_S_OBI_middle.Inst_S_OBI_middle_ConfigMem.Inst_frame0_bit7.Q sg13g2_a21oi_1
XFILLER_11_1330 VPWR VGND sg13g2_fill_2
XFILLER_1_325 VPWR VGND sg13g2_decap_4
XFILLER_1_303 VPWR VGND sg13g2_fill_2
XFILLER_2_815 VPWR VGND sg13g2_decap_8
XFILLER_9_436 VPWR VGND sg13g2_decap_8
XFILLER_4_130 VPWR VGND sg13g2_decap_8
XFILLER_5_620 VPWR VGND sg13g2_fill_2
X_0321_ Tile_X1Y0_S4END[14] ADDR_top22 Tile_X1Y0_S_OBI_middle.Inst_S_OBI_middle_ConfigMem.Inst_frame1_bit3.Q
+ Tile_X1Y0_S_OBI_middle.Inst_S_OBI_middle_switch_matrix.N4BEG1 VPWR VGND sg13g2_mux2_1
XFILLER_4_56 VPWR VGND sg13g2_decap_8
XFILLER_1_1096 VPWR VGND sg13g2_decap_8
XFILLER_8_480 VPWR VGND sg13g2_decap_8
X_0519_ Tile_X2Y0_S4END[7] Tile_X2Y0_S_OBI_right.Inst_S_OBI_right_ConfigMem.Inst_frame0_bit24.Q
+ _0179_ VPWR VGND sg13g2_nor2b_1
XFILLER_7_929 VPWR VGND sg13g2_decap_8
XFILLER_6_428 VPWR VGND sg13g2_decap_8
XFILLER_1_100 VPWR VGND sg13g2_decap_4
XFILLER_2_667 VPWR VGND sg13g2_decap_4
XFILLER_9_222 VPWR VGND sg13g2_fill_1
X_0870_ Tile_X0Y0_FrameData[23] Tile_X0Y0_FrameStrobe[1] Tile_X0Y0_S_OBI_left.Inst_S_OBI_left_ConfigMem.Inst_frame1_bit23.Q
+ VPWR VGND sg13g2_dlhq_1
XFILLER_6_951 VPWR VGND sg13g2_decap_8
XFILLER_6_995 VPWR VGND sg13g2_fill_1
X_0304_ Tile_X1Y0_S2MID[5] BE_top2 Tile_X1Y0_S_OBI_middle.Inst_S_OBI_middle_ConfigMem.Inst_frame2_bit20.Q
+ Tile_X1Y0_S_OBI_middle.Inst_S_OBI_middle_switch_matrix.N2BEG2 VPWR VGND sg13g2_mux2_1
XFILLER_7_1261 VPWR VGND sg13g2_decap_8
X_0999_ Tile_X1Y0_S_OBI_middle.Inst_S_OBI_middle_switch_matrix.N1BEG3 Tile_X1Y0_N1BEG[3]
+ VPWR VGND sg13g2_buf_1
XFILLER_8_1036 VPWR VGND sg13g2_decap_4
XFILLER_7_759 VPWR VGND sg13g2_fill_1
XFILLER_3_965 VPWR VGND sg13g2_decap_8
XFILLER_6_0 VPWR VGND sg13g2_decap_8
XFILLER_6_214 VPWR VGND sg13g2_decap_4
XFILLER_1_24 VPWR VGND sg13g2_decap_8
XFILLER_2_464 VPWR VGND sg13g2_decap_8
X_0922_ Tile_X0Y0_FrameStrobe[19] Tile_X0Y0_FrameStrobe_O[19] VPWR VGND sg13g2_buf_1
X_0853_ Tile_X0Y0_FrameData[8] Tile_X0Y0_FrameStrobe[0] Tile_X0Y0_S_OBI_left.Inst_S_OBI_left_ConfigMem.Inst_frame0_bit8.Q
+ VPWR VGND sg13g2_dlhq_1
X_0784_ Tile_X0Y0_FrameData[7] Tile_X2Y0_FrameStrobe[0] Tile_X2Y0_S_OBI_right.Inst_S_OBI_right_ConfigMem.Inst_frame0_bit7.Q
+ VPWR VGND sg13g2_dlhq_1
XFILLER_0_935 VPWR VGND sg13g2_decap_8
XFILLER_11_574 VPWR VGND sg13g2_fill_2
XFILLER_11_563 VPWR VGND sg13g2_fill_1
XFILLER_7_567 VPWR VGND sg13g2_fill_1
XFILLER_7_589 VPWR VGND sg13g2_fill_1
XFILLER_2_250 VPWR VGND sg13g2_decap_4
XFILLER_3_762 VPWR VGND sg13g2_decap_8
X_1121_ Tile_X2Y0_S_OBI_right.Inst_S_OBI_right_switch_matrix.N4BEG0 Tile_X2Y0_N4BEG[0]
+ VPWR VGND sg13g2_buf_1
X_1052_ Tile_X0Y0_FrameData[3] Tile_X2Y0_FrameData_O[3] VPWR VGND sg13g2_buf_1
XFILLER_2_294 VPWR VGND sg13g2_decap_8
XFILLER_4_1242 VPWR VGND sg13g2_decap_8
X_0905_ Tile_X0Y0_FrameStrobe[2] Tile_X0Y0_FrameStrobe_O[2] VPWR VGND sg13g2_buf_1
X_0767_ Tile_X0Y0_FrameData[24] Tile_X2Y0_FrameStrobe[0] Tile_X2Y0_S_OBI_right.Inst_S_OBI_right_ConfigMem.Inst_frame0_bit24.Q
+ VPWR VGND sg13g2_dlhq_1
X_0836_ Tile_X0Y0_FrameData[25] Tile_X0Y0_FrameStrobe[0] Tile_X0Y0_S_OBI_left.Inst_S_OBI_left_ConfigMem.Inst_frame0_bit25.Q
+ VPWR VGND sg13g2_dlhq_1
X_0698_ Tile_X0Y0_FrameData[7] Tile_X1Y0_FrameStrobe[0] Tile_X1Y0_S_OBI_middle.Inst_S_OBI_middle_ConfigMem.Inst_frame0_bit7.Q
+ VPWR VGND sg13g2_dlhq_1
XFILLER_5_1028 VPWR VGND sg13g2_fill_1
XANTENNA_83 VPWR VGND WDATA_top9 sg13g2_antennanp
XANTENNA_50 VPWR VGND Tile_X0Y0_FrameData[5] sg13g2_antennanp
XANTENNA_61 VPWR VGND Tile_X0Y0_FrameData[6] sg13g2_antennanp
XANTENNA_72 VPWR VGND WDATA_top2 sg13g2_antennanp
XANTENNA_94 VPWR VGND Tile_X0Y0_FrameData[18] sg13g2_antennanp
XFILLER_0_732 VPWR VGND sg13g2_decap_8
XFILLER_4_548 VPWR VGND sg13g2_fill_2
XFILLER_11_371 VPWR VGND sg13g2_decap_4
X_0621_ VGND VPWR Tile_X0Y0_S4END[10] Tile_X0Y0_S_OBI_left.Inst_S_OBI_left_ConfigMem.Inst_frame0_bit15.Q
+ _0234_ Tile_X0Y0_S_OBI_left.Inst_S_OBI_left_ConfigMem.Inst_frame0_bit16.Q sg13g2_a21oi_1
XFILLER_7_56 VPWR VGND sg13g2_decap_8
X_0552_ Tile_X0Y0_S2END[7] ADDR_top7 Tile_X0Y0_S_OBI_left.Inst_S_OBI_left_ConfigMem.Inst_frame1_bit6.Q
+ Tile_X0Y0_S_OBI_left.Inst_S_OBI_left_switch_matrix.N2BEGb0 VPWR VGND sg13g2_mux2_1
X_0483_ Tile_X2Y0_S4END[3] Tile_X2Y0_S_OBI_right.Inst_S_OBI_right_ConfigMem.Inst_frame0_bit12.Q
+ _0147_ VPWR VGND sg13g2_nor2b_1
X_1035_ Tile_X1Y0_S_OBI_middle.Inst_S_OBI_middle_switch_matrix.NN4BEG3 Tile_X1Y0_NN4BEG[3]
+ VPWR VGND sg13g2_buf_1
X_1104_ Tile_X2Y0_S_OBI_right.Inst_S_OBI_right_switch_matrix.N1BEG3 Tile_X2Y0_N1BEG[3]
+ VPWR VGND sg13g2_buf_1
XFILLER_4_1083 VPWR VGND sg13g2_fill_2
X_0819_ Tile_X0Y0_FrameData[4] Tile_X2Y0_FrameStrobe[1] Tile_X2Y0_S_OBI_right.Inst_S_OBI_right_ConfigMem.Inst_frame1_bit4.Q
+ VPWR VGND sg13g2_dlhq_1
XFILLER_9_618 VPWR VGND sg13g2_decap_4
XFILLER_5_857 VPWR VGND sg13g2_decap_8
XFILLER_10_1088 VPWR VGND sg13g2_fill_2
XFILLER_4_356 VPWR VGND sg13g2_decap_8
XFILLER_1_1201 VPWR VGND sg13g2_decap_8
XFILLER_1_1278 VPWR VGND sg13g2_decap_8
X_0604_ Tile_X0Y0_S4END[2] Tile_X0Y0_S_OBI_left.Inst_S_OBI_left_ConfigMem.Inst_frame0_bit9.Q
+ _0219_ VPWR VGND sg13g2_nor2b_1
X_0535_ Tile_X2Y0_S_OBI_right.Inst_S_OBI_right_ConfigMem.Inst_frame0_bit31.Q VPWR
+ _0193_ VGND _0031_ Tile_X2Y0_S_OBI_right.Inst_S_OBI_right_ConfigMem.Inst_frame0_bit30.Q
+ sg13g2_o21ai_1
X_0466_ Tile_X2Y0_S_OBI_right.Inst_S_OBI_right_ConfigMem.Inst_frame0_bit5.Q _0130_
+ _0131_ _0132_ VPWR VGND sg13g2_nor3_1
X_0397_ _0105_ Tile_X1Y0_S1END[1] Tile_X1Y0_S_OBI_middle.Inst_S_OBI_middle_ConfigMem.Inst_frame0_bit6.Q
+ VPWR VGND sg13g2_nand2b_1
X_1018_ Tile_X1Y0_S_OBI_middle.Inst_S_OBI_middle_switch_matrix.N4BEG2 Tile_X1Y0_N4BEG[2]
+ VPWR VGND sg13g2_buf_1
XFILLER_10_617 VPWR VGND sg13g2_decap_4
XFILLER_9_415 VPWR VGND sg13g2_decap_8
XFILLER_5_654 VPWR VGND sg13g2_decap_8
X_0320_ Tile_X1Y0_S4END[15] ADDR_top23 Tile_X1Y0_S_OBI_middle.Inst_S_OBI_middle_ConfigMem.Inst_frame1_bit2.Q
+ Tile_X1Y0_S_OBI_middle.Inst_S_OBI_middle_switch_matrix.N4BEG0 VPWR VGND sg13g2_mux2_1
XFILLER_1_893 VPWR VGND sg13g2_decap_8
XFILLER_3_1307 VPWR VGND sg13g2_fill_1
XFILLER_4_35 VPWR VGND sg13g2_decap_8
XFILLER_1_1075 VPWR VGND sg13g2_decap_8
X_0518_ Tile_X2Y0_S_OBI_right.Inst_S_OBI_right_ConfigMem.Inst_frame0_bit25.Q VPWR
+ _0178_ VGND _0033_ Tile_X2Y0_S_OBI_right.Inst_S_OBI_right_ConfigMem.Inst_frame0_bit24.Q
+ sg13g2_o21ai_1
X_0449_ _0116_ VPWR Tile_X2Y0_S_OBI_right.Inst_S_OBI_right_switch_matrix.NN4BEG9 VGND
+ _0034_ Tile_X2Y0_S_OBI_right.Inst_S_OBI_right_ConfigMem.Inst_frame0_bit1.Q sg13g2_o21ai_1
XFILLER_7_908 VPWR VGND sg13g2_decap_8
XFILLER_10_436 VPWR VGND sg13g2_decap_4
XFILLER_6_407 VPWR VGND sg13g2_decap_8
XFILLER_1_189 VPWR VGND sg13g2_decap_8
XFILLER_2_646 VPWR VGND sg13g2_decap_8
XFILLER_6_930 VPWR VGND sg13g2_decap_8
XFILLER_5_484 VPWR VGND sg13g2_decap_8
X_0303_ Tile_X1Y0_S2MID[6] BE_top1 Tile_X1Y0_S_OBI_middle.Inst_S_OBI_middle_ConfigMem.Inst_frame2_bit19.Q
+ Tile_X1Y0_S_OBI_middle.Inst_S_OBI_middle_switch_matrix.N2BEG1 VPWR VGND sg13g2_mux2_1
XFILLER_3_1159 VPWR VGND sg13g2_decap_8
X_0998_ Tile_X1Y0_S_OBI_middle.Inst_S_OBI_middle_switch_matrix.N1BEG2 Tile_X1Y0_N1BEG[2]
+ VPWR VGND sg13g2_buf_1
XFILLER_2_443 VPWR VGND sg13g2_decap_8
XFILLER_3_944 VPWR VGND sg13g2_decap_8
X_0921_ Tile_X0Y0_FrameStrobe[18] Tile_X0Y0_FrameStrobe_O[18] VPWR VGND sg13g2_buf_1
XFILLER_2_1170 VPWR VGND sg13g2_fill_2
X_0852_ Tile_X0Y0_FrameData[9] Tile_X0Y0_FrameStrobe[0] Tile_X0Y0_S_OBI_left.Inst_S_OBI_left_ConfigMem.Inst_frame0_bit9.Q
+ VPWR VGND sg13g2_dlhq_1
X_0783_ Tile_X0Y0_FrameData[8] Tile_X2Y0_FrameStrobe[0] Tile_X2Y0_S_OBI_right.Inst_S_OBI_right_ConfigMem.Inst_frame0_bit8.Q
+ VPWR VGND sg13g2_dlhq_1
XFILLER_6_760 VPWR VGND sg13g2_fill_2
XFILLER_0_914 VPWR VGND sg13g2_decap_8
XFILLER_3_218 VPWR VGND sg13g2_fill_1
XFILLER_0_1107 VPWR VGND sg13g2_fill_2
X_1051_ Tile_X0Y0_FrameData[2] Tile_X2Y0_FrameData_O[2] VPWR VGND sg13g2_buf_1
XFILLER_4_1298 VPWR VGND sg13g2_decap_8
X_1120_ Tile_X2Y0_S_OBI_right.Inst_S_OBI_right_switch_matrix.N2BEGb7 Tile_X2Y0_N2BEGb[7]
+ VPWR VGND sg13g2_buf_1
X_0904_ Tile_X0Y0_FrameStrobe[1] Tile_X0Y0_FrameStrobe_O[1] VPWR VGND sg13g2_buf_1
X_0835_ Tile_X0Y0_FrameData[26] Tile_X0Y0_FrameStrobe[0] Tile_X0Y0_S_OBI_left.Inst_S_OBI_left_ConfigMem.Inst_frame0_bit26.Q
+ VPWR VGND sg13g2_dlhq_1
X_0766_ Tile_X0Y0_FrameData[25] Tile_X2Y0_FrameStrobe[0] Tile_X2Y0_S_OBI_right.Inst_S_OBI_right_ConfigMem.Inst_frame0_bit25.Q
+ VPWR VGND sg13g2_dlhq_1
X_0697_ Tile_X0Y0_FrameData[8] Tile_X1Y0_FrameStrobe[0] Tile_X1Y0_S_OBI_middle.Inst_S_OBI_middle_ConfigMem.Inst_frame0_bit8.Q
+ VPWR VGND sg13g2_dlhq_1
XFILLER_9_1165 VPWR VGND sg13g2_fill_2
XANTENNA_95 VPWR VGND Tile_X0Y0_FrameData[18] sg13g2_antennanp
XANTENNA_40 VPWR VGND Tile_X0Y0_FrameData[30] sg13g2_antennanp
XANTENNA_84 VPWR VGND Tile_X0Y0_FrameData[18] sg13g2_antennanp
XANTENNA_51 VPWR VGND Tile_X0Y0_FrameData[5] sg13g2_antennanp
XANTENNA_62 VPWR VGND Tile_X0Y0_FrameData[6] sg13g2_antennanp
XANTENNA_73 VPWR VGND WDATA_top2 sg13g2_antennanp
XFILLER_0_711 VPWR VGND sg13g2_decap_8
XFILLER_0_788 VPWR VGND sg13g2_decap_8
X_0620_ _0233_ Tile_X0Y0_S2END[4] Tile_X0Y0_S_OBI_left.Inst_S_OBI_left_ConfigMem.Inst_frame0_bit15.Q
+ VPWR VGND sg13g2_nand2b_1
X_0551_ Tile_X0Y0_S2MID[0] WDATA_top0 Tile_X0Y0_S_OBI_left.Inst_S_OBI_left_ConfigMem.Inst_frame1_bit5.Q
+ Tile_X0Y0_S_OBI_left.Inst_S_OBI_left_switch_matrix.N2BEG7 VPWR VGND sg13g2_mux2_1
XFILLER_7_35 VPWR VGND sg13g2_decap_8
XFILLER_7_387 VPWR VGND sg13g2_decap_8
X_0482_ Tile_X2Y0_S2MID[3] Tile_X2Y0_S_OBI_right.Inst_S_OBI_right_ConfigMem.Inst_frame0_bit12.Q
+ Tile_X2Y0_S_OBI_right.Inst_S_OBI_right_ConfigMem.Inst_frame0_bit13.Q _0146_ VPWR
+ VGND sg13g2_nor3_1
X_1103_ Tile_X2Y0_S_OBI_right.Inst_S_OBI_right_switch_matrix.N1BEG2 Tile_X2Y0_N1BEG[2]
+ VPWR VGND sg13g2_buf_1
X_1034_ Tile_X1Y0_S_OBI_middle.Inst_S_OBI_middle_switch_matrix.NN4BEG2 Tile_X1Y0_NN4BEG[2]
+ VPWR VGND sg13g2_buf_1
X_0749_ Tile_X0Y0_FrameData[20] Tile_X1Y0_FrameStrobe[2] Tile_X1Y0_S_OBI_middle.Inst_S_OBI_middle_ConfigMem.Inst_frame2_bit20.Q
+ VPWR VGND sg13g2_dlhq_1
X_0818_ Tile_X0Y0_FrameData[5] Tile_X2Y0_FrameStrobe[1] Tile_X2Y0_S_OBI_right.Inst_S_OBI_right_ConfigMem.Inst_frame1_bit5.Q
+ VPWR VGND sg13g2_dlhq_1
XFILLER_8_129 VPWR VGND sg13g2_fill_2
XFILLER_4_335 VPWR VGND sg13g2_decap_8
XFILLER_5_836 VPWR VGND sg13g2_decap_4
XFILLER_0_585 VPWR VGND sg13g2_decap_8
XFILLER_1_1257 VPWR VGND sg13g2_decap_8
XFILLER_7_140 VPWR VGND sg13g2_decap_4
X_0534_ VPWR VGND Tile_X2Y0_S_OBI_right.Inst_S_OBI_right_ConfigMem.Inst_frame0_bit31.Q
+ _0050_ _0191_ _0189_ _0192_ _0190_ sg13g2_a221oi_1
X_0603_ Tile_X0Y0_S2MID[2] Tile_X0Y0_S_OBI_left.Inst_S_OBI_left_ConfigMem.Inst_frame0_bit9.Q
+ Tile_X0Y0_S_OBI_left.Inst_S_OBI_left_ConfigMem.Inst_frame0_bit10.Q _0218_ VPWR VGND
+ sg13g2_nor3_1
X_0465_ Tile_X2Y0_S4END[1] Tile_X2Y0_S_OBI_right.Inst_S_OBI_right_ConfigMem.Inst_frame0_bit6.Q
+ _0131_ VPWR VGND sg13g2_nor2b_1
X_0396_ _0104_ _0101_ _0100_ GNT_top VPWR VGND sg13g2_a21o_1
XFILLER_6_1157 VPWR VGND sg13g2_decap_4
X_1017_ Tile_X1Y0_S_OBI_middle.Inst_S_OBI_middle_switch_matrix.N4BEG1 Tile_X1Y0_N4BEG[1]
+ VPWR VGND sg13g2_buf_1
XFILLER_11_1310 VPWR VGND sg13g2_decap_4
XFILLER_1_349 VPWR VGND sg13g2_decap_8
XFILLER_4_14 VPWR VGND sg13g2_decap_8
XFILLER_5_622 VPWR VGND sg13g2_fill_1
XFILLER_5_688 VPWR VGND sg13g2_decap_4
XFILLER_1_872 VPWR VGND sg13g2_fill_1
XFILLER_1_861 VPWR VGND sg13g2_decap_8
XFILLER_0_382 VPWR VGND sg13g2_decap_8
XFILLER_3_1319 VPWR VGND sg13g2_decap_8
XFILLER_1_1054 VPWR VGND sg13g2_decap_8
XFILLER_9_961 VPWR VGND sg13g2_decap_4
XFILLER_8_1219 VPWR VGND sg13g2_fill_1
X_0517_ Tile_X2Y0_S2MID[7] Tile_X2Y0_S_OBI_right.Inst_S_OBI_right_ConfigMem.Inst_frame0_bit24.Q
+ Tile_X2Y0_S_OBI_right.Inst_S_OBI_right_ConfigMem.Inst_frame0_bit25.Q _0177_ VPWR
+ VGND sg13g2_nor3_1
X_0379_ Tile_X1Y0_S_OBI_middle.Inst_S_OBI_middle_ConfigMem.Inst_frame0_bit26.Q VPWR
+ _0091_ VGND Tile_X1Y0_SS4END[9] Tile_X1Y0_S_OBI_middle.Inst_S_OBI_middle_ConfigMem.Inst_frame0_bit27.Q
+ sg13g2_o21ai_1
X_0448_ _0116_ ADDR_top10 Tile_X2Y0_S_OBI_right.Inst_S_OBI_right_ConfigMem.Inst_frame0_bit1.Q
+ VPWR VGND sg13g2_nand2_1
XFILLER_11_938 VPWR VGND sg13g2_decap_4
XFILLER_2_625 VPWR VGND sg13g2_decap_8
XFILLER_1_168 VPWR VGND sg13g2_decap_8
XFILLER_2_1330 VPWR VGND sg13g2_fill_2
XFILLER_9_257 VPWR VGND sg13g2_fill_1
X_0302_ Tile_X1Y0_S2MID[7] BE_top0 Tile_X1Y0_S_OBI_middle.Inst_S_OBI_middle_ConfigMem.Inst_frame2_bit18.Q
+ Tile_X1Y0_S_OBI_middle.Inst_S_OBI_middle_switch_matrix.N2BEG0 VPWR VGND sg13g2_mux2_1
XFILLER_5_463 VPWR VGND sg13g2_decap_8
XFILLER_6_986 VPWR VGND sg13g2_decap_8
XFILLER_7_1296 VPWR VGND sg13g2_decap_8
XFILLER_7_1230 VPWR VGND sg13g2_fill_1
X_0997_ Tile_X1Y0_S_OBI_middle.Inst_S_OBI_middle_switch_matrix.N1BEG1 Tile_X1Y0_N1BEG[1]
+ VPWR VGND sg13g2_buf_1
XFILLER_11_768 VPWR VGND sg13g2_fill_2
XFILLER_2_422 VPWR VGND sg13g2_decap_8
XFILLER_2_499 VPWR VGND sg13g2_decap_8
XFILLER_3_923 VPWR VGND sg13g2_decap_8
XFILLER_1_59 VPWR VGND sg13g2_decap_8
X_0920_ Tile_X0Y0_FrameStrobe[17] Tile_X0Y0_FrameStrobe_O[17] VPWR VGND sg13g2_buf_1
XANTENNA_130 VPWR VGND Tile_X0Y0_FrameData[23] sg13g2_antennanp
X_0851_ Tile_X0Y0_FrameData[10] Tile_X0Y0_FrameStrobe[0] Tile_X0Y0_S_OBI_left.Inst_S_OBI_left_ConfigMem.Inst_frame0_bit10.Q
+ VPWR VGND sg13g2_dlhq_1
X_0782_ Tile_X0Y0_FrameData[9] Tile_X2Y0_FrameStrobe[0] Tile_X2Y0_S_OBI_right.Inst_S_OBI_right_ConfigMem.Inst_frame0_bit9.Q
+ VPWR VGND sg13g2_dlhq_1
XFILLER_10_35 VPWR VGND sg13g2_decap_4
XFILLER_3_797 VPWR VGND sg13g2_decap_8
X_1050_ Tile_X0Y0_FrameData[1] Tile_X2Y0_FrameData_O[1] VPWR VGND sg13g2_buf_1
XFILLER_4_1277 VPWR VGND sg13g2_decap_8
X_0903_ Tile_X0Y0_FrameStrobe[0] Tile_X0Y0_FrameStrobe_O[0] VPWR VGND sg13g2_buf_1
X_0834_ Tile_X0Y0_FrameData[27] Tile_X0Y0_FrameStrobe[0] Tile_X0Y0_S_OBI_left.Inst_S_OBI_left_ConfigMem.Inst_frame0_bit27.Q
+ VPWR VGND sg13g2_dlhq_1
X_0765_ Tile_X0Y0_FrameData[26] Tile_X2Y0_FrameStrobe[0] Tile_X2Y0_S_OBI_right.Inst_S_OBI_right_ConfigMem.Inst_frame0_bit26.Q
+ VPWR VGND sg13g2_dlhq_1
X_0696_ Tile_X0Y0_FrameData[9] Tile_X1Y0_FrameStrobe[0] Tile_X1Y0_S_OBI_middle.Inst_S_OBI_middle_ConfigMem.Inst_frame0_bit9.Q
+ VPWR VGND sg13g2_dlhq_1
XFILLER_2_91 VPWR VGND sg13g2_decap_8
XFILLER_5_1019 VPWR VGND sg13g2_decap_8
XANTENNA_96 VPWR VGND Tile_X0Y0_FrameData[18] sg13g2_antennanp
XANTENNA_74 VPWR VGND WDATA_top4 sg13g2_antennanp
XFILLER_10_1249 VPWR VGND sg13g2_fill_2
XANTENNA_85 VPWR VGND Tile_X0Y0_FrameData[18] sg13g2_antennanp
XANTENNA_41 VPWR VGND Tile_X0Y0_FrameData[30] sg13g2_antennanp
XANTENNA_63 VPWR VGND Tile_X0Y0_FrameData[6] sg13g2_antennanp
XANTENNA_30 VPWR VGND Tile_X0Y0_FrameData[1] sg13g2_antennanp
XFILLER_4_517 VPWR VGND sg13g2_decap_8
XANTENNA_52 VPWR VGND Tile_X0Y0_FrameData[5] sg13g2_antennanp
XFILLER_0_767 VPWR VGND sg13g2_decap_8
XFILLER_8_834 VPWR VGND sg13g2_fill_2
XFILLER_8_801 VPWR VGND sg13g2_fill_1
XFILLER_7_14 VPWR VGND sg13g2_decap_8
XFILLER_7_311 VPWR VGND sg13g2_fill_2
XFILLER_8_878 VPWR VGND sg13g2_decap_8
X_0550_ Tile_X0Y0_S2MID[1] WDATA_top1 Tile_X0Y0_S_OBI_left.Inst_S_OBI_left_ConfigMem.Inst_frame1_bit4.Q
+ Tile_X0Y0_S_OBI_left.Inst_S_OBI_left_switch_matrix.N2BEG6 VPWR VGND sg13g2_mux2_1
X_0481_ Tile_X2Y0_S_OBI_right.Inst_S_OBI_right_ConfigMem.Inst_frame0_bit13.Q VPWR
+ _0145_ VGND Tile_X2Y0_S_OBI_right.Inst_S_OBI_right_ConfigMem.Inst_frame0_bit12.Q
+ _0042_ sg13g2_o21ai_1
X_1102_ Tile_X2Y0_S_OBI_right.Inst_S_OBI_right_switch_matrix.N1BEG1 Tile_X2Y0_N1BEG[1]
+ VPWR VGND sg13g2_buf_1
XFILLER_3_583 VPWR VGND sg13g2_decap_8
X_1033_ Tile_X1Y0_S_OBI_middle.Inst_S_OBI_middle_switch_matrix.NN4BEG1 Tile_X1Y0_NN4BEG[1]
+ VPWR VGND sg13g2_buf_1
XFILLER_4_1085 VPWR VGND sg13g2_fill_1
X_0817_ Tile_X0Y0_FrameData[6] Tile_X2Y0_FrameStrobe[1] Tile_X2Y0_S_OBI_right.Inst_S_OBI_right_ConfigMem.Inst_frame1_bit6.Q
+ VPWR VGND sg13g2_dlhq_1
X_0679_ Tile_X0Y0_FrameData[26] Tile_X1Y0_FrameStrobe[0] Tile_X1Y0_S_OBI_middle.Inst_S_OBI_middle_ConfigMem.Inst_frame0_bit26.Q
+ VPWR VGND sg13g2_dlhq_1
X_0748_ Tile_X0Y0_FrameData[21] Tile_X1Y0_FrameStrobe[2] Tile_X1Y0_S_OBI_middle.Inst_S_OBI_middle_ConfigMem.Inst_frame2_bit21.Q
+ VPWR VGND sg13g2_dlhq_1
XFILLER_1_509 VPWR VGND sg13g2_decap_8
XFILLER_10_1024 VPWR VGND sg13g2_fill_1
XFILLER_4_303 VPWR VGND sg13g2_decap_8
XFILLER_5_804 VPWR VGND sg13g2_fill_2
XFILLER_0_564 VPWR VGND sg13g2_decap_8
XFILLER_1_1236 VPWR VGND sg13g2_decap_8
X_0533_ Tile_X2Y0_SS4END[15] Tile_X2Y0_S_OBI_right.Inst_S_OBI_right_ConfigMem.Inst_frame0_bit30.Q
+ _0191_ VPWR VGND sg13g2_nor2_1
XFILLER_3_380 VPWR VGND sg13g2_decap_8
X_0464_ Tile_X2Y0_S2MID[1] Tile_X2Y0_S_OBI_right.Inst_S_OBI_right_ConfigMem.Inst_frame0_bit6.Q
+ Tile_X2Y0_S_OBI_right.Inst_S_OBI_right_ConfigMem.Inst_frame0_bit7.Q _0130_ VPWR
+ VGND sg13g2_nor3_1
XFILLER_4_881 VPWR VGND sg13g2_decap_8
X_0602_ Tile_X0Y0_S_OBI_left.Inst_S_OBI_left_ConfigMem.Inst_frame0_bit10.Q VPWR _0217_
+ VGND Tile_X0Y0_S_OBI_left.Inst_S_OBI_left_ConfigMem.Inst_frame0_bit9.Q _0060_ sg13g2_o21ai_1
X_0395_ Tile_X1Y0_S_OBI_middle.Inst_S_OBI_middle_ConfigMem.Inst_frame0_bit2.Q _0102_
+ _0103_ _0104_ VPWR VGND sg13g2_nor3_1
X_1016_ Tile_X1Y0_S_OBI_middle.Inst_S_OBI_middle_switch_matrix.N4BEG0 Tile_X1Y0_N4BEG[0]
+ VPWR VGND sg13g2_buf_1
XFILLER_2_829 VPWR VGND sg13g2_decap_8
XFILLER_0_1291 VPWR VGND sg13g2_decap_8
XFILLER_5_612 VPWR VGND sg13g2_fill_1
XFILLER_1_840 VPWR VGND sg13g2_fill_1
XFILLER_1_1033 VPWR VGND sg13g2_decap_8
XFILLER_1_884 VPWR VGND sg13g2_decap_4
XFILLER_0_361 VPWR VGND sg13g2_decap_8
XFILLER_9_940 VPWR VGND sg13g2_decap_4
XFILLER_8_494 VPWR VGND sg13g2_decap_8
X_0516_ VPWR VGND Tile_X2Y0_S_OBI_right.Inst_S_OBI_right_ConfigMem.Inst_frame0_bit25.Q
+ _0048_ _0175_ _0173_ _0176_ _0174_ sg13g2_a221oi_1
X_0447_ _0115_ VPWR Tile_X2Y0_S_OBI_right.Inst_S_OBI_right_switch_matrix.NN4BEG8 VGND
+ _0033_ Tile_X2Y0_S_OBI_right.Inst_S_OBI_right_ConfigMem.Inst_frame0_bit0.Q sg13g2_o21ai_1
X_0378_ _0089_ VPWR RDATA_top28 VGND Tile_X1Y0_S_OBI_middle.Inst_S_OBI_middle_ConfigMem.Inst_frame0_bit25.Q
+ _0090_ sg13g2_o21ai_1
XFILLER_11_917 VPWR VGND sg13g2_decap_8
XFILLER_11_1130 VPWR VGND sg13g2_fill_2
XFILLER_1_125 VPWR VGND sg13g2_decap_8
XFILLER_1_147 VPWR VGND sg13g2_decap_8
XFILLER_2_604 VPWR VGND sg13g2_decap_8
XFILLER_5_442 VPWR VGND sg13g2_decap_8
XFILLER_6_965 VPWR VGND sg13g2_decap_8
XFILLER_1_692 VPWR VGND sg13g2_decap_8
XFILLER_1_670 VPWR VGND sg13g2_decap_8
X_0301_ Tile_X1Y0_S_OBI_middle.Inst_S_OBI_middle_ConfigMem.Inst_frame2_bit17.Q Tile_X1Y0_S1END[0]
+ WE_top REQ_top BE_top0 Tile_X1Y0_S_OBI_middle.Inst_S_OBI_middle_ConfigMem.Inst_frame2_bit16.Q
+ Tile_X1Y0_S_OBI_middle.Inst_S_OBI_middle_switch_matrix.N1BEG3 VPWR VGND sg13g2_mux4_1
XFILLER_7_1275 VPWR VGND sg13g2_decap_8
XFILLER_3_1128 VPWR VGND sg13g2_fill_1
X_0996_ Tile_X1Y0_S_OBI_middle.Inst_S_OBI_middle_switch_matrix.N1BEG0 Tile_X1Y0_N1BEG[0]
+ VPWR VGND sg13g2_buf_1
XFILLER_11_725 VPWR VGND sg13g2_fill_1
XFILLER_7_707 VPWR VGND sg13g2_decap_4
XFILLER_3_902 VPWR VGND sg13g2_decap_8
XFILLER_6_239 VPWR VGND sg13g2_fill_2
XFILLER_2_401 VPWR VGND sg13g2_decap_8
XFILLER_2_478 VPWR VGND sg13g2_decap_8
XFILLER_3_979 VPWR VGND sg13g2_decap_8
XANTENNA_131 VPWR VGND Tile_X0Y0_FrameData[23] sg13g2_antennanp
XFILLER_1_38 VPWR VGND sg13g2_decap_8
XFILLER_2_1172 VPWR VGND sg13g2_fill_1
XANTENNA_120 VPWR VGND Tile_X0Y0_FrameData[20] sg13g2_antennanp
X_0850_ Tile_X0Y0_FrameData[11] Tile_X0Y0_FrameStrobe[0] Tile_X0Y0_S_OBI_left.Inst_S_OBI_left_ConfigMem.Inst_frame0_bit11.Q
+ VPWR VGND sg13g2_dlhq_1
X_0781_ Tile_X0Y0_FrameData[10] Tile_X2Y0_FrameStrobe[0] Tile_X2Y0_S_OBI_right.Inst_S_OBI_right_ConfigMem.Inst_frame0_bit10.Q
+ VPWR VGND sg13g2_dlhq_1
XFILLER_6_795 VPWR VGND sg13g2_decap_4
XFILLER_2_990 VPWR VGND sg13g2_decap_8
X_0979_ Tile_X1Y0_FrameStrobe[3] Tile_X1Y0_FrameStrobe_O[3] VPWR VGND sg13g2_buf_1
XFILLER_10_14 VPWR VGND sg13g2_decap_8
XFILLER_0_949 VPWR VGND sg13g2_decap_8
XFILLER_11_500 VPWR VGND sg13g2_decap_4
XFILLER_11_599 VPWR VGND sg13g2_decap_8
XFILLER_4_0 VPWR VGND sg13g2_decap_8
XFILLER_4_1256 VPWR VGND sg13g2_decap_8
X_0902_ VPWR VGND Tile_X0Y0_Co sg13g2_tielo
X_0833_ Tile_X0Y0_FrameData[28] Tile_X0Y0_FrameStrobe[0] Tile_X0Y0_S_OBI_left.Inst_S_OBI_left_ConfigMem.Inst_frame0_bit28.Q
+ VPWR VGND sg13g2_dlhq_1
X_0764_ Tile_X0Y0_FrameData[27] Tile_X2Y0_FrameStrobe[0] Tile_X2Y0_S_OBI_right.Inst_S_OBI_right_ConfigMem.Inst_frame0_bit27.Q
+ VPWR VGND sg13g2_dlhq_1
X_0695_ Tile_X0Y0_FrameData[10] Tile_X1Y0_FrameStrobe[0] Tile_X1Y0_S_OBI_middle.Inst_S_OBI_middle_ConfigMem.Inst_frame0_bit10.Q
+ VPWR VGND sg13g2_dlhq_1
XFILLER_9_1167 VPWR VGND sg13g2_fill_1
XFILLER_2_70 VPWR VGND sg13g2_decap_8
XFILLER_5_1009 VPWR VGND sg13g2_fill_2
XANTENNA_20 VPWR VGND Tile_X0Y0_FrameData[14] sg13g2_antennanp
XANTENNA_31 VPWR VGND Tile_X0Y0_FrameData[30] sg13g2_antennanp
XANTENNA_97 VPWR VGND Tile_X0Y0_FrameData[18] sg13g2_antennanp
XANTENNA_86 VPWR VGND Tile_X0Y0_FrameData[18] sg13g2_antennanp
XANTENNA_75 VPWR VGND WDATA_top4 sg13g2_antennanp
XANTENNA_42 VPWR VGND Tile_X0Y0_FrameData[30] sg13g2_antennanp
XANTENNA_64 VPWR VGND Tile_X0Y0_FrameData[6] sg13g2_antennanp
XANTENNA_53 VPWR VGND Tile_X0Y0_FrameData[5] sg13g2_antennanp
XFILLER_0_746 VPWR VGND sg13g2_decap_8
X_0480_ VPWR VGND Tile_X2Y0_S_OBI_right.Inst_S_OBI_right_ConfigMem.Inst_frame0_bit13.Q
+ _0041_ _0143_ _0141_ _0144_ _0142_ sg13g2_a221oi_1
XFILLER_3_562 VPWR VGND sg13g2_decap_8
X_1101_ Tile_X2Y0_S_OBI_right.Inst_S_OBI_right_switch_matrix.N1BEG0 Tile_X2Y0_N1BEG[0]
+ VPWR VGND sg13g2_buf_1
X_1032_ Tile_X1Y0_S_OBI_middle.Inst_S_OBI_middle_switch_matrix.NN4BEG0 Tile_X1Y0_NN4BEG[0]
+ VPWR VGND sg13g2_buf_1
X_0747_ Tile_X0Y0_FrameData[22] Tile_X1Y0_FrameStrobe[2] Tile_X1Y0_S_OBI_middle.Inst_S_OBI_middle_ConfigMem.Inst_frame2_bit22.Q
+ VPWR VGND sg13g2_dlhq_1
X_0816_ Tile_X0Y0_FrameData[7] Tile_X2Y0_FrameStrobe[1] Tile_X2Y0_S_OBI_right.Inst_S_OBI_right_ConfigMem.Inst_frame1_bit7.Q
+ VPWR VGND sg13g2_dlhq_1
X_0678_ Tile_X0Y0_FrameData[27] Tile_X1Y0_FrameStrobe[0] Tile_X1Y0_S_OBI_middle.Inst_S_OBI_middle_ConfigMem.Inst_frame0_bit27.Q
+ VPWR VGND sg13g2_dlhq_1
XFILLER_0_543 VPWR VGND sg13g2_decap_8
XFILLER_1_1215 VPWR VGND sg13g2_decap_8
XFILLER_8_665 VPWR VGND sg13g2_fill_2
XFILLER_8_632 VPWR VGND sg13g2_fill_2
XFILLER_8_621 VPWR VGND sg13g2_fill_1
X_0601_ _0216_ _0213_ _0212_ RDATA_top1 VPWR VGND sg13g2_a21o_1
XFILLER_7_131 VPWR VGND sg13g2_fill_1
X_0532_ VGND VPWR Tile_X2Y0_S4END[15] Tile_X2Y0_S_OBI_right.Inst_S_OBI_right_ConfigMem.Inst_frame0_bit30.Q
+ _0190_ Tile_X2Y0_S_OBI_right.Inst_S_OBI_right_ConfigMem.Inst_frame0_bit31.Q sg13g2_a21oi_1
XFILLER_4_860 VPWR VGND sg13g2_decap_8
X_0463_ Tile_X2Y0_S_OBI_right.Inst_S_OBI_right_ConfigMem.Inst_frame0_bit7.Q VPWR _0129_
+ VGND Tile_X2Y0_S_OBI_right.Inst_S_OBI_right_ConfigMem.Inst_frame0_bit6.Q _0038_
+ sg13g2_o21ai_1
X_0394_ Tile_X1Y0_S1END[2] Tile_X1Y0_S_OBI_middle.Inst_S_OBI_middle_ConfigMem.Inst_frame0_bit3.Q
+ _0103_ VPWR VGND sg13g2_nor2b_1
XFILLER_6_1126 VPWR VGND sg13g2_decap_4
X_1015_ Tile_X1Y0_S_OBI_middle.Inst_S_OBI_middle_switch_matrix.N2BEGb7 Tile_X1Y0_N2BEGb[7]
+ VPWR VGND sg13g2_buf_1
XFILLER_11_1323 VPWR VGND sg13g2_decap_8
XFILLER_1_329 VPWR VGND sg13g2_fill_1
XFILLER_2_808 VPWR VGND sg13g2_decap_8
XFILLER_0_1270 VPWR VGND sg13g2_decap_8
XFILLER_9_429 VPWR VGND sg13g2_decap_8
XFILLER_4_112 VPWR VGND sg13g2_decap_8
XFILLER_4_123 VPWR VGND sg13g2_decap_8
XFILLER_1_852 VPWR VGND sg13g2_decap_4
XFILLER_0_340 VPWR VGND sg13g2_decap_8
XFILLER_4_49 VPWR VGND sg13g2_decap_8
XFILLER_5_668 VPWR VGND sg13g2_fill_2
XFILLER_1_1012 VPWR VGND sg13g2_decap_8
XFILLER_1_1089 VPWR VGND sg13g2_decap_8
XFILLER_8_473 VPWR VGND sg13g2_decap_8
X_0515_ Tile_X2Y0_SS4END[13] Tile_X2Y0_S_OBI_right.Inst_S_OBI_right_ConfigMem.Inst_frame0_bit24.Q
+ _0175_ VPWR VGND sg13g2_nor2_1
X_0377_ _0090_ Tile_X1Y0_S4END[8] Tile_X1Y0_S_OBI_middle.Inst_S_OBI_middle_ConfigMem.Inst_frame0_bit24.Q
+ VPWR VGND sg13g2_nand2b_1
X_0446_ _0115_ ADDR_top11 Tile_X2Y0_S_OBI_right.Inst_S_OBI_right_ConfigMem.Inst_frame0_bit0.Q
+ VPWR VGND sg13g2_nand2_1
XFILLER_8_7 VPWR VGND sg13g2_decap_8
XFILLER_1_104 VPWR VGND sg13g2_fill_1
XFILLER_5_421 VPWR VGND sg13g2_decap_8
XFILLER_5_498 VPWR VGND sg13g2_decap_8
XFILLER_6_944 VPWR VGND sg13g2_decap_8
X_0300_ Tile_X1Y0_S_OBI_middle.Inst_S_OBI_middle_ConfigMem.Inst_frame2_bit15.Q Tile_X1Y0_S1END[1]
+ WE_top REQ_top BE_top1 Tile_X1Y0_S_OBI_middle.Inst_S_OBI_middle_ConfigMem.Inst_frame2_bit14.Q
+ Tile_X1Y0_S_OBI_middle.Inst_S_OBI_middle_switch_matrix.N1BEG2 VPWR VGND sg13g2_mux4_1
X_0995_ Tile_X1Y0_FrameStrobe[19] Tile_X1Y0_FrameStrobe_O[19] VPWR VGND sg13g2_buf_1
XFILLER_5_70 VPWR VGND sg13g2_decap_8
X_0429_ Tile_X2Y0_S4END[12] WDATA_top16 Tile_X2Y0_S_OBI_right.Inst_S_OBI_right_ConfigMem.Inst_frame1_bit17.Q
+ Tile_X2Y0_S_OBI_right.Inst_S_OBI_right_switch_matrix.N4BEG3 VPWR VGND sg13g2_mux2_1
XFILLER_6_218 VPWR VGND sg13g2_fill_1
XFILLER_6_229 VPWR VGND sg13g2_decap_8
XFILLER_1_17 VPWR VGND sg13g2_decap_8
XFILLER_2_457 VPWR VGND sg13g2_decap_8
XFILLER_3_958 VPWR VGND sg13g2_decap_8
XANTENNA_132 VPWR VGND Tile_X0Y0_FrameData[23] sg13g2_antennanp
XANTENNA_110 VPWR VGND Tile_X0Y0_FrameData[2] sg13g2_antennanp
XANTENNA_121 VPWR VGND Tile_X0Y0_FrameData[20] sg13g2_antennanp
X_0780_ Tile_X0Y0_FrameData[11] Tile_X2Y0_FrameStrobe[0] Tile_X2Y0_S_OBI_right.Inst_S_OBI_right_ConfigMem.Inst_frame0_bit11.Q
+ VPWR VGND sg13g2_dlhq_1
X_0978_ Tile_X1Y0_FrameStrobe[2] Tile_X1Y0_FrameStrobe_O[2] VPWR VGND sg13g2_buf_1
XFILLER_0_928 VPWR VGND sg13g2_decap_8
XFILLER_2_243 VPWR VGND sg13g2_decap_8
XFILLER_2_254 VPWR VGND sg13g2_fill_2
XFILLER_3_755 VPWR VGND sg13g2_decap_8
XFILLER_2_287 VPWR VGND sg13g2_decap_8
XFILLER_4_1202 VPWR VGND sg13g2_decap_8
XFILLER_4_1235 VPWR VGND sg13g2_decap_8
X_0763_ Tile_X0Y0_FrameData[28] Tile_X2Y0_FrameStrobe[0] Tile_X2Y0_S_OBI_right.Inst_S_OBI_right_ConfigMem.Inst_frame0_bit28.Q
+ VPWR VGND sg13g2_dlhq_1
X_0832_ Tile_X0Y0_FrameData[29] Tile_X0Y0_FrameStrobe[0] Tile_X0Y0_S_OBI_left.Inst_S_OBI_left_ConfigMem.Inst_frame0_bit29.Q
+ VPWR VGND sg13g2_dlhq_1
X_0901_ VPWR VGND Tile_X2Y0_Co sg13g2_tielo
X_0694_ Tile_X0Y0_FrameData[11] Tile_X1Y0_FrameStrobe[0] Tile_X1Y0_S_OBI_middle.Inst_S_OBI_middle_ConfigMem.Inst_frame0_bit11.Q
+ VPWR VGND sg13g2_dlhq_1
XANTENNA_43 VPWR VGND Tile_X0Y0_FrameData[30] sg13g2_antennanp
XANTENNA_21 VPWR VGND Tile_X0Y0_FrameData[14] sg13g2_antennanp
XANTENNA_32 VPWR VGND Tile_X0Y0_FrameData[30] sg13g2_antennanp
XANTENNA_65 VPWR VGND Tile_X0Y0_FrameData[9] sg13g2_antennanp
XANTENNA_54 VPWR VGND Tile_X0Y0_FrameData[5] sg13g2_antennanp
XANTENNA_10 VPWR VGND Tile_X0Y0_FrameData[0] sg13g2_antennanp
XANTENNA_87 VPWR VGND Tile_X0Y0_FrameData[18] sg13g2_antennanp
XANTENNA_76 VPWR VGND WDATA_top4 sg13g2_antennanp
XANTENNA_98 VPWR VGND Tile_X0Y0_FrameData[18] sg13g2_antennanp
XFILLER_0_725 VPWR VGND sg13g2_decap_8
XFILLER_11_375 VPWR VGND sg13g2_fill_1
XFILLER_8_836 VPWR VGND sg13g2_fill_1
XFILLER_7_49 VPWR VGND sg13g2_decap_8
XFILLER_3_541 VPWR VGND sg13g2_decap_8
X_1100_ Tile_X2Y0_FrameStrobe[19] Tile_X2Y0_FrameStrobe_O[19] VPWR VGND sg13g2_buf_1
XFILLER_4_1076 VPWR VGND sg13g2_fill_2
XFILLER_4_1098 VPWR VGND sg13g2_decap_8
X_1031_ Tile_X1Y0_S_OBI_middle.Inst_S_OBI_middle_switch_matrix.N4BEG15 Tile_X1Y0_N4BEG[15]
+ VPWR VGND sg13g2_buf_1
X_0815_ Tile_X0Y0_FrameData[8] Tile_X2Y0_FrameStrobe[1] Tile_X2Y0_S_OBI_right.Inst_S_OBI_right_ConfigMem.Inst_frame1_bit8.Q
+ VPWR VGND sg13g2_dlhq_1
X_0746_ Tile_X0Y0_FrameData[23] Tile_X1Y0_FrameStrobe[2] Tile_X1Y0_S_OBI_middle.Inst_S_OBI_middle_ConfigMem.Inst_frame2_bit23.Q
+ VPWR VGND sg13g2_dlhq_1
XFILLER_7_880 VPWR VGND sg13g2_decap_8
X_0677_ Tile_X0Y0_FrameData[28] Tile_X1Y0_FrameStrobe[0] Tile_X1Y0_S_OBI_middle.Inst_S_OBI_middle_ConfigMem.Inst_frame0_bit28.Q
+ VPWR VGND sg13g2_dlhq_1
XFILLER_10_1059 VPWR VGND sg13g2_fill_1
XFILLER_0_522 VPWR VGND sg13g2_decap_8
XFILLER_4_349 VPWR VGND sg13g2_decap_8
XFILLER_0_599 VPWR VGND sg13g2_decap_8
XFILLER_5_1330 VPWR VGND sg13g2_fill_2
X_0531_ _0189_ Tile_X2Y0_S1END[3] Tile_X2Y0_S_OBI_right.Inst_S_OBI_right_ConfigMem.Inst_frame0_bit30.Q
+ VPWR VGND sg13g2_nand2b_1
X_0600_ Tile_X0Y0_S_OBI_left.Inst_S_OBI_left_ConfigMem.Inst_frame0_bit5.Q _0214_ _0215_
+ _0216_ VPWR VGND sg13g2_nor3_1
XFILLER_7_187 VPWR VGND sg13g2_decap_4
X_0462_ VPWR VGND Tile_X2Y0_S_OBI_right.Inst_S_OBI_right_ConfigMem.Inst_frame0_bit7.Q
+ _0037_ _0127_ _0125_ _0128_ _0126_ sg13g2_a221oi_1
X_0393_ Tile_X1Y0_S1END[0] Tile_X1Y0_S_OBI_middle.Inst_S_OBI_middle_ConfigMem.Inst_frame0_bit3.Q
+ Tile_X1Y0_S_OBI_middle.Inst_S_OBI_middle_ConfigMem.Inst_frame0_bit4.Q _0102_ VPWR
+ VGND sg13g2_nor3_1
X_1014_ Tile_X1Y0_S_OBI_middle.Inst_S_OBI_middle_switch_matrix.N2BEGb6 Tile_X1Y0_N2BEGb[6]
+ VPWR VGND sg13g2_buf_1
XFILLER_8_81 VPWR VGND sg13g2_fill_1
X_0729_ Tile_X0Y0_FrameData[8] Tile_X1Y0_FrameStrobe[1] Tile_X1Y0_S_OBI_middle.Inst_S_OBI_middle_ConfigMem.Inst_frame1_bit8.Q
+ VPWR VGND sg13g2_dlhq_1
XFILLER_9_408 VPWR VGND sg13g2_decap_8
XFILLER_0_396 VPWR VGND sg13g2_decap_8
XFILLER_4_28 VPWR VGND sg13g2_decap_8
XFILLER_1_1068 VPWR VGND sg13g2_decap_8
XFILLER_8_452 VPWR VGND sg13g2_decap_8
X_0514_ VGND VPWR Tile_X2Y0_S4END[13] Tile_X2Y0_S_OBI_right.Inst_S_OBI_right_ConfigMem.Inst_frame0_bit24.Q
+ _0174_ Tile_X2Y0_S_OBI_right.Inst_S_OBI_right_ConfigMem.Inst_frame0_bit25.Q sg13g2_a21oi_1
X_0376_ Tile_X1Y0_S_OBI_middle.Inst_S_OBI_middle_ConfigMem.Inst_frame0_bit24.Q VPWR
+ _0089_ VGND Tile_X1Y0_SS4END[8] Tile_X1Y0_S_OBI_middle.Inst_S_OBI_middle_ConfigMem.Inst_frame0_bit25.Q
+ sg13g2_o21ai_1
X_0445_ _0114_ VPWR Tile_X2Y0_S_OBI_right.Inst_S_OBI_right_switch_matrix.NN4BEG7 VGND
+ _0032_ Tile_X2Y0_S_OBI_right.Inst_S_OBI_right_ConfigMem.Inst_frame1_bit31.Q sg13g2_o21ai_1
XFILLER_10_429 VPWR VGND sg13g2_decap_8
XFILLER_1_116 VPWR VGND sg13g2_decap_4
XFILLER_2_639 VPWR VGND sg13g2_decap_8
XFILLER_10_930 VPWR VGND sg13g2_decap_8
XFILLER_5_400 VPWR VGND sg13g2_decap_8
XFILLER_5_477 VPWR VGND sg13g2_decap_8
XFILLER_6_923 VPWR VGND sg13g2_decap_8
XFILLER_0_182 VPWR VGND sg13g2_decap_8
XFILLER_3_1108 VPWR VGND sg13g2_fill_2
X_0994_ Tile_X1Y0_FrameStrobe[18] Tile_X1Y0_FrameStrobe_O[18] VPWR VGND sg13g2_buf_1
X_0428_ Tile_X2Y0_S4END[13] WDATA_top17 Tile_X2Y0_S_OBI_right.Inst_S_OBI_right_ConfigMem.Inst_frame1_bit16.Q
+ Tile_X2Y0_S_OBI_right.Inst_S_OBI_right_switch_matrix.N4BEG2 VPWR VGND sg13g2_mux2_1
X_0359_ _0078_ Tile_X1Y0_S4END[2] Tile_X1Y0_S_OBI_middle.Inst_S_OBI_middle_ConfigMem.Inst_frame0_bit12.Q
+ VPWR VGND sg13g2_nand2b_1
XFILLER_2_436 VPWR VGND sg13g2_decap_8
XFILLER_3_937 VPWR VGND sg13g2_decap_8
XFILLER_2_1163 VPWR VGND sg13g2_decap_8
XANTENNA_122 VPWR VGND Tile_X0Y0_FrameData[20] sg13g2_antennanp
XANTENNA_100 VPWR VGND Tile_X0Y0_FrameData[22] sg13g2_antennanp
XANTENNA_133 VPWR VGND Tile_X0Y0_FrameData[23] sg13g2_antennanp
XANTENNA_111 VPWR VGND Tile_X0Y0_FrameData[2] sg13g2_antennanp
XFILLER_9_1306 VPWR VGND sg13g2_decap_4
XFILLER_7_1030 VPWR VGND sg13g2_decap_4
X_0977_ Tile_X1Y0_FrameStrobe[1] Tile_X1Y0_FrameStrobe_O[1] VPWR VGND sg13g2_buf_1
XFILLER_0_907 VPWR VGND sg13g2_decap_8
XFILLER_11_568 VPWR VGND sg13g2_fill_2
XFILLER_7_506 VPWR VGND sg13g2_decap_8
XFILLER_2_211 VPWR VGND sg13g2_decap_8
XFILLER_2_266 VPWR VGND sg13g2_fill_1
XFILLER_2_277 VPWR VGND sg13g2_fill_2
X_0900_ VPWR VGND Tile_X1Y0_Co sg13g2_tielo
X_0831_ Tile_X0Y0_FrameData[30] Tile_X0Y0_FrameStrobe[0] Tile_X0Y0_S_OBI_left.Inst_S_OBI_left_ConfigMem.Inst_frame0_bit30.Q
+ VPWR VGND sg13g2_dlhq_1
X_0762_ Tile_X0Y0_FrameData[29] Tile_X2Y0_FrameStrobe[0] Tile_X2Y0_S_OBI_right.Inst_S_OBI_right_ConfigMem.Inst_frame0_bit29.Q
+ VPWR VGND sg13g2_dlhq_1
X_0693_ Tile_X0Y0_FrameData[12] Tile_X1Y0_FrameStrobe[0] Tile_X1Y0_S_OBI_middle.Inst_S_OBI_middle_ConfigMem.Inst_frame0_bit12.Q
+ VPWR VGND sg13g2_dlhq_1
XANTENNA_88 VPWR VGND Tile_X0Y0_FrameData[18] sg13g2_antennanp
XANTENNA_11 VPWR VGND Tile_X0Y0_FrameData[0] sg13g2_antennanp
XANTENNA_44 VPWR VGND Tile_X0Y0_FrameData[30] sg13g2_antennanp
XANTENNA_66 VPWR VGND Tile_X0Y0_FrameData[9] sg13g2_antennanp
XANTENNA_77 VPWR VGND WDATA_top4 sg13g2_antennanp
XANTENNA_33 VPWR VGND Tile_X0Y0_FrameData[30] sg13g2_antennanp
XANTENNA_99 VPWR VGND Tile_X0Y0_FrameData[18] sg13g2_antennanp
XANTENNA_55 VPWR VGND Tile_X0Y0_FrameData[5] sg13g2_antennanp
XANTENNA_22 VPWR VGND Tile_X0Y0_FrameData[14] sg13g2_antennanp
XFILLER_0_704 VPWR VGND sg13g2_decap_8
XFILLER_3_520 VPWR VGND sg13g2_decap_8
XFILLER_7_28 VPWR VGND sg13g2_decap_8
XFILLER_3_597 VPWR VGND sg13g2_decap_8
XFILLER_4_1000 VPWR VGND sg13g2_decap_4
XFILLER_6_1309 VPWR VGND sg13g2_fill_2
X_1030_ Tile_X1Y0_S_OBI_middle.Inst_S_OBI_middle_switch_matrix.N4BEG14 Tile_X1Y0_N4BEG[14]
+ VPWR VGND sg13g2_buf_1
XFILLER_4_1055 VPWR VGND sg13g2_fill_1
X_0814_ Tile_X0Y0_FrameData[9] Tile_X2Y0_FrameStrobe[1] Tile_X2Y0_S_OBI_right.Inst_S_OBI_right_ConfigMem.Inst_frame1_bit9.Q
+ VPWR VGND sg13g2_dlhq_1
X_0676_ Tile_X0Y0_FrameData[29] Tile_X1Y0_FrameStrobe[0] Tile_X1Y0_S_OBI_middle.Inst_S_OBI_middle_ConfigMem.Inst_frame0_bit29.Q
+ VPWR VGND sg13g2_dlhq_1
X_0745_ Tile_X0Y0_FrameData[24] Tile_X1Y0_FrameStrobe[2] Tile_X1Y0_S_OBI_middle.Inst_S_OBI_middle_ConfigMem.Inst_frame2_bit24.Q
+ VPWR VGND sg13g2_dlhq_1
XFILLER_4_317 VPWR VGND sg13g2_fill_1
XFILLER_0_578 VPWR VGND sg13g2_decap_8
XFILLER_0_501 VPWR VGND sg13g2_decap_8
XFILLER_11_162 VPWR VGND sg13g2_fill_1
XFILLER_8_634 VPWR VGND sg13g2_fill_1
X_0530_ _0184_ _0181_ _0188_ RDATA_top18 VPWR VGND sg13g2_a21o_1
XFILLER_4_895 VPWR VGND sg13g2_decap_8
XFILLER_7_144 VPWR VGND sg13g2_fill_1
X_0392_ Tile_X1Y0_S_OBI_middle.Inst_S_OBI_middle_ConfigMem.Inst_frame0_bit4.Q VPWR
+ _0101_ VGND _0028_ Tile_X1Y0_S_OBI_middle.Inst_S_OBI_middle_ConfigMem.Inst_frame0_bit3.Q
+ sg13g2_o21ai_1
XFILLER_3_394 VPWR VGND sg13g2_decap_8
X_0461_ Tile_X2Y0_SS4END[7] Tile_X2Y0_S_OBI_right.Inst_S_OBI_right_ConfigMem.Inst_frame0_bit6.Q
+ _0127_ VPWR VGND sg13g2_nor2_1
X_1013_ Tile_X1Y0_S_OBI_middle.Inst_S_OBI_middle_switch_matrix.N2BEGb5 Tile_X1Y0_N2BEGb[5]
+ VPWR VGND sg13g2_buf_1
XFILLER_11_1314 VPWR VGND sg13g2_fill_1
XFILLER_11_1303 VPWR VGND sg13g2_decap_8
X_0728_ Tile_X0Y0_FrameData[9] Tile_X1Y0_FrameStrobe[1] Tile_X1Y0_S_OBI_middle.Inst_S_OBI_middle_ConfigMem.Inst_frame1_bit9.Q
+ VPWR VGND sg13g2_dlhq_1
X_0659_ Tile_X0Y0_S_OBI_left.Inst_S_OBI_left_ConfigMem.Inst_frame0_bit26.Q _0012_
+ _0013_ _0014_ VPWR VGND sg13g2_nor3_1
XFILLER_0_375 VPWR VGND sg13g2_decap_8
XFILLER_1_1047 VPWR VGND sg13g2_decap_8
XFILLER_5_1172 VPWR VGND sg13g2_fill_1
XFILLER_9_965 VPWR VGND sg13g2_fill_2
XFILLER_8_431 VPWR VGND sg13g2_decap_8
X_0513_ _0173_ Tile_X2Y0_S2END[7] Tile_X2Y0_S_OBI_right.Inst_S_OBI_right_ConfigMem.Inst_frame0_bit24.Q
+ VPWR VGND sg13g2_nand2b_1
X_0444_ _0114_ ADDR_top12 Tile_X2Y0_S_OBI_right.Inst_S_OBI_right_ConfigMem.Inst_frame1_bit31.Q
+ VPWR VGND sg13g2_nand2_1
X_0375_ _0087_ VPWR RDATA_top27 VGND Tile_X1Y0_S_OBI_middle.Inst_S_OBI_middle_ConfigMem.Inst_frame0_bit23.Q
+ _0088_ sg13g2_o21ai_1
XFILLER_10_419 VPWR VGND sg13g2_decap_4
XFILLER_2_618 VPWR VGND sg13g2_decap_8
XFILLER_2_1323 VPWR VGND sg13g2_decap_8
XFILLER_6_902 VPWR VGND sg13g2_decap_8
XFILLER_5_456 VPWR VGND sg13g2_decap_8
XFILLER_6_979 VPWR VGND sg13g2_decap_8
XFILLER_7_1289 VPWR VGND sg13g2_decap_8
XFILLER_0_161 VPWR VGND sg13g2_decap_8
X_0993_ Tile_X1Y0_FrameStrobe[17] Tile_X1Y0_FrameStrobe_O[17] VPWR VGND sg13g2_buf_1
X_0427_ Tile_X2Y0_S4END[14] WDATA_top18 Tile_X2Y0_S_OBI_right.Inst_S_OBI_right_ConfigMem.Inst_frame1_bit15.Q
+ Tile_X2Y0_S_OBI_right.Inst_S_OBI_right_switch_matrix.N4BEG1 VPWR VGND sg13g2_mux2_1
XFILLER_5_990 VPWR VGND sg13g2_fill_2
X_0289_ VPWR _0062_ Tile_X0Y0_SS4END[3] VGND sg13g2_inv_1
X_0358_ Tile_X1Y0_S_OBI_middle.Inst_S_OBI_middle_ConfigMem.Inst_frame0_bit12.Q VPWR
+ _0077_ VGND Tile_X1Y0_SS4END[2] Tile_X1Y0_S_OBI_middle.Inst_S_OBI_middle_ConfigMem.Inst_frame0_bit13.Q
+ sg13g2_o21ai_1
XFILLER_2_415 VPWR VGND sg13g2_decap_8
XFILLER_3_916 VPWR VGND sg13g2_decap_8
XANTENNA_101 VPWR VGND Tile_X0Y0_FrameData[22] sg13g2_antennanp
XANTENNA_123 VPWR VGND Tile_X0Y0_FrameData[20] sg13g2_antennanp
XFILLER_2_1197 VPWR VGND sg13g2_decap_8
XANTENNA_112 VPWR VGND Tile_X0Y0_FrameData[2] sg13g2_antennanp
XANTENNA_134 VPWR VGND Tile_X0Y0_FrameData[23] sg13g2_antennanp
XFILLER_6_765 VPWR VGND sg13g2_fill_2
X_0976_ Tile_X1Y0_FrameStrobe[0] Tile_X1Y0_FrameStrobe_O[0] VPWR VGND sg13g2_buf_1
XFILLER_10_39 VPWR VGND sg13g2_fill_2
XFILLER_10_28 VPWR VGND sg13g2_decap_8
X_0830_ Tile_X0Y0_FrameData[31] Tile_X0Y0_FrameStrobe[0] Tile_X0Y0_S_OBI_left.Inst_S_OBI_left_ConfigMem.Inst_frame0_bit31.Q
+ VPWR VGND sg13g2_dlhq_1
X_0761_ Tile_X0Y0_FrameData[30] Tile_X2Y0_FrameStrobe[0] Tile_X2Y0_S_OBI_right.Inst_S_OBI_right_ConfigMem.Inst_frame0_bit30.Q
+ VPWR VGND sg13g2_dlhq_1
X_0692_ Tile_X0Y0_FrameData[13] Tile_X1Y0_FrameStrobe[0] Tile_X1Y0_S_OBI_middle.Inst_S_OBI_middle_ConfigMem.Inst_frame0_bit13.Q
+ VPWR VGND sg13g2_dlhq_1
XFILLER_9_1137 VPWR VGND sg13g2_fill_1
XFILLER_2_84 VPWR VGND sg13g2_decap_8
XANTENNA_89 VPWR VGND Tile_X0Y0_FrameData[18] sg13g2_antennanp
X_0959_ Tile_X0Y0_S_OBI_left.Inst_S_OBI_left_switch_matrix.NN4BEG0 Tile_X0Y0_NN4BEG[0]
+ VPWR VGND sg13g2_buf_1
XANTENNA_78 VPWR VGND WDATA_top5 sg13g2_antennanp
XANTENNA_34 VPWR VGND Tile_X0Y0_FrameData[30] sg13g2_antennanp
XANTENNA_45 VPWR VGND Tile_X0Y0_FrameData[30] sg13g2_antennanp
XANTENNA_56 VPWR VGND Tile_X0Y0_FrameData[5] sg13g2_antennanp
XANTENNA_23 VPWR VGND Tile_X0Y0_FrameData[1] sg13g2_antennanp
XANTENNA_12 VPWR VGND Tile_X0Y0_FrameData[0] sg13g2_antennanp
XANTENNA_67 VPWR VGND Tile_X0Y0_FrameData[9] sg13g2_antennanp
XFILLER_8_827 VPWR VGND sg13g2_decap_8
XFILLER_11_93 VPWR VGND sg13g2_fill_1
XFILLER_2_0 VPWR VGND sg13g2_decap_8
XFILLER_3_576 VPWR VGND sg13g2_decap_8
X_0813_ Tile_X0Y0_FrameData[10] Tile_X2Y0_FrameStrobe[1] Tile_X2Y0_S_OBI_right.Inst_S_OBI_right_ConfigMem.Inst_frame1_bit10.Q
+ VPWR VGND sg13g2_dlhq_1
X_0675_ Tile_X0Y0_FrameData[30] Tile_X1Y0_FrameStrobe[0] Tile_X1Y0_S_OBI_middle.Inst_S_OBI_middle_ConfigMem.Inst_frame0_bit30.Q
+ VPWR VGND sg13g2_dlhq_1
X_0744_ Tile_X0Y0_FrameData[25] Tile_X1Y0_FrameStrobe[2] Tile_X1Y0_S_OBI_middle.Inst_S_OBI_middle_ConfigMem.Inst_frame2_bit25.Q
+ VPWR VGND sg13g2_dlhq_1
X_1089_ Tile_X2Y0_FrameStrobe[8] Tile_X2Y0_FrameStrobe_O[8] VPWR VGND sg13g2_buf_1
XFILLER_0_557 VPWR VGND sg13g2_decap_8
XFILLER_1_1229 VPWR VGND sg13g2_decap_8
XFILLER_3_373 VPWR VGND sg13g2_decap_8
XFILLER_4_874 VPWR VGND sg13g2_decap_8
X_0460_ VGND VPWR Tile_X2Y0_S4END[7] Tile_X2Y0_S_OBI_right.Inst_S_OBI_right_ConfigMem.Inst_frame0_bit6.Q
+ _0126_ Tile_X2Y0_S_OBI_right.Inst_S_OBI_right_ConfigMem.Inst_frame0_bit7.Q sg13g2_a21oi_1
X_1012_ Tile_X1Y0_S_OBI_middle.Inst_S_OBI_middle_switch_matrix.N2BEGb4 Tile_X1Y0_N2BEGb[4]
+ VPWR VGND sg13g2_buf_1
X_0391_ VPWR VGND Tile_X1Y0_S_OBI_middle.Inst_S_OBI_middle_ConfigMem.Inst_frame0_bit4.Q
+ _0029_ _0099_ _0097_ _0100_ _0098_ sg13g2_a221oi_1
X_0727_ Tile_X0Y0_FrameData[10] Tile_X1Y0_FrameStrobe[1] Tile_X1Y0_S_OBI_middle.Inst_S_OBI_middle_ConfigMem.Inst_frame1_bit10.Q
+ VPWR VGND sg13g2_dlhq_1
X_0658_ Tile_X0Y0_S4END[8] Tile_X0Y0_S_OBI_left.Inst_S_OBI_left_ConfigMem.Inst_frame0_bit27.Q
+ _0013_ VPWR VGND sg13g2_nor2b_1
X_0589_ Tile_X0Y0_S2MID[0] Tile_X0Y0_S_OBI_left.Inst_S_OBI_left_ConfigMem.Inst_frame0_bit3.Q
+ Tile_X0Y0_S_OBI_left.Inst_S_OBI_left_ConfigMem.Inst_frame0_bit4.Q _0206_ VPWR VGND
+ sg13g2_nor3_1
XFILLER_0_1284 VPWR VGND sg13g2_decap_8
XFILLER_4_137 VPWR VGND sg13g2_decap_8
XFILLER_1_888 VPWR VGND sg13g2_fill_1
XFILLER_1_877 VPWR VGND sg13g2_decap_8
XFILLER_0_354 VPWR VGND sg13g2_decap_8
XFILLER_1_1026 VPWR VGND sg13g2_decap_8
XFILLER_9_933 VPWR VGND sg13g2_decap_8
XFILLER_8_487 VPWR VGND sg13g2_decap_8
XFILLER_8_410 VPWR VGND sg13g2_decap_8
X_0443_ _0113_ VPWR Tile_X2Y0_S_OBI_right.Inst_S_OBI_right_switch_matrix.NN4BEG6 VGND
+ _0031_ Tile_X2Y0_S_OBI_right.Inst_S_OBI_right_ConfigMem.Inst_frame1_bit30.Q sg13g2_o21ai_1
X_0374_ _0088_ Tile_X1Y0_S4END[7] Tile_X1Y0_S_OBI_middle.Inst_S_OBI_middle_ConfigMem.Inst_frame0_bit22.Q
+ VPWR VGND sg13g2_nand2b_1
XFILLER_4_682 VPWR VGND sg13g2_fill_2
X_0512_ _0172_ _0169_ _0168_ RDATA_top16 VPWR VGND sg13g2_a21o_1
XFILLER_2_1302 VPWR VGND sg13g2_decap_4
XFILLER_9_218 VPWR VGND sg13g2_decap_4
XFILLER_5_435 VPWR VGND sg13g2_decap_8
XFILLER_6_958 VPWR VGND sg13g2_decap_8
XFILLER_1_685 VPWR VGND sg13g2_decap_8
XFILLER_1_663 VPWR VGND sg13g2_decap_8
XFILLER_0_140 VPWR VGND sg13g2_decap_8
XFILLER_7_1268 VPWR VGND sg13g2_decap_8
X_0992_ Tile_X1Y0_FrameStrobe[16] Tile_X1Y0_FrameStrobe_O[16] VPWR VGND sg13g2_buf_1
XFILLER_9_796 VPWR VGND sg13g2_decap_8
X_0426_ Tile_X2Y0_S4END[15] WDATA_top19 Tile_X2Y0_S_OBI_right.Inst_S_OBI_right_ConfigMem.Inst_frame1_bit14.Q
+ Tile_X2Y0_S_OBI_right.Inst_S_OBI_right_switch_matrix.N4BEG0 VPWR VGND sg13g2_mux2_1
XFILLER_5_84 VPWR VGND sg13g2_fill_2
X_0357_ _0075_ VPWR RDATA_top21 VGND Tile_X1Y0_S_OBI_middle.Inst_S_OBI_middle_ConfigMem.Inst_frame0_bit11.Q
+ _0076_ sg13g2_o21ai_1
X_0288_ VPWR _0061_ Tile_X0Y0_S_OBI_left.Inst_S_OBI_left_ConfigMem.Inst_frame0_bit11.Q
+ VGND sg13g2_inv_1
XFILLER_6_7 VPWR VGND sg13g2_decap_8
XANTENNA_124 VPWR VGND Tile_X0Y0_FrameData[20] sg13g2_antennanp
XANTENNA_102 VPWR VGND Tile_X0Y0_FrameData[22] sg13g2_antennanp
XANTENNA_113 VPWR VGND Tile_X0Y0_FrameData[2] sg13g2_antennanp
XANTENNA_135 VPWR VGND Tile_X0Y0_FrameData[23] sg13g2_antennanp
XFILLER_6_799 VPWR VGND sg13g2_fill_1
XFILLER_7_1010 VPWR VGND sg13g2_fill_1
XFILLER_1_493 VPWR VGND sg13g2_decap_8
XFILLER_2_983 VPWR VGND sg13g2_decap_8
XFILLER_9_571 VPWR VGND sg13g2_fill_1
X_0975_ Tile_X0Y0_UserCLK Tile_X0Y0_UserCLKo VPWR VGND sg13g2_buf_1
X_0409_ Tile_X2Y0_S1END[0] ADDR_top18 Tile_X2Y0_S_OBI_right.Inst_S_OBI_right_ConfigMem.Inst_frame2_bit29.Q
+ Tile_X2Y0_S_OBI_right.Inst_S_OBI_right_switch_matrix.N1BEG3 VPWR VGND sg13g2_mux2_1
XFILLER_11_504 VPWR VGND sg13g2_fill_2
XFILLER_8_1330 VPWR VGND sg13g2_fill_2
XFILLER_3_769 VPWR VGND sg13g2_fill_1
XFILLER_4_1249 VPWR VGND sg13g2_decap_8
X_0760_ Tile_X0Y0_FrameData[31] Tile_X2Y0_FrameStrobe[0] Tile_X2Y0_S_OBI_right.Inst_S_OBI_right_ConfigMem.Inst_frame0_bit31.Q
+ VPWR VGND sg13g2_dlhq_1
X_0691_ Tile_X0Y0_FrameData[14] Tile_X1Y0_FrameStrobe[0] Tile_X1Y0_S_OBI_middle.Inst_S_OBI_middle_ConfigMem.Inst_frame0_bit14.Q
+ VPWR VGND sg13g2_dlhq_1
XFILLER_6_530 VPWR VGND sg13g2_decap_4
XFILLER_2_63 VPWR VGND sg13g2_decap_8
XFILLER_2_780 VPWR VGND sg13g2_decap_8
XANTENNA_13 VPWR VGND Tile_X0Y0_FrameData[0] sg13g2_antennanp
X_0958_ Tile_X0Y0_S4END[0] Tile_X0Y0_N4BEG[15] VPWR VGND sg13g2_buf_1
XANTENNA_79 VPWR VGND WDATA_top5 sg13g2_antennanp
XANTENNA_46 VPWR VGND Tile_X0Y0_FrameData[30] sg13g2_antennanp
XANTENNA_68 VPWR VGND Tile_X0Y0_FrameData[9] sg13g2_antennanp
XANTENNA_35 VPWR VGND Tile_X0Y0_FrameData[30] sg13g2_antennanp
XANTENNA_57 VPWR VGND Tile_X0Y0_FrameData[5] sg13g2_antennanp
XANTENNA_24 VPWR VGND Tile_X0Y0_FrameData[1] sg13g2_antennanp
X_0889_ Tile_X0Y0_FrameData[4] Tile_X0Y0_FrameStrobe[1] Tile_X0Y0_S_OBI_left.Inst_S_OBI_left_ConfigMem.Inst_frame1_bit4.Q
+ VPWR VGND sg13g2_dlhq_1
XFILLER_0_739 VPWR VGND sg13g2_decap_8
XFILLER_3_1293 VPWR VGND sg13g2_decap_8
XFILLER_3_555 VPWR VGND sg13g2_decap_8
X_0743_ Tile_X0Y0_FrameData[26] Tile_X1Y0_FrameStrobe[2] Tile_X1Y0_S_OBI_middle.Inst_S_OBI_middle_ConfigMem.Inst_frame2_bit26.Q
+ VPWR VGND sg13g2_dlhq_1
XFILLER_7_894 VPWR VGND sg13g2_decap_8
X_0812_ Tile_X0Y0_FrameData[11] Tile_X2Y0_FrameStrobe[1] Tile_X2Y0_S_OBI_right.Inst_S_OBI_right_ConfigMem.Inst_frame1_bit11.Q
+ VPWR VGND sg13g2_dlhq_1
X_0674_ Tile_X0Y0_FrameData[31] Tile_X1Y0_FrameStrobe[0] Tile_X1Y0_S_OBI_middle.Inst_S_OBI_middle_ConfigMem.Inst_frame0_bit31.Q
+ VPWR VGND sg13g2_dlhq_1
XFILLER_6_393 VPWR VGND sg13g2_decap_8
X_1088_ Tile_X2Y0_FrameStrobe[7] Tile_X2Y0_FrameStrobe_O[7] VPWR VGND sg13g2_buf_1
XFILLER_0_536 VPWR VGND sg13g2_decap_8
XFILLER_5_1311 VPWR VGND sg13g2_fill_1
XFILLER_1_1208 VPWR VGND sg13g2_decap_8
XFILLER_8_625 VPWR VGND sg13g2_decap_8
XFILLER_8_603 VPWR VGND sg13g2_fill_1
X_0390_ Tile_X1Y0_S2MID[1] Tile_X1Y0_S_OBI_middle.Inst_S_OBI_middle_ConfigMem.Inst_frame0_bit3.Q
+ _0099_ VPWR VGND sg13g2_nor2_1
XFILLER_3_352 VPWR VGND sg13g2_decap_8
XFILLER_4_853 VPWR VGND sg13g2_decap_8
X_1011_ Tile_X1Y0_S_OBI_middle.Inst_S_OBI_middle_switch_matrix.N2BEGb3 Tile_X1Y0_N2BEGb[3]
+ VPWR VGND sg13g2_buf_1
X_0726_ Tile_X0Y0_FrameData[11] Tile_X1Y0_FrameStrobe[1] Tile_X1Y0_S_OBI_middle.Inst_S_OBI_middle_ConfigMem.Inst_frame1_bit11.Q
+ VPWR VGND sg13g2_dlhq_1
X_0657_ Tile_X0Y0_S1END[0] Tile_X0Y0_S_OBI_left.Inst_S_OBI_left_ConfigMem.Inst_frame0_bit27.Q
+ Tile_X0Y0_S_OBI_left.Inst_S_OBI_left_ConfigMem.Inst_frame0_bit28.Q _0012_ VPWR VGND
+ sg13g2_nor3_1
X_0588_ Tile_X0Y0_S_OBI_left.Inst_S_OBI_left_ConfigMem.Inst_frame0_bit4.Q VPWR _0205_
+ VGND Tile_X0Y0_S_OBI_left.Inst_S_OBI_left_ConfigMem.Inst_frame0_bit3.Q _0056_ sg13g2_o21ai_1
XFILLER_0_1263 VPWR VGND sg13g2_decap_8
XFILLER_4_105 VPWR VGND sg13g2_decap_8
XFILLER_1_856 VPWR VGND sg13g2_fill_1
XFILLER_1_845 VPWR VGND sg13g2_decap_8
XFILLER_1_823 VPWR VGND sg13g2_fill_2
XFILLER_1_812 VPWR VGND sg13g2_decap_8
XFILLER_0_333 VPWR VGND sg13g2_decap_8
XFILLER_1_1005 VPWR VGND sg13g2_decap_8
XFILLER_5_1196 VPWR VGND sg13g2_decap_8
XFILLER_8_466 VPWR VGND sg13g2_decap_8
X_0511_ Tile_X2Y0_S_OBI_right.Inst_S_OBI_right_ConfigMem.Inst_frame0_bit20.Q _0170_
+ _0171_ _0172_ VPWR VGND sg13g2_nor3_1
X_0442_ _0113_ ADDR_top13 Tile_X2Y0_S_OBI_right.Inst_S_OBI_right_ConfigMem.Inst_frame1_bit30.Q
+ VPWR VGND sg13g2_nand2_1
XFILLER_3_193 VPWR VGND sg13g2_fill_2
X_0373_ Tile_X1Y0_S_OBI_middle.Inst_S_OBI_middle_ConfigMem.Inst_frame0_bit22.Q VPWR
+ _0087_ VGND Tile_X1Y0_SS4END[7] Tile_X1Y0_S_OBI_middle.Inst_S_OBI_middle_ConfigMem.Inst_frame0_bit23.Q
+ sg13g2_o21ai_1
XFILLER_11_1102 VPWR VGND sg13g2_fill_1
X_0709_ Tile_X0Y0_FrameData[28] Tile_X1Y0_FrameStrobe[1] Tile_X1Y0_S_OBI_middle.Inst_S_OBI_middle_ConfigMem.Inst_frame1_bit28.Q
+ VPWR VGND sg13g2_dlhq_1
XFILLER_0_1082 VPWR VGND sg13g2_decap_8
XFILLER_5_414 VPWR VGND sg13g2_decap_8
XFILLER_6_937 VPWR VGND sg13g2_decap_8
XFILLER_1_642 VPWR VGND sg13g2_decap_8
XFILLER_0_196 VPWR VGND sg13g2_decap_8
X_0991_ Tile_X1Y0_FrameStrobe[15] Tile_X1Y0_FrameStrobe_O[15] VPWR VGND sg13g2_buf_1
XFILLER_5_63 VPWR VGND sg13g2_decap_8
XFILLER_10_0 VPWR VGND sg13g2_decap_8
X_0425_ Tile_X2Y0_S2END[0] ADDR_top10 Tile_X2Y0_S_OBI_right.Inst_S_OBI_right_ConfigMem.Inst_frame1_bit13.Q
+ Tile_X2Y0_S_OBI_right.Inst_S_OBI_right_switch_matrix.N2BEGb7 VPWR VGND sg13g2_mux2_1
X_0356_ _0076_ Tile_X1Y0_S4END[1] Tile_X1Y0_S_OBI_middle.Inst_S_OBI_middle_ConfigMem.Inst_frame0_bit10.Q
+ VPWR VGND sg13g2_nand2b_1
X_0287_ VPWR _0060_ Tile_X0Y0_SS4END[2] VGND sg13g2_inv_1
XANTENNA_114 VPWR VGND Tile_X0Y0_FrameData[2] sg13g2_antennanp
XANTENNA_103 VPWR VGND Tile_X0Y0_FrameData[22] sg13g2_antennanp
XFILLER_2_1100 VPWR VGND sg13g2_decap_4
XANTENNA_136 VPWR VGND Tile_X0Y0_FrameData[23] sg13g2_antennanp
XANTENNA_125 VPWR VGND Tile_X0Y0_FrameData[20] sg13g2_antennanp
XFILLER_6_756 VPWR VGND sg13g2_decap_4
XFILLER_6_767 VPWR VGND sg13g2_fill_1
XFILLER_7_1055 VPWR VGND sg13g2_decap_4
XFILLER_2_962 VPWR VGND sg13g2_decap_8
X_0974_ Tile_X0Y0_SS4END[0] Tile_X0Y0_NN4BEG[15] VPWR VGND sg13g2_buf_1
X_0408_ Tile_X2Y0_S1END[1] ADDR_top19 Tile_X2Y0_S_OBI_right.Inst_S_OBI_right_ConfigMem.Inst_frame2_bit28.Q
+ Tile_X2Y0_S_OBI_right.Inst_S_OBI_right_switch_matrix.N1BEG2 VPWR VGND sg13g2_mux2_1
X_0339_ Tile_X1Y0_SS4END[12] ADDR_top20 Tile_X1Y0_S_OBI_middle.Inst_S_OBI_middle_ConfigMem.Inst_frame1_bit21.Q
+ Tile_X1Y0_S_OBI_middle.Inst_S_OBI_middle_switch_matrix.NN4BEG3 VPWR VGND sg13g2_mux2_1
XFILLER_11_527 VPWR VGND sg13g2_fill_2
XFILLER_3_715 VPWR VGND sg13g2_decap_4
XFILLER_4_1228 VPWR VGND sg13g2_decap_8
X_0690_ Tile_X0Y0_FrameData[15] Tile_X1Y0_FrameStrobe[0] Tile_X1Y0_S_OBI_middle.Inst_S_OBI_middle_ConfigMem.Inst_frame0_bit15.Q
+ VPWR VGND sg13g2_dlhq_1
XFILLER_2_42 VPWR VGND sg13g2_decap_8
XANTENNA_36 VPWR VGND Tile_X0Y0_FrameData[30] sg13g2_antennanp
XANTENNA_25 VPWR VGND Tile_X0Y0_FrameData[1] sg13g2_antennanp
XANTENNA_47 VPWR VGND Tile_X0Y0_FrameData[30] sg13g2_antennanp
XANTENNA_14 VPWR VGND Tile_X0Y0_FrameData[0] sg13g2_antennanp
X_0957_ Tile_X0Y0_S4END[1] Tile_X0Y0_N4BEG[14] VPWR VGND sg13g2_buf_1
X_0888_ Tile_X0Y0_FrameData[5] Tile_X0Y0_FrameStrobe[1] Tile_X0Y0_S_OBI_left.Inst_S_OBI_left_ConfigMem.Inst_frame1_bit5.Q
+ VPWR VGND sg13g2_dlhq_1
XANTENNA_69 VPWR VGND Tile_X0Y0_FrameData[9] sg13g2_antennanp
XANTENNA_58 VPWR VGND Tile_X0Y0_FrameData[6] sg13g2_antennanp
XFILLER_0_718 VPWR VGND sg13g2_decap_8
XFILLER_3_1272 VPWR VGND sg13g2_decap_8
XFILLER_11_324 VPWR VGND sg13g2_decap_4
XFILLER_3_534 VPWR VGND sg13g2_decap_8
XFILLER_4_1036 VPWR VGND sg13g2_fill_2
X_0673_ _0026_ _0023_ _0022_ RDATA_top9 VPWR VGND sg13g2_a21o_1
X_0742_ Tile_X0Y0_FrameData[27] Tile_X1Y0_FrameStrobe[2] Tile_X1Y0_S_OBI_middle.Inst_S_OBI_middle_ConfigMem.Inst_frame2_bit27.Q
+ VPWR VGND sg13g2_dlhq_1
XFILLER_7_873 VPWR VGND sg13g2_decap_8
XFILLER_7_840 VPWR VGND sg13g2_fill_1
X_0811_ Tile_X0Y0_FrameData[12] Tile_X2Y0_FrameStrobe[1] Tile_X2Y0_S_OBI_right.Inst_S_OBI_right_ConfigMem.Inst_frame1_bit12.Q
+ VPWR VGND sg13g2_dlhq_1
XFILLER_6_372 VPWR VGND sg13g2_decap_8
X_1087_ Tile_X2Y0_FrameStrobe[6] Tile_X2Y0_FrameStrobe_O[6] VPWR VGND sg13g2_buf_1
XFILLER_0_515 VPWR VGND sg13g2_decap_8
XFILLER_11_110 VPWR VGND sg13g2_fill_1
XFILLER_3_1080 VPWR VGND sg13g2_fill_1
XFILLER_11_143 VPWR VGND sg13g2_fill_2
XFILLER_4_832 VPWR VGND sg13g2_decap_8
XFILLER_3_331 VPWR VGND sg13g2_decap_8
X_1010_ Tile_X1Y0_S_OBI_middle.Inst_S_OBI_middle_switch_matrix.N2BEGb2 Tile_X1Y0_N2BEGb[2]
+ VPWR VGND sg13g2_buf_1
X_0656_ Tile_X0Y0_S_OBI_left.Inst_S_OBI_left_ConfigMem.Inst_frame0_bit28.Q VPWR _0011_
+ VGND _0052_ Tile_X0Y0_S_OBI_left.Inst_S_OBI_left_ConfigMem.Inst_frame0_bit27.Q sg13g2_o21ai_1
XFILLER_6_191 VPWR VGND sg13g2_fill_2
X_0725_ Tile_X0Y0_FrameData[12] Tile_X1Y0_FrameStrobe[1] Tile_X1Y0_S_OBI_middle.Inst_S_OBI_middle_ConfigMem.Inst_frame1_bit12.Q
+ VPWR VGND sg13g2_dlhq_1
X_0587_ VPWR VGND Tile_X0Y0_S_OBI_left.Inst_S_OBI_left_ConfigMem.Inst_frame0_bit4.Q
+ _0055_ _0203_ _0201_ _0204_ _0202_ sg13g2_a221oi_1
X_1139_ Tile_X2Y0_S_OBI_right.Inst_S_OBI_right_switch_matrix.NN4BEG2 Tile_X2Y0_NN4BEG[2]
+ VPWR VGND sg13g2_buf_1
XFILLER_0_1242 VPWR VGND sg13g2_decap_8
XFILLER_1_868 VPWR VGND sg13g2_decap_4
XFILLER_0_389 VPWR VGND sg13g2_decap_8
XFILLER_8_445 VPWR VGND sg13g2_decap_8
X_0510_ Tile_X2Y0_S4END[6] Tile_X2Y0_S_OBI_right.Inst_S_OBI_right_ConfigMem.Inst_frame0_bit21.Q
+ _0171_ VPWR VGND sg13g2_nor2b_1
X_0441_ Tile_X2Y0_SS4END[10] ADDR_top14 Tile_X2Y0_S_OBI_right.Inst_S_OBI_right_ConfigMem.Inst_frame1_bit29.Q
+ Tile_X2Y0_S_OBI_right.Inst_S_OBI_right_switch_matrix.NN4BEG5 VPWR VGND sg13g2_mux2_1
X_0372_ _0085_ VPWR RDATA_top26 VGND Tile_X1Y0_S_OBI_middle.Inst_S_OBI_middle_ConfigMem.Inst_frame0_bit21.Q
+ _0086_ sg13g2_o21ai_1
X_0708_ Tile_X0Y0_FrameData[29] Tile_X1Y0_FrameStrobe[1] Tile_X1Y0_S_OBI_middle.Inst_S_OBI_middle_ConfigMem.Inst_frame1_bit29.Q
+ VPWR VGND sg13g2_dlhq_1
XFILLER_1_109 VPWR VGND sg13g2_decap_8
X_0639_ Tile_X0Y0_S2MID[6] Tile_X0Y0_S_OBI_left.Inst_S_OBI_left_ConfigMem.Inst_frame0_bit21.Q
+ Tile_X0Y0_S_OBI_left.Inst_S_OBI_left_ConfigMem.Inst_frame0_bit22.Q _0250_ VPWR VGND
+ sg13g2_nor3_1
XFILLER_2_1315 VPWR VGND sg13g2_fill_1
XFILLER_10_923 VPWR VGND sg13g2_decap_8
XFILLER_0_1061 VPWR VGND sg13g2_decap_8
XFILLER_6_916 VPWR VGND sg13g2_decap_8
XFILLER_1_621 VPWR VGND sg13g2_decap_8
XFILLER_0_175 VPWR VGND sg13g2_decap_8
X_0990_ Tile_X1Y0_FrameStrobe[14] Tile_X1Y0_FrameStrobe_O[14] VPWR VGND sg13g2_buf_1
XFILLER_5_42 VPWR VGND sg13g2_decap_8
X_0424_ Tile_X2Y0_S2END[1] ADDR_top11 Tile_X2Y0_S_OBI_right.Inst_S_OBI_right_ConfigMem.Inst_frame1_bit12.Q
+ Tile_X2Y0_S_OBI_right.Inst_S_OBI_right_switch_matrix.N2BEGb6 VPWR VGND sg13g2_mux2_1
X_0286_ VPWR _0059_ Tile_X0Y0_S_OBI_left.Inst_S_OBI_left_ConfigMem.Inst_frame0_bit8.Q
+ VGND sg13g2_inv_1
X_0355_ Tile_X1Y0_S_OBI_middle.Inst_S_OBI_middle_ConfigMem.Inst_frame0_bit10.Q VPWR
+ _0075_ VGND Tile_X1Y0_SS4END[1] Tile_X1Y0_S_OBI_middle.Inst_S_OBI_middle_ConfigMem.Inst_frame0_bit11.Q
+ sg13g2_o21ai_1
XFILLER_2_429 VPWR VGND sg13g2_decap_8
XANTENNA_137 VPWR VGND Tile_X0Y0_FrameData[23] sg13g2_antennanp
XANTENNA_126 VPWR VGND Tile_X0Y0_FrameData[20] sg13g2_antennanp
XANTENNA_115 VPWR VGND Tile_X0Y0_FrameData[2] sg13g2_antennanp
XFILLER_2_1123 VPWR VGND sg13g2_fill_1
XFILLER_2_1156 VPWR VGND sg13g2_decap_8
XANTENNA_104 VPWR VGND Tile_X0Y0_FrameData[22] sg13g2_antennanp
XFILLER_6_1281 VPWR VGND sg13g2_decap_8
XFILLER_6_702 VPWR VGND sg13g2_decap_4
XFILLER_6_735 VPWR VGND sg13g2_decap_4
XFILLER_1_462 VPWR VGND sg13g2_decap_8
XFILLER_2_941 VPWR VGND sg13g2_decap_8
XFILLER_7_1034 VPWR VGND sg13g2_fill_1
XFILLER_1_484 VPWR VGND sg13g2_decap_4
X_0973_ Tile_X0Y0_SS4END[1] Tile_X0Y0_NN4BEG[14] VPWR VGND sg13g2_buf_1
X_0407_ Tile_X2Y0_S1END[2] WDATA_top18 Tile_X2Y0_S_OBI_right.Inst_S_OBI_right_ConfigMem.Inst_frame2_bit27.Q
+ Tile_X2Y0_S_OBI_right.Inst_S_OBI_right_switch_matrix.N1BEG1 VPWR VGND sg13g2_mux2_1
X_0269_ VPWR _0042_ Tile_X2Y0_SS4END[3] VGND sg13g2_inv_1
X_0338_ Tile_X1Y0_SS4END[13] ADDR_top21 Tile_X1Y0_S_OBI_middle.Inst_S_OBI_middle_ConfigMem.Inst_frame1_bit20.Q
+ Tile_X1Y0_S_OBI_middle.Inst_S_OBI_middle_switch_matrix.NN4BEG2 VPWR VGND sg13g2_mux2_1
XFILLER_2_204 VPWR VGND sg13g2_decap_8
XFILLER_2_259 VPWR VGND sg13g2_decap_8
XFILLER_1_292 VPWR VGND sg13g2_decap_8
XFILLER_2_21 VPWR VGND sg13g2_decap_8
XFILLER_2_98 VPWR VGND sg13g2_decap_8
X_0956_ Tile_X0Y0_S4END[2] Tile_X0Y0_N4BEG[13] VPWR VGND sg13g2_buf_1
XANTENNA_37 VPWR VGND Tile_X0Y0_FrameData[30] sg13g2_antennanp
XANTENNA_48 VPWR VGND Tile_X0Y0_FrameData[30] sg13g2_antennanp
XANTENNA_15 VPWR VGND Tile_X0Y0_FrameData[14] sg13g2_antennanp
XANTENNA_26 VPWR VGND Tile_X0Y0_FrameData[1] sg13g2_antennanp
XANTENNA_59 VPWR VGND Tile_X0Y0_FrameData[6] sg13g2_antennanp
X_0887_ Tile_X0Y0_FrameData[6] Tile_X0Y0_FrameStrobe[1] Tile_X0Y0_S_OBI_left.Inst_S_OBI_left_ConfigMem.Inst_frame1_bit6.Q
+ VPWR VGND sg13g2_dlhq_1
XFILLER_3_1251 VPWR VGND sg13g2_decap_8
XFILLER_7_307 VPWR VGND sg13g2_decap_4
XFILLER_11_74 VPWR VGND sg13g2_fill_2
XFILLER_3_513 VPWR VGND sg13g2_decap_8
XFILLER_4_1004 VPWR VGND sg13g2_fill_1
X_0810_ Tile_X0Y0_FrameData[13] Tile_X2Y0_FrameStrobe[1] Tile_X2Y0_S_OBI_right.Inst_S_OBI_right_ConfigMem.Inst_frame1_bit13.Q
+ VPWR VGND sg13g2_dlhq_1
XFILLER_11_881 VPWR VGND sg13g2_fill_2
X_0741_ Tile_X0Y0_FrameData[28] Tile_X1Y0_FrameStrobe[2] Tile_X1Y0_S_OBI_middle.Inst_S_OBI_middle_ConfigMem.Inst_frame2_bit28.Q
+ VPWR VGND sg13g2_dlhq_1
X_0672_ Tile_X0Y0_S_OBI_left.Inst_S_OBI_left_ConfigMem.Inst_frame0_bit29.Q _0024_
+ _0025_ _0026_ VPWR VGND sg13g2_nor3_1
XFILLER_2_590 VPWR VGND sg13g2_decap_8
X_1086_ Tile_X2Y0_FrameStrobe[5] Tile_X2Y0_FrameStrobe_O[5] VPWR VGND sg13g2_buf_1
X_0939_ Tile_X0Y0_S_OBI_left.Inst_S_OBI_left_switch_matrix.N2BEGb4 Tile_X0Y0_N2BEGb[4]
+ VPWR VGND sg13g2_buf_1
XFILLER_0_0 VPWR VGND sg13g2_decap_8
XFILLER_3_387 VPWR VGND sg13g2_decap_8
XFILLER_4_888 VPWR VGND sg13g2_decap_8
XFILLER_8_75 VPWR VGND sg13g2_fill_2
XFILLER_8_42 VPWR VGND sg13g2_decap_8
X_0724_ Tile_X0Y0_FrameData[13] Tile_X1Y0_FrameStrobe[1] Tile_X1Y0_S_OBI_middle.Inst_S_OBI_middle_ConfigMem.Inst_frame1_bit13.Q
+ VPWR VGND sg13g2_dlhq_1
X_0586_ Tile_X0Y0_SS4END[6] Tile_X0Y0_S_OBI_left.Inst_S_OBI_left_ConfigMem.Inst_frame0_bit3.Q
+ _0203_ VPWR VGND sg13g2_nor2_1
X_0655_ _0006_ _0004_ _0010_ RDATA_top7 VPWR VGND sg13g2_a21o_1
XFILLER_0_1221 VPWR VGND sg13g2_decap_8
X_1138_ Tile_X2Y0_S_OBI_right.Inst_S_OBI_right_switch_matrix.NN4BEG1 Tile_X2Y0_NN4BEG[1]
+ VPWR VGND sg13g2_buf_1
X_1069_ Tile_X0Y0_FrameData[20] Tile_X2Y0_FrameData_O[20] VPWR VGND sg13g2_buf_1
XFILLER_0_1298 VPWR VGND sg13g2_decap_8
XFILLER_1_836 VPWR VGND sg13g2_decap_4
XFILLER_1_803 VPWR VGND sg13g2_decap_4
XFILLER_0_368 VPWR VGND sg13g2_decap_8
XFILLER_0_313 VPWR VGND sg13g2_fill_2
XFILLER_8_424 VPWR VGND sg13g2_decap_8
X_0440_ Tile_X2Y0_SS4END[11] ADDR_top15 Tile_X2Y0_S_OBI_right.Inst_S_OBI_right_ConfigMem.Inst_frame1_bit28.Q
+ Tile_X2Y0_S_OBI_right.Inst_S_OBI_right_switch_matrix.NN4BEG4 VPWR VGND sg13g2_mux2_1
XFILLER_3_140 VPWR VGND sg13g2_decap_8
XFILLER_3_195 VPWR VGND sg13g2_fill_1
XFILLER_4_652 VPWR VGND sg13g2_fill_1
X_0371_ _0086_ Tile_X1Y0_S4END[6] Tile_X1Y0_S_OBI_middle.Inst_S_OBI_middle_ConfigMem.Inst_frame0_bit20.Q
+ VPWR VGND sg13g2_nand2b_1
X_0707_ Tile_X0Y0_FrameData[30] Tile_X1Y0_FrameStrobe[1] Tile_X1Y0_S_OBI_middle.Inst_S_OBI_middle_ConfigMem.Inst_frame1_bit30.Q
+ VPWR VGND sg13g2_dlhq_1
X_0638_ Tile_X0Y0_S_OBI_left.Inst_S_OBI_left_ConfigMem.Inst_frame0_bit22.Q VPWR _0249_
+ VGND _0054_ Tile_X0Y0_S_OBI_left.Inst_S_OBI_left_ConfigMem.Inst_frame0_bit21.Q sg13g2_o21ai_1
X_0569_ Tile_X0Y0_S4END[6] WDATA_top0 Tile_X0Y0_S_OBI_left.Inst_S_OBI_left_ConfigMem.Inst_frame1_bit23.Q
+ Tile_X0Y0_S_OBI_left.Inst_S_OBI_left_switch_matrix.N4BEG9 VPWR VGND sg13g2_mux2_1
XFILLER_0_1040 VPWR VGND sg13g2_decap_8
XFILLER_10_957 VPWR VGND sg13g2_decap_4
XFILLER_1_600 VPWR VGND sg13g2_fill_1
XFILLER_5_449 VPWR VGND sg13g2_decap_8
XFILLER_1_699 VPWR VGND sg13g2_decap_8
XFILLER_1_677 VPWR VGND sg13g2_decap_4
XFILLER_0_154 VPWR VGND sg13g2_decap_8
XFILLER_5_21 VPWR VGND sg13g2_decap_8
X_0423_ Tile_X2Y0_S2END[2] ADDR_top12 Tile_X2Y0_S_OBI_right.Inst_S_OBI_right_ConfigMem.Inst_frame1_bit11.Q
+ Tile_X2Y0_S_OBI_right.Inst_S_OBI_right_switch_matrix.N2BEGb5 VPWR VGND sg13g2_mux2_1
XFILLER_4_482 VPWR VGND sg13g2_decap_8
XFILLER_5_983 VPWR VGND sg13g2_decap_8
X_0354_ _0073_ VPWR RDATA_top20 VGND Tile_X1Y0_S_OBI_middle.Inst_S_OBI_middle_ConfigMem.Inst_frame0_bit9.Q
+ _0074_ sg13g2_o21ai_1
X_0285_ VPWR _0058_ Tile_X0Y0_SS4END[1] VGND sg13g2_inv_1
XFILLER_2_408 VPWR VGND sg13g2_decap_8
XFILLER_3_909 VPWR VGND sg13g2_decap_8
XFILLER_6_1260 VPWR VGND sg13g2_decap_8
XANTENNA_116 VPWR VGND Tile_X0Y0_FrameData[2] sg13g2_antennanp
XANTENNA_105 VPWR VGND Tile_X0Y0_FrameData[22] sg13g2_antennanp
XANTENNA_127 VPWR VGND Tile_X0Y0_FrameData[20] sg13g2_antennanp
XFILLER_1_441 VPWR VGND sg13g2_decap_8
XFILLER_2_920 VPWR VGND sg13g2_decap_8
XFILLER_2_997 VPWR VGND sg13g2_decap_8
X_0972_ Tile_X0Y0_SS4END[2] Tile_X0Y0_NN4BEG[13] VPWR VGND sg13g2_buf_1
X_0337_ Tile_X1Y0_SS4END[14] ADDR_top22 Tile_X1Y0_S_OBI_middle.Inst_S_OBI_middle_ConfigMem.Inst_frame1_bit19.Q
+ Tile_X1Y0_S_OBI_middle.Inst_S_OBI_middle_switch_matrix.NN4BEG1 VPWR VGND sg13g2_mux2_1
X_0406_ Tile_X1Y0_S_OBI_middle.Inst_S_OBI_middle_ConfigMem.Inst_frame2_bit11.Q Tile_X1Y0_S1END[3]
+ WE_top REQ_top BE_top3 Tile_X1Y0_S_OBI_middle.Inst_S_OBI_middle_ConfigMem.Inst_frame2_bit10.Q
+ Tile_X1Y0_S_OBI_middle.Inst_S_OBI_middle_switch_matrix.N1BEG0 VPWR VGND sg13g2_mux4_1
X_0268_ VPWR _0041_ Tile_X2Y0_S_OBI_right.Inst_S_OBI_right_ConfigMem.Inst_frame0_bit11.Q
+ VGND sg13g2_inv_1
XFILLER_8_1300 VPWR VGND sg13g2_decap_8
XFILLER_4_7 VPWR VGND sg13g2_decap_8
XFILLER_6_555 VPWR VGND sg13g2_fill_1
XFILLER_2_77 VPWR VGND sg13g2_decap_8
XFILLER_2_794 VPWR VGND sg13g2_decap_8
XANTENNA_49 VPWR VGND Tile_X0Y0_FrameData[30] sg13g2_antennanp
X_0955_ Tile_X0Y0_S4END[3] Tile_X0Y0_N4BEG[12] VPWR VGND sg13g2_buf_1
XANTENNA_38 VPWR VGND Tile_X0Y0_FrameData[30] sg13g2_antennanp
XANTENNA_27 VPWR VGND Tile_X0Y0_FrameData[1] sg13g2_antennanp
XANTENNA_16 VPWR VGND Tile_X0Y0_FrameData[14] sg13g2_antennanp
X_0886_ Tile_X0Y0_FrameData[7] Tile_X0Y0_FrameStrobe[1] Tile_X0Y0_S_OBI_left.Inst_S_OBI_left_ConfigMem.Inst_frame1_bit7.Q
+ VPWR VGND sg13g2_dlhq_1
XFILLER_3_1230 VPWR VGND sg13g2_decap_8
XFILLER_11_42 VPWR VGND sg13g2_decap_8
XFILLER_3_569 VPWR VGND sg13g2_decap_8
X_0740_ Tile_X0Y0_FrameData[29] Tile_X1Y0_FrameStrobe[2] Tile_X1Y0_S_OBI_middle.Inst_S_OBI_middle_ConfigMem.Inst_frame2_bit29.Q
+ VPWR VGND sg13g2_dlhq_1
X_0671_ Tile_X0Y0_S4END[9] Tile_X0Y0_S_OBI_left.Inst_S_OBI_left_ConfigMem.Inst_frame0_bit30.Q
+ _0025_ VPWR VGND sg13g2_nor2b_1
X_1085_ Tile_X2Y0_FrameStrobe[4] Tile_X2Y0_FrameStrobe_O[4] VPWR VGND sg13g2_buf_1
XFILLER_9_190 VPWR VGND sg13g2_fill_1
X_0869_ Tile_X0Y0_FrameData[24] Tile_X0Y0_FrameStrobe[1] Tile_X0Y0_S_OBI_left.Inst_S_OBI_left_ConfigMem.Inst_frame1_bit24.Q
+ VPWR VGND sg13g2_dlhq_1
X_0938_ Tile_X0Y0_S_OBI_left.Inst_S_OBI_left_switch_matrix.N2BEGb3 Tile_X0Y0_N2BEGb[3]
+ VPWR VGND sg13g2_buf_1
XFILLER_3_1071 VPWR VGND sg13g2_decap_8
XFILLER_3_366 VPWR VGND sg13g2_decap_8
XFILLER_4_867 VPWR VGND sg13g2_decap_8
X_0723_ Tile_X0Y0_FrameData[14] Tile_X1Y0_FrameStrobe[1] Tile_X1Y0_S_OBI_middle.Inst_S_OBI_middle_ConfigMem.Inst_frame1_bit14.Q
+ VPWR VGND sg13g2_dlhq_1
XFILLER_8_21 VPWR VGND sg13g2_decap_8
XFILLER_7_661 VPWR VGND sg13g2_decap_8
X_0654_ VPWR VGND Tile_X0Y0_S_OBI_left.Inst_S_OBI_left_ConfigMem.Inst_frame0_bit25.Q
+ _0068_ _0009_ _0007_ _0010_ _0008_ sg13g2_a221oi_1
X_0585_ VGND VPWR Tile_X0Y0_S4END[6] Tile_X0Y0_S_OBI_left.Inst_S_OBI_left_ConfigMem.Inst_frame0_bit3.Q
+ _0202_ Tile_X0Y0_S_OBI_left.Inst_S_OBI_left_ConfigMem.Inst_frame0_bit4.Q sg13g2_a21oi_1
XFILLER_6_193 VPWR VGND sg13g2_fill_1
X_1137_ Tile_X2Y0_S_OBI_right.Inst_S_OBI_right_switch_matrix.NN4BEG0 Tile_X2Y0_NN4BEG[0]
+ VPWR VGND sg13g2_buf_1
XFILLER_0_1200 VPWR VGND sg13g2_decap_8
X_1068_ Tile_X0Y0_FrameData[19] Tile_X2Y0_FrameData_O[19] VPWR VGND sg13g2_buf_1
XFILLER_0_1277 VPWR VGND sg13g2_decap_8
XFILLER_0_303 VPWR VGND sg13g2_decap_4
XFILLER_0_347 VPWR VGND sg13g2_decap_8
XFILLER_5_1122 VPWR VGND sg13g2_fill_2
XFILLER_1_1019 VPWR VGND sg13g2_decap_8
XFILLER_9_926 VPWR VGND sg13g2_decap_8
XFILLER_8_403 VPWR VGND sg13g2_decap_8
XFILLER_4_675 VPWR VGND sg13g2_decap_8
X_0370_ Tile_X1Y0_S_OBI_middle.Inst_S_OBI_middle_ConfigMem.Inst_frame0_bit20.Q VPWR
+ _0085_ VGND Tile_X1Y0_SS4END[6] Tile_X1Y0_S_OBI_middle.Inst_S_OBI_middle_ConfigMem.Inst_frame0_bit21.Q
+ sg13g2_o21ai_1
X_0706_ Tile_X0Y0_FrameData[31] Tile_X1Y0_FrameStrobe[1] Tile_X1Y0_S_OBI_middle.Inst_S_OBI_middle_ConfigMem.Inst_frame1_bit31.Q
+ VPWR VGND sg13g2_dlhq_1
X_0637_ _0244_ _0242_ _0248_ RDATA_top5 VPWR VGND sg13g2_a21o_1
X_0499_ Tile_X2Y0_S2MID[5] Tile_X2Y0_S_OBI_right.Inst_S_OBI_right_ConfigMem.Inst_frame0_bit18.Q
+ Tile_X2Y0_S_OBI_right.Inst_S_OBI_right_ConfigMem.Inst_frame0_bit19.Q _0161_ VPWR
+ VGND sg13g2_nor3_1
XFILLER_2_1306 VPWR VGND sg13g2_fill_1
X_0568_ Tile_X0Y0_S4END[7] WDATA_top1 Tile_X0Y0_S_OBI_left.Inst_S_OBI_left_ConfigMem.Inst_frame1_bit22.Q
+ Tile_X0Y0_S_OBI_left.Inst_S_OBI_left_switch_matrix.N4BEG8 VPWR VGND sg13g2_mux2_1
XFILLER_0_1096 VPWR VGND sg13g2_decap_8
XFILLER_5_428 VPWR VGND sg13g2_decap_8
XFILLER_1_656 VPWR VGND sg13g2_decap_8
XFILLER_1_612 VPWR VGND sg13g2_decap_4
XFILLER_0_133 VPWR VGND sg13g2_decap_8
XFILLER_10_1160 VPWR VGND sg13g2_fill_2
XFILLER_8_255 VPWR VGND sg13g2_fill_1
XFILLER_4_461 VPWR VGND sg13g2_decap_8
XFILLER_5_962 VPWR VGND sg13g2_decap_8
X_0422_ Tile_X2Y0_S2END[3] ADDR_top13 Tile_X2Y0_S_OBI_right.Inst_S_OBI_right_ConfigMem.Inst_frame1_bit10.Q
+ Tile_X2Y0_S_OBI_right.Inst_S_OBI_right_switch_matrix.N2BEGb4 VPWR VGND sg13g2_mux2_1
X_0353_ _0074_ Tile_X1Y0_S4END[0] Tile_X1Y0_S_OBI_middle.Inst_S_OBI_middle_ConfigMem.Inst_frame0_bit8.Q
+ VPWR VGND sg13g2_nand2b_1
XFILLER_5_77 VPWR VGND sg13g2_decap_8
X_0284_ VPWR _0057_ Tile_X0Y0_S_OBI_left.Inst_S_OBI_left_ConfigMem.Inst_frame0_bit5.Q
+ VGND sg13g2_inv_1
XANTENNA_106 VPWR VGND Tile_X0Y0_FrameData[22] sg13g2_antennanp
XANTENNA_117 VPWR VGND Tile_X0Y0_FrameData[2] sg13g2_antennanp
XANTENNA_128 VPWR VGND Tile_X0Y0_FrameData[20] sg13g2_antennanp
XFILLER_10_755 VPWR VGND sg13g2_fill_2
XFILLER_1_420 VPWR VGND sg13g2_decap_8
XFILLER_2_976 VPWR VGND sg13g2_decap_8
X_0971_ Tile_X0Y0_SS4END[3] Tile_X0Y0_NN4BEG[12] VPWR VGND sg13g2_buf_1
X_0336_ Tile_X1Y0_SS4END[15] ADDR_top23 Tile_X1Y0_S_OBI_middle.Inst_S_OBI_middle_ConfigMem.Inst_frame1_bit18.Q
+ Tile_X1Y0_S_OBI_middle.Inst_S_OBI_middle_switch_matrix.NN4BEG0 VPWR VGND sg13g2_mux2_1
X_0267_ VPWR _0040_ Tile_X2Y0_SS4END[2] VGND sg13g2_inv_1
X_0405_ _0112_ _0109_ _0108_ RVALID_top VPWR VGND sg13g2_a21o_1
XFILLER_1_1180 VPWR VGND sg13g2_decap_8
XFILLER_4_1209 VPWR VGND sg13g2_fill_2
XFILLER_6_512 VPWR VGND sg13g2_fill_1
XFILLER_1_261 VPWR VGND sg13g2_fill_2
XFILLER_2_56 VPWR VGND sg13g2_decap_8
XFILLER_2_773 VPWR VGND sg13g2_decap_8
X_0954_ Tile_X0Y0_S4END[4] Tile_X0Y0_N4BEG[11] VPWR VGND sg13g2_buf_1
XANTENNA_39 VPWR VGND Tile_X0Y0_FrameData[30] sg13g2_antennanp
X_0885_ Tile_X0Y0_FrameData[8] Tile_X0Y0_FrameStrobe[1] Tile_X0Y0_S_OBI_left.Inst_S_OBI_left_ConfigMem.Inst_frame1_bit8.Q
+ VPWR VGND sg13g2_dlhq_1
XANTENNA_28 VPWR VGND Tile_X0Y0_FrameData[1] sg13g2_antennanp
XANTENNA_17 VPWR VGND Tile_X0Y0_FrameData[14] sg13g2_antennanp
X_0319_ Tile_X1Y0_S2END[0] ADDR_top20 Tile_X1Y0_S_OBI_middle.Inst_S_OBI_middle_ConfigMem.Inst_frame1_bit1.Q
+ Tile_X1Y0_S_OBI_middle.Inst_S_OBI_middle_switch_matrix.N2BEGb7 VPWR VGND sg13g2_mux2_1
XFILLER_3_1286 VPWR VGND sg13g2_decap_8
XFILLER_11_21 VPWR VGND sg13g2_decap_8
XFILLER_3_548 VPWR VGND sg13g2_decap_8
XFILLER_11_894 VPWR VGND sg13g2_fill_1
XFILLER_11_883 VPWR VGND sg13g2_fill_1
X_0670_ Tile_X0Y0_S1END[1] Tile_X0Y0_S_OBI_left.Inst_S_OBI_left_ConfigMem.Inst_frame0_bit30.Q
+ Tile_X0Y0_S_OBI_left.Inst_S_OBI_left_ConfigMem.Inst_frame0_bit31.Q _0024_ VPWR VGND
+ sg13g2_nor3_1
XFILLER_7_832 VPWR VGND sg13g2_fill_2
XFILLER_7_887 VPWR VGND sg13g2_decap_8
XFILLER_6_386 VPWR VGND sg13g2_decap_8
X_1084_ Tile_X2Y0_FrameStrobe[3] Tile_X2Y0_FrameStrobe_O[3] VPWR VGND sg13g2_buf_1
X_1153_ Tile_X2Y0_UserCLK Tile_X2Y0_UserCLKo VPWR VGND sg13g2_buf_1
X_0937_ Tile_X0Y0_S_OBI_left.Inst_S_OBI_left_switch_matrix.N2BEGb2 Tile_X0Y0_N2BEGb[2]
+ VPWR VGND sg13g2_buf_1
X_0799_ Tile_X0Y0_FrameData[24] Tile_X2Y0_FrameStrobe[1] Tile_X2Y0_S_OBI_right.Inst_S_OBI_right_ConfigMem.Inst_frame1_bit24.Q
+ VPWR VGND sg13g2_dlhq_1
X_0868_ Tile_X0Y0_FrameData[25] Tile_X0Y0_FrameStrobe[1] Tile_X0Y0_S_OBI_left.Inst_S_OBI_left_ConfigMem.Inst_frame1_bit25.Q
+ VPWR VGND sg13g2_dlhq_1
XFILLER_0_529 VPWR VGND sg13g2_decap_8
XFILLER_5_1304 VPWR VGND sg13g2_decap_8
XFILLER_5_1326 VPWR VGND sg13g2_decap_4
XFILLER_3_345 VPWR VGND sg13g2_decap_8
XFILLER_4_846 VPWR VGND sg13g2_decap_8
X_0653_ Tile_X0Y0_SS4END[13] Tile_X0Y0_S_OBI_left.Inst_S_OBI_left_ConfigMem.Inst_frame0_bit24.Q
+ _0009_ VPWR VGND sg13g2_nor2_1
X_0722_ Tile_X0Y0_FrameData[15] Tile_X1Y0_FrameStrobe[1] Tile_X1Y0_S_OBI_middle.Inst_S_OBI_middle_ConfigMem.Inst_frame1_bit15.Q
+ VPWR VGND sg13g2_dlhq_1
X_0584_ _0201_ Tile_X0Y0_S2END[0] Tile_X0Y0_S_OBI_left.Inst_S_OBI_left_ConfigMem.Inst_frame0_bit3.Q
+ VPWR VGND sg13g2_nand2b_1
X_1136_ Tile_X2Y0_S4END[0] Tile_X2Y0_N4BEG[15] VPWR VGND sg13g2_buf_1
X_1067_ Tile_X0Y0_FrameData[18] Tile_X2Y0_FrameData_O[18] VPWR VGND sg13g2_buf_1
XFILLER_0_1256 VPWR VGND sg13g2_decap_8
XFILLER_0_326 VPWR VGND sg13g2_decap_8
XFILLER_9_1292 VPWR VGND sg13g2_decap_8
XFILLER_10_1331 VPWR VGND sg13g2_fill_1
XFILLER_8_459 VPWR VGND sg13g2_decap_8
XFILLER_0_893 VPWR VGND sg13g2_decap_8
XFILLER_3_186 VPWR VGND sg13g2_fill_2
X_0636_ VPWR VGND Tile_X0Y0_S_OBI_left.Inst_S_OBI_left_ConfigMem.Inst_frame0_bit19.Q
+ _0065_ _0247_ _0245_ _0248_ _0246_ sg13g2_a221oi_1
XFILLER_8_960 VPWR VGND sg13g2_decap_4
X_0705_ Tile_X0Y0_FrameData[0] Tile_X1Y0_FrameStrobe[0] Tile_X1Y0_S_OBI_middle.Inst_S_OBI_middle_ConfigMem.Inst_frame0_bit0.Q
+ VPWR VGND sg13g2_dlhq_1
XFILLER_7_492 VPWR VGND sg13g2_decap_8
X_0498_ VPWR VGND Tile_X2Y0_S_OBI_right.Inst_S_OBI_right_ConfigMem.Inst_frame0_bit19.Q
+ _0045_ _0159_ _0157_ _0160_ _0158_ sg13g2_a221oi_1
X_0567_ Tile_X0Y0_S4END[8] WDATA_top2 Tile_X0Y0_S_OBI_left.Inst_S_OBI_left_ConfigMem.Inst_frame1_bit21.Q
+ Tile_X0Y0_S_OBI_left.Inst_S_OBI_left_switch_matrix.N4BEG7 VPWR VGND sg13g2_mux2_1
XFILLER_0_1075 VPWR VGND sg13g2_decap_8
X_1119_ Tile_X2Y0_S_OBI_right.Inst_S_OBI_right_switch_matrix.N2BEGb6 Tile_X2Y0_N2BEGb[6]
+ VPWR VGND sg13g2_buf_1
XFILLER_10_937 VPWR VGND sg13g2_fill_2
XFILLER_5_407 VPWR VGND sg13g2_decap_8
XFILLER_1_635 VPWR VGND sg13g2_decap_8
XFILLER_0_112 VPWR VGND sg13g2_decap_8
XFILLER_0_189 VPWR VGND sg13g2_decap_8
XFILLER_4_440 VPWR VGND sg13g2_decap_8
XFILLER_5_56 VPWR VGND sg13g2_decap_8
XFILLER_5_941 VPWR VGND sg13g2_decap_8
X_0421_ Tile_X2Y0_S2END[4] ADDR_top14 Tile_X2Y0_S_OBI_right.Inst_S_OBI_right_ConfigMem.Inst_frame1_bit9.Q
+ Tile_X2Y0_S_OBI_right.Inst_S_OBI_right_switch_matrix.N2BEGb3 VPWR VGND sg13g2_mux2_1
XFILLER_0_690 VPWR VGND sg13g2_decap_8
X_0352_ Tile_X1Y0_S_OBI_middle.Inst_S_OBI_middle_ConfigMem.Inst_frame0_bit8.Q VPWR
+ _0073_ VGND Tile_X1Y0_SS4END[0] Tile_X1Y0_S_OBI_middle.Inst_S_OBI_middle_ConfigMem.Inst_frame0_bit9.Q
+ sg13g2_o21ai_1
X_0283_ VPWR _0056_ Tile_X0Y0_SS4END[0] VGND sg13g2_inv_1
X_0619_ _0232_ _0229_ _0228_ RDATA_top3 VPWR VGND sg13g2_a21o_1
XANTENNA_129 VPWR VGND Tile_X0Y0_FrameData[20] sg13g2_antennanp
XANTENNA_107 VPWR VGND Tile_X0Y0_FrameData[22] sg13g2_antennanp
XANTENNA_118 VPWR VGND Tile_X0Y0_FrameData[2] sg13g2_antennanp
XFILLER_2_1104 VPWR VGND sg13g2_fill_2
XFILLER_6_1295 VPWR VGND sg13g2_decap_8
XFILLER_6_716 VPWR VGND sg13g2_fill_2
XFILLER_7_1015 VPWR VGND sg13g2_fill_1
XFILLER_2_955 VPWR VGND sg13g2_decap_8
X_0970_ Tile_X0Y0_SS4END[4] Tile_X0Y0_NN4BEG[11] VPWR VGND sg13g2_buf_1
XFILLER_9_576 VPWR VGND sg13g2_fill_2
X_0404_ Tile_X1Y0_S_OBI_middle.Inst_S_OBI_middle_ConfigMem.Inst_frame0_bit5.Q _0110_
+ _0111_ _0112_ VPWR VGND sg13g2_nor3_1
XFILLER_5_793 VPWR VGND sg13g2_decap_8
X_0266_ VPWR _0039_ Tile_X2Y0_S_OBI_right.Inst_S_OBI_right_ConfigMem.Inst_frame0_bit8.Q
+ VGND sg13g2_inv_1
X_0335_ Tile_X1Y0_S4END[0] WDATA_top20 Tile_X1Y0_S_OBI_middle.Inst_S_OBI_middle_ConfigMem.Inst_frame1_bit17.Q
+ Tile_X1Y0_S_OBI_middle.Inst_S_OBI_middle_switch_matrix.N4BEG15 VPWR VGND sg13g2_mux2_1
XFILLER_3_719 VPWR VGND sg13g2_fill_2
XFILLER_6_1081 VPWR VGND sg13g2_decap_8
XFILLER_1_240 VPWR VGND sg13g2_decap_8
XFILLER_2_752 VPWR VGND sg13g2_decap_8
XFILLER_2_35 VPWR VGND sg13g2_decap_8
XANTENNA_29 VPWR VGND Tile_X0Y0_FrameData[1] sg13g2_antennanp
XANTENNA_18 VPWR VGND Tile_X0Y0_FrameData[14] sg13g2_antennanp
X_0953_ Tile_X0Y0_S4END[5] Tile_X0Y0_N4BEG[10] VPWR VGND sg13g2_buf_1
X_0884_ Tile_X0Y0_FrameData[9] Tile_X0Y0_FrameStrobe[1] Tile_X0Y0_S_OBI_left.Inst_S_OBI_left_ConfigMem.Inst_frame1_bit9.Q
+ VPWR VGND sg13g2_dlhq_1
X_0318_ Tile_X1Y0_S2END[1] ADDR_top21 Tile_X1Y0_S_OBI_middle.Inst_S_OBI_middle_ConfigMem.Inst_frame1_bit0.Q
+ Tile_X1Y0_S_OBI_middle.Inst_S_OBI_middle_switch_matrix.N2BEGb6 VPWR VGND sg13g2_mux2_1
XFILLER_3_1265 VPWR VGND sg13g2_decap_8
XFILLER_11_328 VPWR VGND sg13g2_fill_2
XFILLER_11_317 VPWR VGND sg13g2_decap_8
XFILLER_3_527 VPWR VGND sg13g2_decap_8
XFILLER_11_840 VPWR VGND sg13g2_decap_4
XFILLER_7_866 VPWR VGND sg13g2_decap_8
X_1083_ Tile_X2Y0_FrameStrobe[2] Tile_X2Y0_FrameStrobe_O[2] VPWR VGND sg13g2_buf_1
X_1152_ Tile_X2Y0_SS4END[0] Tile_X2Y0_NN4BEG[15] VPWR VGND sg13g2_buf_1
X_0936_ Tile_X0Y0_S_OBI_left.Inst_S_OBI_left_switch_matrix.N2BEGb1 Tile_X0Y0_N2BEGb[1]
+ VPWR VGND sg13g2_buf_1
X_0798_ Tile_X0Y0_FrameData[25] Tile_X2Y0_FrameStrobe[1] Tile_X2Y0_S_OBI_right.Inst_S_OBI_right_ConfigMem.Inst_frame1_bit25.Q
+ VPWR VGND sg13g2_dlhq_1
X_0867_ Tile_X0Y0_FrameData[26] Tile_X0Y0_FrameStrobe[1] Tile_X0Y0_S_OBI_left.Inst_S_OBI_left_ConfigMem.Inst_frame1_bit26.Q
+ VPWR VGND sg13g2_dlhq_1
XFILLER_0_508 VPWR VGND sg13g2_decap_8
XFILLER_3_302 VPWR VGND sg13g2_decap_8
XFILLER_4_803 VPWR VGND sg13g2_fill_2
XFILLER_4_825 VPWR VGND sg13g2_decap_8
XFILLER_7_129 VPWR VGND sg13g2_fill_2
XFILLER_8_56 VPWR VGND sg13g2_fill_2
XFILLER_11_692 VPWR VGND sg13g2_decap_8
X_0652_ VGND VPWR Tile_X0Y0_S4END[13] Tile_X0Y0_S_OBI_left.Inst_S_OBI_left_ConfigMem.Inst_frame0_bit24.Q
+ _0008_ Tile_X0Y0_S_OBI_left.Inst_S_OBI_left_ConfigMem.Inst_frame0_bit25.Q sg13g2_a21oi_1
X_0583_ _0200_ VPWR Tile_X0Y0_S_OBI_left.Inst_S_OBI_left_switch_matrix.NN4BEG9 VGND
+ _0054_ Tile_X0Y0_S_OBI_left.Inst_S_OBI_left_ConfigMem.Inst_frame0_bit1.Q sg13g2_o21ai_1
X_0721_ Tile_X0Y0_FrameData[16] Tile_X1Y0_FrameStrobe[1] Tile_X1Y0_S_OBI_middle.Inst_S_OBI_middle_ConfigMem.Inst_frame1_bit16.Q
+ VPWR VGND sg13g2_dlhq_1
XFILLER_6_140 VPWR VGND sg13g2_fill_2
X_1135_ Tile_X2Y0_S4END[1] Tile_X2Y0_N4BEG[14] VPWR VGND sg13g2_buf_1
XFILLER_0_1235 VPWR VGND sg13g2_decap_8
X_1066_ Tile_X0Y0_FrameData[17] Tile_X2Y0_FrameData_O[17] VPWR VGND sg13g2_buf_1
X_0919_ Tile_X0Y0_FrameStrobe[16] Tile_X0Y0_FrameStrobe_O[16] VPWR VGND sg13g2_buf_1
XFILLER_8_438 VPWR VGND sg13g2_decap_8
XFILLER_0_872 VPWR VGND sg13g2_decap_8
X_0635_ Tile_X0Y0_SS4END[11] Tile_X0Y0_S_OBI_left.Inst_S_OBI_left_ConfigMem.Inst_frame0_bit18.Q
+ _0247_ VPWR VGND sg13g2_nor2_1
X_0704_ Tile_X0Y0_FrameData[1] Tile_X1Y0_FrameStrobe[0] Tile_X1Y0_S_OBI_middle.Inst_S_OBI_middle_ConfigMem.Inst_frame0_bit1.Q
+ VPWR VGND sg13g2_dlhq_1
X_0566_ Tile_X0Y0_S4END[9] WDATA_top3 Tile_X0Y0_S_OBI_left.Inst_S_OBI_left_ConfigMem.Inst_frame1_bit20.Q
+ Tile_X0Y0_S_OBI_left.Inst_S_OBI_left_switch_matrix.N4BEG6 VPWR VGND sg13g2_mux2_1
XFILLER_7_471 VPWR VGND sg13g2_decap_8
X_0497_ Tile_X2Y0_SS4END[11] Tile_X2Y0_S_OBI_right.Inst_S_OBI_right_ConfigMem.Inst_frame0_bit18.Q
+ _0159_ VPWR VGND sg13g2_nor2_1
X_1118_ Tile_X2Y0_S_OBI_right.Inst_S_OBI_right_switch_matrix.N2BEGb5 Tile_X2Y0_N2BEGb[5]
+ VPWR VGND sg13g2_buf_1
XFILLER_0_1054 VPWR VGND sg13g2_decap_8
X_1049_ Tile_X0Y0_FrameData[0] Tile_X2Y0_FrameData_O[0] VPWR VGND sg13g2_buf_1
XFILLER_6_909 VPWR VGND sg13g2_decap_8
XFILLER_0_168 VPWR VGND sg13g2_decap_8
XFILLER_9_714 VPWR VGND sg13g2_fill_1
X_0420_ Tile_X2Y0_S2END[5] ADDR_top15 Tile_X2Y0_S_OBI_right.Inst_S_OBI_right_ConfigMem.Inst_frame1_bit8.Q
+ Tile_X2Y0_S_OBI_right.Inst_S_OBI_right_switch_matrix.N2BEGb2 VPWR VGND sg13g2_mux2_1
XFILLER_10_1162 VPWR VGND sg13g2_fill_1
XFILLER_4_496 VPWR VGND sg13g2_decap_8
XFILLER_5_35 VPWR VGND sg13g2_decap_8
XFILLER_5_920 VPWR VGND sg13g2_decap_8
X_0282_ VPWR _0055_ Tile_X0Y0_S_OBI_left.Inst_S_OBI_left_ConfigMem.Inst_frame0_bit2.Q
+ VGND sg13g2_inv_1
X_0351_ Tile_X1Y0_SS4END[0] WDATA_top20 Tile_X1Y0_S_OBI_middle.Inst_S_OBI_middle_ConfigMem.Inst_frame0_bit1.Q
+ Tile_X1Y0_S_OBI_middle.Inst_S_OBI_middle_switch_matrix.NN4BEG15 VPWR VGND sg13g2_mux2_1
XFILLER_1_1330 VPWR VGND sg13g2_fill_2
X_0618_ Tile_X0Y0_S_OBI_left.Inst_S_OBI_left_ConfigMem.Inst_frame0_bit11.Q _0230_
+ _0231_ _0232_ VPWR VGND sg13g2_nor3_1
X_0549_ Tile_X0Y0_S2MID[2] WDATA_top2 Tile_X0Y0_S_OBI_left.Inst_S_OBI_left_ConfigMem.Inst_frame1_bit3.Q
+ Tile_X0Y0_S_OBI_left.Inst_S_OBI_left_switch_matrix.N2BEG5 VPWR VGND sg13g2_mux2_1
XANTENNA_119 VPWR VGND Tile_X0Y0_FrameData[20] sg13g2_antennanp
XFILLER_2_1149 VPWR VGND sg13g2_decap_8
XANTENNA_108 VPWR VGND Tile_X0Y0_FrameData[2] sg13g2_antennanp
XFILLER_6_1274 VPWR VGND sg13g2_decap_8
XFILLER_2_934 VPWR VGND sg13g2_decap_8
XFILLER_1_488 VPWR VGND sg13g2_fill_1
XFILLER_1_477 VPWR VGND sg13g2_decap_8
XFILLER_1_455 VPWR VGND sg13g2_decap_8
XFILLER_9_511 VPWR VGND sg13g2_fill_1
X_0403_ Tile_X1Y0_S1END[2] Tile_X1Y0_S_OBI_middle.Inst_S_OBI_middle_ConfigMem.Inst_frame0_bit6.Q
+ _0111_ VPWR VGND sg13g2_nor2b_1
X_0334_ Tile_X1Y0_S4END[1] WDATA_top21 Tile_X1Y0_S_OBI_middle.Inst_S_OBI_middle_ConfigMem.Inst_frame1_bit16.Q
+ Tile_X1Y0_S_OBI_middle.Inst_S_OBI_middle_switch_matrix.N4BEG14 VPWR VGND sg13g2_mux2_1
X_0265_ VPWR _0038_ Tile_X2Y0_SS4END[1] VGND sg13g2_inv_1
XFILLER_6_1071 VPWR VGND sg13g2_decap_4
XFILLER_10_532 VPWR VGND sg13g2_fill_2
XFILLER_9_0 VPWR VGND sg13g2_decap_8
XFILLER_1_285 VPWR VGND sg13g2_decap_8
XFILLER_1_263 VPWR VGND sg13g2_fill_1
XFILLER_2_14 VPWR VGND sg13g2_decap_8
XFILLER_2_731 VPWR VGND sg13g2_decap_8
XANTENNA_19 VPWR VGND Tile_X0Y0_FrameData[14] sg13g2_antennanp
X_0952_ Tile_X0Y0_S_OBI_left.Inst_S_OBI_left_switch_matrix.N4BEG9 Tile_X0Y0_N4BEG[9]
+ VPWR VGND sg13g2_buf_1
X_0883_ Tile_X0Y0_FrameData[10] Tile_X0Y0_FrameStrobe[1] Tile_X0Y0_S_OBI_left.Inst_S_OBI_left_ConfigMem.Inst_frame1_bit10.Q
+ VPWR VGND sg13g2_dlhq_1
X_0317_ Tile_X1Y0_S2END[2] ADDR_top22 Tile_X1Y0_S_OBI_middle.Inst_S_OBI_middle_ConfigMem.Inst_frame2_bit31.Q
+ Tile_X1Y0_S_OBI_middle.Inst_S_OBI_middle_switch_matrix.N2BEGb5 VPWR VGND sg13g2_mux2_1
XFILLER_3_1244 VPWR VGND sg13g2_decap_8
XFILLER_2_7 VPWR VGND sg13g2_decap_8
XFILLER_3_506 VPWR VGND sg13g2_decap_8
XFILLER_7_801 VPWR VGND sg13g2_decap_4
XFILLER_11_874 VPWR VGND sg13g2_decap_8
X_1151_ Tile_X2Y0_SS4END[1] Tile_X2Y0_NN4BEG[14] VPWR VGND sg13g2_buf_1
XFILLER_2_583 VPWR VGND sg13g2_decap_8
X_1082_ Tile_X2Y0_FrameStrobe[1] Tile_X2Y0_FrameStrobe_O[1] VPWR VGND sg13g2_buf_1
X_0935_ Tile_X0Y0_S_OBI_left.Inst_S_OBI_left_switch_matrix.N2BEGb0 Tile_X0Y0_N2BEGb[0]
+ VPWR VGND sg13g2_buf_1
X_0866_ Tile_X0Y0_FrameData[27] Tile_X0Y0_FrameStrobe[1] Tile_X0Y0_S_OBI_left.Inst_S_OBI_left_ConfigMem.Inst_frame1_bit27.Q
+ VPWR VGND sg13g2_dlhq_1
X_0797_ Tile_X0Y0_FrameData[26] Tile_X2Y0_FrameStrobe[1] Tile_X2Y0_S_OBI_right.Inst_S_OBI_right_ConfigMem.Inst_frame1_bit26.Q
+ VPWR VGND sg13g2_dlhq_1
XFILLER_8_35 VPWR VGND sg13g2_decap_8
X_0720_ Tile_X0Y0_FrameData[17] Tile_X1Y0_FrameStrobe[1] Tile_X1Y0_S_OBI_middle.Inst_S_OBI_middle_ConfigMem.Inst_frame1_bit17.Q
+ VPWR VGND sg13g2_dlhq_1
X_0651_ _0007_ Tile_X0Y0_S2END[7] Tile_X0Y0_S_OBI_left.Inst_S_OBI_left_ConfigMem.Inst_frame0_bit24.Q
+ VPWR VGND sg13g2_nand2b_1
X_0582_ _0200_ ADDR_top0 Tile_X0Y0_S_OBI_left.Inst_S_OBI_left_ConfigMem.Inst_frame0_bit1.Q
+ VPWR VGND sg13g2_nand2_1
XFILLER_3_881 VPWR VGND sg13g2_decap_8
XFILLER_6_185 VPWR VGND sg13g2_fill_2
X_1134_ Tile_X2Y0_S4END[2] Tile_X2Y0_N4BEG[13] VPWR VGND sg13g2_buf_1
XFILLER_2_380 VPWR VGND sg13g2_decap_8
XFILLER_0_1214 VPWR VGND sg13g2_decap_8
X_1065_ Tile_X0Y0_FrameData[16] Tile_X2Y0_FrameData_O[16] VPWR VGND sg13g2_buf_1
X_0918_ Tile_X0Y0_FrameStrobe[15] Tile_X0Y0_FrameStrobe_O[15] VPWR VGND sg13g2_buf_1
X_0849_ Tile_X0Y0_FrameData[12] Tile_X0Y0_FrameStrobe[0] Tile_X0Y0_S_OBI_left.Inst_S_OBI_left_ConfigMem.Inst_frame0_bit12.Q
+ VPWR VGND sg13g2_dlhq_1
XFILLER_1_829 VPWR VGND sg13g2_decap_8
XFILLER_1_807 VPWR VGND sg13g2_fill_1
XFILLER_8_417 VPWR VGND sg13g2_decap_8
XFILLER_3_133 VPWR VGND sg13g2_decap_8
XFILLER_0_851 VPWR VGND sg13g2_decap_8
XFILLER_3_188 VPWR VGND sg13g2_fill_1
X_0703_ Tile_X0Y0_FrameData[2] Tile_X1Y0_FrameStrobe[0] Tile_X1Y0_S_OBI_middle.Inst_S_OBI_middle_ConfigMem.Inst_frame0_bit2.Q
+ VPWR VGND sg13g2_dlhq_1
XFILLER_7_450 VPWR VGND sg13g2_decap_8
X_0496_ VGND VPWR Tile_X2Y0_S4END[11] Tile_X2Y0_S_OBI_right.Inst_S_OBI_right_ConfigMem.Inst_frame0_bit18.Q
+ _0158_ Tile_X2Y0_S_OBI_right.Inst_S_OBI_right_ConfigMem.Inst_frame0_bit19.Q sg13g2_a21oi_1
X_0565_ Tile_X0Y0_S4END[10] WDATA_top4 Tile_X0Y0_S_OBI_left.Inst_S_OBI_left_ConfigMem.Inst_frame1_bit19.Q
+ Tile_X0Y0_S_OBI_left.Inst_S_OBI_left_switch_matrix.N4BEG5 VPWR VGND sg13g2_mux2_1
X_0634_ VGND VPWR Tile_X0Y0_S4END[11] Tile_X0Y0_S_OBI_left.Inst_S_OBI_left_ConfigMem.Inst_frame0_bit18.Q
+ _0246_ Tile_X0Y0_S_OBI_left.Inst_S_OBI_left_ConfigMem.Inst_frame0_bit19.Q sg13g2_a21oi_1
X_1117_ Tile_X2Y0_S_OBI_right.Inst_S_OBI_right_switch_matrix.N2BEGb4 Tile_X2Y0_N2BEGb[4]
+ VPWR VGND sg13g2_buf_1
XFILLER_0_1033 VPWR VGND sg13g2_decap_8
XFILLER_10_939 VPWR VGND sg13g2_fill_1
X_1048_ Tile_X1Y0_UserCLK Tile_X1Y0_UserCLKo VPWR VGND sg13g2_buf_1
XFILLER_0_91 VPWR VGND sg13g2_decap_8
XFILLER_0_147 VPWR VGND sg13g2_decap_8
XFILLER_4_475 VPWR VGND sg13g2_decap_8
XFILLER_5_14 VPWR VGND sg13g2_decap_8
X_0350_ Tile_X1Y0_SS4END[1] WDATA_top21 Tile_X1Y0_S_OBI_middle.Inst_S_OBI_middle_ConfigMem.Inst_frame0_bit0.Q
+ Tile_X1Y0_S_OBI_middle.Inst_S_OBI_middle_switch_matrix.NN4BEG14 VPWR VGND sg13g2_mux2_1
XFILLER_5_976 VPWR VGND sg13g2_decap_8
X_0281_ VPWR _0054_ Tile_X0Y0_SS4END[6] VGND sg13g2_inv_1
XFILLER_8_792 VPWR VGND sg13g2_decap_8
X_0617_ Tile_X0Y0_S4END[3] Tile_X0Y0_S_OBI_left.Inst_S_OBI_left_ConfigMem.Inst_frame0_bit12.Q
+ _0231_ VPWR VGND sg13g2_nor2b_1
X_0548_ Tile_X0Y0_S2MID[3] WDATA_top3 Tile_X0Y0_S_OBI_left.Inst_S_OBI_left_ConfigMem.Inst_frame1_bit2.Q
+ Tile_X0Y0_S_OBI_left.Inst_S_OBI_left_switch_matrix.N2BEG4 VPWR VGND sg13g2_mux2_1
X_0479_ Tile_X2Y0_SS4END[9] Tile_X2Y0_S_OBI_right.Inst_S_OBI_right_ConfigMem.Inst_frame0_bit12.Q
+ _0143_ VPWR VGND sg13g2_nor2_1
XANTENNA_109 VPWR VGND Tile_X0Y0_FrameData[2] sg13g2_antennanp
XFILLER_1_434 VPWR VGND sg13g2_decap_8
XFILLER_2_913 VPWR VGND sg13g2_decap_8
XFILLER_5_762 VPWR VGND sg13g2_decap_4
X_0333_ Tile_X1Y0_S4END[2] WDATA_top22 Tile_X1Y0_S_OBI_middle.Inst_S_OBI_middle_ConfigMem.Inst_frame1_bit15.Q
+ Tile_X1Y0_S_OBI_middle.Inst_S_OBI_middle_switch_matrix.N4BEG13 VPWR VGND sg13g2_mux2_1
X_0402_ Tile_X1Y0_S1END[0] Tile_X1Y0_S_OBI_middle.Inst_S_OBI_middle_ConfigMem.Inst_frame0_bit6.Q
+ Tile_X1Y0_S_OBI_middle.Inst_S_OBI_middle_ConfigMem.Inst_frame0_bit7.Q _0110_ VPWR
+ VGND sg13g2_nor3_1
XFILLER_1_1194 VPWR VGND sg13g2_decap_8
X_0264_ VPWR _0037_ Tile_X2Y0_S_OBI_right.Inst_S_OBI_right_ConfigMem.Inst_frame0_bit5.Q
+ VGND sg13g2_inv_1
XFILLER_8_1326 VPWR VGND sg13g2_decap_4
XFILLER_1_275 VPWR VGND sg13g2_decap_4
XFILLER_2_710 VPWR VGND sg13g2_decap_8
XFILLER_2_787 VPWR VGND sg13g2_decap_8
X_0951_ Tile_X0Y0_S_OBI_left.Inst_S_OBI_left_switch_matrix.N4BEG8 Tile_X0Y0_N4BEG[8]
+ VPWR VGND sg13g2_buf_1
X_0882_ Tile_X0Y0_FrameData[11] Tile_X0Y0_FrameStrobe[1] Tile_X0Y0_S_OBI_left.Inst_S_OBI_left_ConfigMem.Inst_frame1_bit11.Q
+ VPWR VGND sg13g2_dlhq_1
X_0316_ Tile_X1Y0_S2END[3] ADDR_top23 Tile_X1Y0_S_OBI_middle.Inst_S_OBI_middle_ConfigMem.Inst_frame2_bit30.Q
+ Tile_X1Y0_S_OBI_middle.Inst_S_OBI_middle_switch_matrix.N2BEGb4 VPWR VGND sg13g2_mux2_1
XFILLER_3_1223 VPWR VGND sg13g2_decap_8
XFILLER_11_35 VPWR VGND sg13g2_decap_8
XFILLER_8_1134 VPWR VGND sg13g2_decap_4
XFILLER_6_345 VPWR VGND sg13g2_fill_2
X_1150_ Tile_X2Y0_SS4END[2] Tile_X2Y0_NN4BEG[13] VPWR VGND sg13g2_buf_1
XFILLER_2_562 VPWR VGND sg13g2_decap_8
X_1081_ Tile_X2Y0_FrameStrobe[0] Tile_X2Y0_FrameStrobe_O[0] VPWR VGND sg13g2_buf_1
X_0865_ Tile_X0Y0_FrameData[28] Tile_X0Y0_FrameStrobe[1] Tile_X0Y0_S_OBI_left.Inst_S_OBI_left_ConfigMem.Inst_frame1_bit28.Q
+ VPWR VGND sg13g2_dlhq_1
X_0934_ Tile_X0Y0_S_OBI_left.Inst_S_OBI_left_switch_matrix.N2BEG7 Tile_X0Y0_N2BEG[7]
+ VPWR VGND sg13g2_buf_1
X_0796_ Tile_X0Y0_FrameData[27] Tile_X2Y0_FrameStrobe[1] Tile_X2Y0_S_OBI_right.Inst_S_OBI_right_ConfigMem.Inst_frame1_bit27.Q
+ VPWR VGND sg13g2_dlhq_1
XFILLER_3_91 VPWR VGND sg13g2_decap_8
XFILLER_11_149 VPWR VGND sg13g2_fill_1
XFILLER_3_359 VPWR VGND sg13g2_decap_8
XFILLER_8_14 VPWR VGND sg13g2_decap_8
XFILLER_3_860 VPWR VGND sg13g2_decap_8
X_0650_ Tile_X0Y0_S_OBI_left.Inst_S_OBI_left_ConfigMem.Inst_frame0_bit23.Q _0003_
+ _0005_ _0006_ VPWR VGND sg13g2_nor3_1
X_0581_ _0199_ VPWR Tile_X0Y0_S_OBI_left.Inst_S_OBI_left_switch_matrix.NN4BEG8 VGND
+ _0053_ Tile_X0Y0_S_OBI_left.Inst_S_OBI_left_ConfigMem.Inst_frame0_bit0.Q sg13g2_o21ai_1
X_1133_ Tile_X2Y0_S4END[3] Tile_X2Y0_N4BEG[12] VPWR VGND sg13g2_buf_1
X_1064_ Tile_X0Y0_FrameData[15] Tile_X2Y0_FrameData_O[15] VPWR VGND sg13g2_buf_1
X_0779_ Tile_X0Y0_FrameData[12] Tile_X2Y0_FrameStrobe[0] Tile_X2Y0_S_OBI_right.Inst_S_OBI_right_ConfigMem.Inst_frame0_bit12.Q
+ VPWR VGND sg13g2_dlhq_1
X_0917_ Tile_X0Y0_FrameStrobe[14] Tile_X0Y0_FrameStrobe_O[14] VPWR VGND sg13g2_buf_1
X_0848_ Tile_X0Y0_FrameData[13] Tile_X0Y0_FrameStrobe[0] Tile_X0Y0_S_OBI_left.Inst_S_OBI_left_ConfigMem.Inst_frame0_bit13.Q
+ VPWR VGND sg13g2_dlhq_1
XFILLER_1_819 VPWR VGND sg13g2_decap_4
XFILLER_0_307 VPWR VGND sg13g2_fill_2
XFILLER_9_919 VPWR VGND sg13g2_decap_8
XFILLER_0_830 VPWR VGND sg13g2_decap_8
XFILLER_3_112 VPWR VGND sg13g2_decap_8
XFILLER_3_167 VPWR VGND sg13g2_fill_2
XFILLER_4_657 VPWR VGND sg13g2_fill_1
X_0633_ _0245_ Tile_X0Y0_S2END[5] Tile_X0Y0_S_OBI_left.Inst_S_OBI_left_ConfigMem.Inst_frame0_bit18.Q
+ VPWR VGND sg13g2_nand2b_1
X_0702_ Tile_X0Y0_FrameData[3] Tile_X1Y0_FrameStrobe[0] Tile_X1Y0_S_OBI_middle.Inst_S_OBI_middle_ConfigMem.Inst_frame0_bit3.Q
+ VPWR VGND sg13g2_dlhq_1
X_0495_ _0157_ Tile_X2Y0_S2END[5] Tile_X2Y0_S_OBI_right.Inst_S_OBI_right_ConfigMem.Inst_frame0_bit18.Q
+ VPWR VGND sg13g2_nand2b_1
X_0564_ Tile_X0Y0_S4END[11] WDATA_top5 Tile_X0Y0_S_OBI_left.Inst_S_OBI_left_ConfigMem.Inst_frame1_bit18.Q
+ Tile_X0Y0_S_OBI_left.Inst_S_OBI_left_switch_matrix.N4BEG4 VPWR VGND sg13g2_mux2_1
X_1116_ Tile_X2Y0_S_OBI_right.Inst_S_OBI_right_switch_matrix.N2BEGb3 Tile_X2Y0_N2BEGb[3]
+ VPWR VGND sg13g2_buf_1
XFILLER_0_1012 VPWR VGND sg13g2_decap_8
XFILLER_0_70 VPWR VGND sg13g2_decap_8
X_1047_ Tile_X1Y0_S_OBI_middle.Inst_S_OBI_middle_switch_matrix.NN4BEG15 Tile_X1Y0_NN4BEG[15]
+ VPWR VGND sg13g2_buf_1
XFILLER_0_1089 VPWR VGND sg13g2_decap_8
XFILLER_1_649 VPWR VGND sg13g2_decap_8
XFILLER_1_616 VPWR VGND sg13g2_fill_1
XFILLER_1_605 VPWR VGND sg13g2_decap_8
XFILLER_0_126 VPWR VGND sg13g2_decap_8
XFILLER_9_738 VPWR VGND sg13g2_fill_1
XFILLER_8_226 VPWR VGND sg13g2_decap_4
XFILLER_5_955 VPWR VGND sg13g2_decap_8
XFILLER_4_454 VPWR VGND sg13g2_decap_8
X_0280_ VPWR _0053_ Tile_X0Y0_SS4END[7] VGND sg13g2_inv_1
XFILLER_10_7 VPWR VGND sg13g2_decap_8
X_0616_ Tile_X0Y0_S2MID[3] Tile_X0Y0_S_OBI_left.Inst_S_OBI_left_ConfigMem.Inst_frame0_bit12.Q
+ Tile_X0Y0_S_OBI_left.Inst_S_OBI_left_ConfigMem.Inst_frame0_bit13.Q _0230_ VPWR VGND
+ sg13g2_nor3_1
X_0547_ Tile_X0Y0_S2MID[4] WDATA_top4 Tile_X0Y0_S_OBI_left.Inst_S_OBI_left_ConfigMem.Inst_frame1_bit1.Q
+ Tile_X0Y0_S_OBI_left.Inst_S_OBI_left_switch_matrix.N2BEG3 VPWR VGND sg13g2_mux2_1
X_0478_ VGND VPWR Tile_X2Y0_S4END[9] Tile_X2Y0_S_OBI_right.Inst_S_OBI_right_ConfigMem.Inst_frame0_bit12.Q
+ _0142_ Tile_X2Y0_S_OBI_right.Inst_S_OBI_right_ConfigMem.Inst_frame0_bit13.Q sg13g2_a21oi_1
XFILLER_1_413 VPWR VGND sg13g2_decap_8
XFILLER_2_969 VPWR VGND sg13g2_decap_8
X_0332_ Tile_X1Y0_S4END[3] WDATA_top23 Tile_X1Y0_S_OBI_middle.Inst_S_OBI_middle_ConfigMem.Inst_frame1_bit14.Q
+ Tile_X1Y0_S_OBI_middle.Inst_S_OBI_middle_switch_matrix.N4BEG12 VPWR VGND sg13g2_mux2_1
X_0401_ Tile_X1Y0_S_OBI_middle.Inst_S_OBI_middle_ConfigMem.Inst_frame0_bit7.Q VPWR
+ _0109_ VGND _0027_ Tile_X1Y0_S_OBI_middle.Inst_S_OBI_middle_ConfigMem.Inst_frame0_bit6.Q
+ sg13g2_o21ai_1
X_0263_ VPWR _0036_ Tile_X2Y0_SS4END[0] VGND sg13g2_inv_1
XFILLER_1_1173 VPWR VGND sg13g2_decap_8
XFILLER_10_534 VPWR VGND sg13g2_fill_1
XFILLER_1_210 VPWR VGND sg13g2_fill_2
XFILLER_6_505 VPWR VGND sg13g2_decap_8
XFILLER_1_254 VPWR VGND sg13g2_decap_8
XFILLER_2_49 VPWR VGND sg13g2_decap_8
XFILLER_2_766 VPWR VGND sg13g2_decap_8
XFILLER_9_376 VPWR VGND sg13g2_fill_2
X_0881_ Tile_X0Y0_FrameData[12] Tile_X0Y0_FrameStrobe[1] Tile_X0Y0_S_OBI_left.Inst_S_OBI_left_ConfigMem.Inst_frame1_bit12.Q
+ VPWR VGND sg13g2_dlhq_1
X_0950_ Tile_X0Y0_S_OBI_left.Inst_S_OBI_left_switch_matrix.N4BEG7 Tile_X0Y0_N4BEG[7]
+ VPWR VGND sg13g2_buf_1
X_0315_ Tile_X1Y0_S2END[4] ADDR_top20 Tile_X1Y0_S_OBI_middle.Inst_S_OBI_middle_ConfigMem.Inst_frame2_bit29.Q
+ Tile_X1Y0_S_OBI_middle.Inst_S_OBI_middle_switch_matrix.N2BEGb3 VPWR VGND sg13g2_mux2_1
XFILLER_3_1202 VPWR VGND sg13g2_decap_8
XFILLER_3_1279 VPWR VGND sg13g2_decap_8
XFILLER_11_14 VPWR VGND sg13g2_decap_8
XFILLER_2_541 VPWR VGND sg13g2_decap_8
XFILLER_6_379 VPWR VGND sg13g2_decap_8
X_1080_ Tile_X0Y0_FrameData[31] Tile_X2Y0_FrameData_O[31] VPWR VGND sg13g2_buf_1
X_0795_ Tile_X0Y0_FrameData[28] Tile_X2Y0_FrameStrobe[1] Tile_X2Y0_S_OBI_right.Inst_S_OBI_right_ConfigMem.Inst_frame1_bit28.Q
+ VPWR VGND sg13g2_dlhq_1
X_0864_ Tile_X0Y0_FrameData[29] Tile_X0Y0_FrameStrobe[1] Tile_X0Y0_S_OBI_left.Inst_S_OBI_left_ConfigMem.Inst_frame1_bit29.Q
+ VPWR VGND sg13g2_dlhq_1
X_0933_ Tile_X0Y0_S_OBI_left.Inst_S_OBI_left_switch_matrix.N2BEG6 Tile_X0Y0_N2BEG[6]
+ VPWR VGND sg13g2_buf_1
XFILLER_3_70 VPWR VGND sg13g2_decap_8
XFILLER_5_1319 VPWR VGND sg13g2_decap_8
XFILLER_3_338 VPWR VGND sg13g2_decap_8
XFILLER_4_839 VPWR VGND sg13g2_decap_8
XFILLER_10_161 VPWR VGND sg13g2_fill_1
XFILLER_6_187 VPWR VGND sg13g2_fill_1
X_0580_ _0199_ ADDR_top1 Tile_X0Y0_S_OBI_left.Inst_S_OBI_left_ConfigMem.Inst_frame0_bit0.Q
+ VPWR VGND sg13g2_nand2_1
X_1132_ Tile_X2Y0_S4END[4] Tile_X2Y0_N4BEG[11] VPWR VGND sg13g2_buf_1
XFILLER_0_1249 VPWR VGND sg13g2_decap_8
XFILLER_4_1330 VPWR VGND sg13g2_fill_2
X_1063_ Tile_X0Y0_FrameData[14] Tile_X2Y0_FrameData_O[14] VPWR VGND sg13g2_buf_1
X_0916_ Tile_X0Y0_FrameStrobe[13] Tile_X0Y0_FrameStrobe_O[13] VPWR VGND sg13g2_buf_1
X_0847_ Tile_X0Y0_FrameData[14] Tile_X0Y0_FrameStrobe[0] Tile_X0Y0_S_OBI_left.Inst_S_OBI_left_ConfigMem.Inst_frame0_bit14.Q
+ VPWR VGND sg13g2_dlhq_1
XFILLER_0_319 VPWR VGND sg13g2_decap_8
X_0778_ Tile_X0Y0_FrameData[13] Tile_X2Y0_FrameStrobe[0] Tile_X2Y0_S_OBI_right.Inst_S_OBI_right_ConfigMem.Inst_frame0_bit13.Q
+ VPWR VGND sg13g2_dlhq_1
XFILLER_9_1285 VPWR VGND sg13g2_decap_8
XFILLER_4_614 VPWR VGND sg13g2_fill_1
XFILLER_4_625 VPWR VGND sg13g2_fill_2
XFILLER_0_886 VPWR VGND sg13g2_decap_8
X_0632_ Tile_X0Y0_S_OBI_left.Inst_S_OBI_left_ConfigMem.Inst_frame0_bit17.Q _0241_
+ _0243_ _0244_ VPWR VGND sg13g2_nor3_1
XFILLER_8_964 VPWR VGND sg13g2_fill_2
XFILLER_8_953 VPWR VGND sg13g2_decap_8
X_0701_ Tile_X0Y0_FrameData[4] Tile_X1Y0_FrameStrobe[0] Tile_X1Y0_S_OBI_middle.Inst_S_OBI_middle_ConfigMem.Inst_frame0_bit4.Q
+ VPWR VGND sg13g2_dlhq_1
X_0563_ Tile_X0Y0_S4END[12] WDATA_top6 Tile_X0Y0_S_OBI_left.Inst_S_OBI_left_ConfigMem.Inst_frame1_bit17.Q
+ Tile_X0Y0_S_OBI_left.Inst_S_OBI_left_switch_matrix.N4BEG3 VPWR VGND sg13g2_mux2_1
XFILLER_7_485 VPWR VGND sg13g2_decap_8
X_0494_ _0152_ _0149_ _0156_ RDATA_top14 VPWR VGND sg13g2_a21o_1
XFILLER_2_190 VPWR VGND sg13g2_decap_8
X_1115_ Tile_X2Y0_S_OBI_right.Inst_S_OBI_right_switch_matrix.N2BEGb2 Tile_X2Y0_N2BEGb[2]
+ VPWR VGND sg13g2_buf_1
X_1046_ Tile_X1Y0_S_OBI_middle.Inst_S_OBI_middle_switch_matrix.NN4BEG14 Tile_X1Y0_NN4BEG[14]
+ VPWR VGND sg13g2_buf_1
XFILLER_0_1068 VPWR VGND sg13g2_decap_8
XFILLER_1_628 VPWR VGND sg13g2_decap_8
XFILLER_0_105 VPWR VGND sg13g2_decap_8
XFILLER_8_216 VPWR VGND sg13g2_decap_8
XFILLER_4_433 VPWR VGND sg13g2_decap_8
XFILLER_5_49 VPWR VGND sg13g2_decap_8
XFILLER_5_934 VPWR VGND sg13g2_decap_8
XFILLER_0_683 VPWR VGND sg13g2_decap_8
XFILLER_1_1311 VPWR VGND sg13g2_fill_1
X_0546_ Tile_X0Y0_S2MID[5] WDATA_top5 Tile_X0Y0_S_OBI_left.Inst_S_OBI_left_ConfigMem.Inst_frame1_bit0.Q
+ Tile_X0Y0_S_OBI_left.Inst_S_OBI_left_switch_matrix.N2BEG2 VPWR VGND sg13g2_mux2_1
X_0615_ Tile_X0Y0_S_OBI_left.Inst_S_OBI_left_ConfigMem.Inst_frame0_bit13.Q VPWR _0229_
+ VGND Tile_X0Y0_S_OBI_left.Inst_S_OBI_left_ConfigMem.Inst_frame0_bit12.Q _0062_ sg13g2_o21ai_1
X_0477_ _0141_ Tile_X2Y0_S2END[3] Tile_X2Y0_S_OBI_right.Inst_S_OBI_right_ConfigMem.Inst_frame0_bit12.Q
+ VPWR VGND sg13g2_nand2b_1
XFILLER_6_1288 VPWR VGND sg13g2_decap_8
X_1029_ Tile_X1Y0_S_OBI_middle.Inst_S_OBI_middle_switch_matrix.N4BEG13 Tile_X1Y0_N4BEG[13]
+ VPWR VGND sg13g2_buf_1
XFILLER_1_469 VPWR VGND sg13g2_decap_4
XFILLER_2_948 VPWR VGND sg13g2_decap_8
XFILLER_9_525 VPWR VGND sg13g2_fill_2
XFILLER_4_252 VPWR VGND sg13g2_fill_2
X_0400_ VPWR VGND Tile_X1Y0_S_OBI_middle.Inst_S_OBI_middle_ConfigMem.Inst_frame0_bit7.Q
+ _0030_ _0107_ _0105_ _0108_ _0106_ sg13g2_a221oi_1
X_0331_ Tile_X1Y0_S4END[4] WDATA_top24 Tile_X1Y0_S_OBI_middle.Inst_S_OBI_middle_ConfigMem.Inst_frame1_bit13.Q
+ Tile_X1Y0_S_OBI_middle.Inst_S_OBI_middle_switch_matrix.N4BEG11 VPWR VGND sg13g2_mux2_1
XFILLER_0_480 VPWR VGND sg13g2_decap_8
X_0262_ VPWR _0035_ Tile_X2Y0_S_OBI_right.Inst_S_OBI_right_ConfigMem.Inst_frame0_bit2.Q
+ VGND sg13g2_inv_1
XFILLER_1_1152 VPWR VGND sg13g2_decap_8
XFILLER_6_70 VPWR VGND sg13g2_decap_8
X_0529_ VPWR VGND Tile_X2Y0_S_OBI_right.Inst_S_OBI_right_ConfigMem.Inst_frame0_bit28.Q
+ _0049_ _0187_ _0185_ _0188_ _0186_ sg13g2_a221oi_1
XFILLER_11_1260 VPWR VGND sg13g2_fill_2
XFILLER_1_233 VPWR VGND sg13g2_decap_8
XFILLER_2_745 VPWR VGND sg13g2_decap_8
XFILLER_2_28 VPWR VGND sg13g2_decap_8
X_0880_ Tile_X0Y0_FrameData[13] Tile_X0Y0_FrameStrobe[1] Tile_X0Y0_S_OBI_left.Inst_S_OBI_left_ConfigMem.Inst_frame1_bit13.Q
+ VPWR VGND sg13g2_dlhq_1
XFILLER_5_594 VPWR VGND sg13g2_fill_1
X_0314_ Tile_X1Y0_S2END[5] ADDR_top21 Tile_X1Y0_S_OBI_middle.Inst_S_OBI_middle_ConfigMem.Inst_frame2_bit28.Q
+ Tile_X1Y0_S_OBI_middle.Inst_S_OBI_middle_switch_matrix.N2BEGb2 VPWR VGND sg13g2_mux2_1
XFILLER_3_1258 VPWR VGND sg13g2_decap_8
XFILLER_11_800 VPWR VGND sg13g2_fill_1
XFILLER_11_844 VPWR VGND sg13g2_fill_2
XFILLER_11_833 VPWR VGND sg13g2_decap_8
XFILLER_10_310 VPWR VGND sg13g2_decap_4
XFILLER_7_815 VPWR VGND sg13g2_fill_2
XFILLER_2_520 VPWR VGND sg13g2_decap_8
XFILLER_2_597 VPWR VGND sg13g2_decap_8
XFILLER_7_0 VPWR VGND sg13g2_decap_8
XFILLER_9_152 VPWR VGND sg13g2_fill_2
X_0932_ Tile_X0Y0_S_OBI_left.Inst_S_OBI_left_switch_matrix.N2BEG5 Tile_X0Y0_N2BEG[5]
+ VPWR VGND sg13g2_buf_1
X_0794_ Tile_X0Y0_FrameData[29] Tile_X2Y0_FrameStrobe[1] Tile_X2Y0_S_OBI_right.Inst_S_OBI_right_ConfigMem.Inst_frame1_bit29.Q
+ VPWR VGND sg13g2_dlhq_1
X_0863_ Tile_X0Y0_FrameData[30] Tile_X0Y0_FrameStrobe[1] Tile_X0Y0_S_OBI_left.Inst_S_OBI_left_ConfigMem.Inst_frame1_bit30.Q
+ VPWR VGND sg13g2_dlhq_1
XFILLER_6_881 VPWR VGND sg13g2_decap_8
XFILLER_3_1000 VPWR VGND sg13g2_decap_8
XFILLER_3_1011 VPWR VGND sg13g2_fill_2
XFILLER_3_1033 VPWR VGND sg13g2_decap_4
XFILLER_0_7 VPWR VGND sg13g2_decap_8
XFILLER_8_49 VPWR VGND sg13g2_decap_8
XFILLER_11_685 VPWR VGND sg13g2_decap_8
XFILLER_10_195 VPWR VGND sg13g2_fill_1
XFILLER_2_394 VPWR VGND sg13g2_decap_8
XFILLER_3_895 VPWR VGND sg13g2_decap_8
X_1131_ Tile_X2Y0_S4END[5] Tile_X2Y0_N4BEG[10] VPWR VGND sg13g2_buf_1
XFILLER_0_1228 VPWR VGND sg13g2_decap_8
X_1062_ Tile_X0Y0_FrameData[13] Tile_X2Y0_FrameData_O[13] VPWR VGND sg13g2_buf_1
X_0915_ Tile_X0Y0_FrameStrobe[12] Tile_X0Y0_FrameStrobe_O[12] VPWR VGND sg13g2_buf_1
X_0777_ Tile_X0Y0_FrameData[14] Tile_X2Y0_FrameStrobe[0] Tile_X2Y0_S_OBI_right.Inst_S_OBI_right_ConfigMem.Inst_frame0_bit14.Q
+ VPWR VGND sg13g2_dlhq_1
X_0846_ Tile_X0Y0_FrameData[15] Tile_X0Y0_FrameStrobe[0] Tile_X0Y0_S_OBI_left.Inst_S_OBI_left_ConfigMem.Inst_frame0_bit15.Q
+ VPWR VGND sg13g2_dlhq_1
XFILLER_9_1253 VPWR VGND sg13g2_fill_2
XFILLER_10_1303 VPWR VGND sg13g2_decap_4
XFILLER_4_648 VPWR VGND sg13g2_decap_4
XFILLER_0_865 VPWR VGND sg13g2_decap_8
XFILLER_11_493 VPWR VGND sg13g2_decap_8
XFILLER_8_932 VPWR VGND sg13g2_decap_8
X_0700_ Tile_X0Y0_FrameData[5] Tile_X1Y0_FrameStrobe[0] Tile_X1Y0_S_OBI_middle.Inst_S_OBI_middle_ConfigMem.Inst_frame0_bit5.Q
+ VPWR VGND sg13g2_dlhq_1
X_0631_ Tile_X0Y0_S4END[5] Tile_X0Y0_S_OBI_left.Inst_S_OBI_left_ConfigMem.Inst_frame0_bit18.Q
+ _0243_ VPWR VGND sg13g2_nor2b_1
X_0562_ Tile_X0Y0_S4END[13] WDATA_top7 Tile_X0Y0_S_OBI_left.Inst_S_OBI_left_ConfigMem.Inst_frame1_bit16.Q
+ Tile_X0Y0_S_OBI_left.Inst_S_OBI_left_switch_matrix.N4BEG2 VPWR VGND sg13g2_mux2_1
XFILLER_7_464 VPWR VGND sg13g2_decap_8
X_0493_ VPWR VGND Tile_X2Y0_S_OBI_right.Inst_S_OBI_right_ConfigMem.Inst_frame0_bit16.Q
+ _0043_ _0155_ _0153_ _0156_ _0154_ sg13g2_a221oi_1
XFILLER_4_1161 VPWR VGND sg13g2_fill_2
X_1114_ Tile_X2Y0_S_OBI_right.Inst_S_OBI_right_switch_matrix.N2BEGb1 Tile_X2Y0_N2BEGb[1]
+ VPWR VGND sg13g2_buf_1
X_1045_ Tile_X1Y0_S_OBI_middle.Inst_S_OBI_middle_switch_matrix.NN4BEG13 Tile_X1Y0_NN4BEG[13]
+ VPWR VGND sg13g2_buf_1
XFILLER_0_1047 VPWR VGND sg13g2_decap_8
X_0829_ Tile_X0Y0_FrameData[26] Tile_X2Y0_FrameStrobe[2] Tile_X2Y0_S_OBI_right.Inst_S_OBI_right_ConfigMem.Inst_frame2_bit26.Q
+ VPWR VGND sg13g2_dlhq_1
XFILLER_4_412 VPWR VGND sg13g2_decap_8
XFILLER_4_489 VPWR VGND sg13g2_decap_8
XFILLER_5_28 VPWR VGND sg13g2_decap_8
XFILLER_5_913 VPWR VGND sg13g2_decap_8
XFILLER_0_662 VPWR VGND sg13g2_decap_8
X_0476_ _0140_ _0138_ _0136_ RDATA_top12 VPWR VGND sg13g2_a21o_1
X_0545_ Tile_X0Y0_S2MID[6] WDATA_top6 Tile_X0Y0_S_OBI_left.Inst_S_OBI_left_ConfigMem.Inst_frame2_bit31.Q
+ Tile_X0Y0_S_OBI_left.Inst_S_OBI_left_switch_matrix.N2BEG1 VPWR VGND sg13g2_mux2_1
X_0614_ VPWR VGND Tile_X0Y0_S_OBI_left.Inst_S_OBI_left_ConfigMem.Inst_frame0_bit13.Q
+ _0061_ _0227_ _0225_ _0228_ _0226_ sg13g2_a221oi_1
XFILLER_6_1267 VPWR VGND sg13g2_decap_8
X_1028_ Tile_X1Y0_S_OBI_middle.Inst_S_OBI_middle_switch_matrix.N4BEG12 Tile_X1Y0_N4BEG[12]
+ VPWR VGND sg13g2_buf_1
XFILLER_2_927 VPWR VGND sg13g2_decap_8
XFILLER_1_448 VPWR VGND sg13g2_decap_8
X_0330_ Tile_X1Y0_S4END[5] WDATA_top25 Tile_X1Y0_S_OBI_middle.Inst_S_OBI_middle_ConfigMem.Inst_frame1_bit12.Q
+ Tile_X1Y0_S_OBI_middle.Inst_S_OBI_middle_switch_matrix.N4BEG10 VPWR VGND sg13g2_mux2_1
XFILLER_4_275 VPWR VGND sg13g2_fill_2
X_0261_ VPWR _0034_ Tile_X2Y0_SS4END[6] VGND sg13g2_inv_1
XFILLER_8_570 VPWR VGND sg13g2_fill_2
X_0528_ Tile_X2Y0_SS4END[14] Tile_X2Y0_S_OBI_right.Inst_S_OBI_right_ConfigMem.Inst_frame0_bit27.Q
+ _0187_ VPWR VGND sg13g2_nor2_1
XFILLER_8_1318 VPWR VGND sg13g2_fill_1
XFILLER_8_1307 VPWR VGND sg13g2_fill_1
X_0459_ _0125_ Tile_X2Y0_S2END[1] Tile_X2Y0_S_OBI_right.Inst_S_OBI_right_ConfigMem.Inst_frame0_bit6.Q
+ VPWR VGND sg13g2_nand2b_1
XFILLER_6_1075 VPWR VGND sg13g2_fill_2
XFILLER_1_212 VPWR VGND sg13g2_fill_1
XFILLER_2_724 VPWR VGND sg13g2_decap_8
XFILLER_9_378 VPWR VGND sg13g2_fill_1
X_0313_ Tile_X1Y0_S2END[6] ADDR_top22 Tile_X1Y0_S_OBI_middle.Inst_S_OBI_middle_ConfigMem.Inst_frame2_bit27.Q
+ Tile_X1Y0_S_OBI_middle.Inst_S_OBI_middle_switch_matrix.N2BEGb1 VPWR VGND sg13g2_mux2_1
XFILLER_3_1237 VPWR VGND sg13g2_decap_8
XFILLER_8_1126 VPWR VGND sg13g2_fill_1
XFILLER_2_576 VPWR VGND sg13g2_decap_8
XFILLER_2_1281 VPWR VGND sg13g2_decap_8
X_0931_ Tile_X0Y0_S_OBI_left.Inst_S_OBI_left_switch_matrix.N2BEG4 Tile_X0Y0_N2BEG[4]
+ VPWR VGND sg13g2_buf_1
X_0862_ Tile_X0Y0_FrameData[31] Tile_X0Y0_FrameStrobe[1] Tile_X0Y0_S_OBI_left.Inst_S_OBI_left_ConfigMem.Inst_frame1_bit31.Q
+ VPWR VGND sg13g2_dlhq_1
X_0793_ Tile_X0Y0_FrameData[30] Tile_X2Y0_FrameStrobe[1] Tile_X2Y0_S_OBI_right.Inst_S_OBI_right_ConfigMem.Inst_frame1_bit30.Q
+ VPWR VGND sg13g2_dlhq_1
XFILLER_6_860 VPWR VGND sg13g2_decap_8
XFILLER_3_1078 VPWR VGND sg13g2_fill_2
XFILLER_8_28 VPWR VGND sg13g2_decap_8
XFILLER_7_668 VPWR VGND sg13g2_fill_2
XFILLER_3_874 VPWR VGND sg13g2_decap_8
XFILLER_2_373 VPWR VGND sg13g2_decap_8
X_1130_ Tile_X2Y0_S_OBI_right.Inst_S_OBI_right_switch_matrix.N4BEG9 Tile_X2Y0_N4BEG[9]
+ VPWR VGND sg13g2_buf_1
XFILLER_0_1207 VPWR VGND sg13g2_decap_8
X_1061_ Tile_X0Y0_FrameData[12] Tile_X2Y0_FrameData_O[12] VPWR VGND sg13g2_buf_1
X_0845_ Tile_X0Y0_FrameData[16] Tile_X0Y0_FrameStrobe[0] Tile_X0Y0_S_OBI_left.Inst_S_OBI_left_ConfigMem.Inst_frame0_bit16.Q
+ VPWR VGND sg13g2_dlhq_1
X_0914_ Tile_X0Y0_FrameStrobe[11] Tile_X0Y0_FrameStrobe_O[11] VPWR VGND sg13g2_buf_1
X_0776_ Tile_X0Y0_FrameData[15] Tile_X2Y0_FrameStrobe[0] Tile_X2Y0_S_OBI_right.Inst_S_OBI_right_ConfigMem.Inst_frame0_bit15.Q
+ VPWR VGND sg13g2_dlhq_1
XFILLER_3_126 VPWR VGND sg13g2_decap_8
XFILLER_4_627 VPWR VGND sg13g2_fill_1
XFILLER_0_844 VPWR VGND sg13g2_decap_8
XFILLER_11_472 VPWR VGND sg13g2_decap_8
XFILLER_8_911 VPWR VGND sg13g2_decap_8
XFILLER_7_443 VPWR VGND sg13g2_decap_8
X_0492_ Tile_X2Y0_SS4END[10] Tile_X2Y0_S_OBI_right.Inst_S_OBI_right_ConfigMem.Inst_frame0_bit15.Q
+ _0155_ VPWR VGND sg13g2_nor2_1
X_0630_ Tile_X0Y0_S_OBI_left.Inst_S_OBI_left_ConfigMem.Inst_frame0_bit19.Q VPWR _0242_
+ VGND Tile_X0Y0_S_OBI_left.Inst_S_OBI_left_ConfigMem.Inst_frame0_bit18.Q _0066_ sg13g2_o21ai_1
X_0561_ Tile_X0Y0_S4END[14] WDATA_top8 Tile_X0Y0_S_OBI_left.Inst_S_OBI_left_ConfigMem.Inst_frame1_bit15.Q
+ Tile_X0Y0_S_OBI_left.Inst_S_OBI_left_switch_matrix.N4BEG1 VPWR VGND sg13g2_mux2_1
XFILLER_3_671 VPWR VGND sg13g2_fill_2
X_1044_ Tile_X1Y0_S_OBI_middle.Inst_S_OBI_middle_switch_matrix.NN4BEG12 Tile_X1Y0_NN4BEG[12]
+ VPWR VGND sg13g2_buf_1
X_1113_ Tile_X2Y0_S_OBI_right.Inst_S_OBI_right_switch_matrix.N2BEGb0 Tile_X2Y0_N2BEGb[0]
+ VPWR VGND sg13g2_buf_1
XFILLER_0_1026 VPWR VGND sg13g2_decap_8
XFILLER_0_84 VPWR VGND sg13g2_decap_8
X_0828_ Tile_X0Y0_FrameData[27] Tile_X2Y0_FrameStrobe[2] Tile_X2Y0_S_OBI_right.Inst_S_OBI_right_ConfigMem.Inst_frame2_bit27.Q
+ VPWR VGND sg13g2_dlhq_1
X_0759_ Tile_X0Y0_FrameData[10] Tile_X1Y0_FrameStrobe[2] Tile_X1Y0_S_OBI_middle.Inst_S_OBI_middle_ConfigMem.Inst_frame2_bit10.Q
+ VPWR VGND sg13g2_dlhq_1
XFILLER_9_1040 VPWR VGND sg13g2_fill_1
XFILLER_4_468 VPWR VGND sg13g2_decap_8
XFILLER_5_969 VPWR VGND sg13g2_decap_8
XFILLER_0_641 VPWR VGND sg13g2_decap_8
X_0613_ Tile_X0Y0_SS4END[9] Tile_X0Y0_S_OBI_left.Inst_S_OBI_left_ConfigMem.Inst_frame0_bit12.Q
+ _0227_ VPWR VGND sg13g2_nor2_1
XFILLER_7_273 VPWR VGND sg13g2_fill_2
X_0544_ Tile_X0Y0_S2MID[7] WDATA_top7 Tile_X0Y0_S_OBI_left.Inst_S_OBI_left_ConfigMem.Inst_frame2_bit30.Q
+ Tile_X0Y0_S_OBI_left.Inst_S_OBI_left_switch_matrix.N2BEG0 VPWR VGND sg13g2_mux2_1
X_0475_ Tile_X2Y0_S_OBI_right.Inst_S_OBI_right_ConfigMem.Inst_frame0_bit8.Q _0137_
+ _0139_ _0140_ VPWR VGND sg13g2_nor3_1
X_1027_ Tile_X1Y0_S_OBI_middle.Inst_S_OBI_middle_switch_matrix.N4BEG11 Tile_X1Y0_N4BEG[11]
+ VPWR VGND sg13g2_buf_1
XFILLER_1_427 VPWR VGND sg13g2_decap_8
XFILLER_1_405 VPWR VGND sg13g2_decap_4
XFILLER_2_906 VPWR VGND sg13g2_decap_8
XFILLER_9_527 VPWR VGND sg13g2_fill_1
XFILLER_1_983 VPWR VGND sg13g2_fill_1
XFILLER_1_972 VPWR VGND sg13g2_decap_8
XFILLER_4_254 VPWR VGND sg13g2_fill_1
X_0260_ VPWR _0033_ Tile_X2Y0_SS4END[7] VGND sg13g2_inv_1
XFILLER_5_1290 VPWR VGND sg13g2_decap_8
XFILLER_1_1187 VPWR VGND sg13g2_decap_8
X_0527_ VGND VPWR Tile_X2Y0_S4END[14] Tile_X2Y0_S_OBI_right.Inst_S_OBI_right_ConfigMem.Inst_frame0_bit27.Q
+ _0186_ Tile_X2Y0_S_OBI_right.Inst_S_OBI_right_ConfigMem.Inst_frame0_bit28.Q sg13g2_a21oi_1
X_0458_ _0124_ _0121_ _0120_ RDATA_top10 VPWR VGND sg13g2_a21o_1
X_0389_ VGND VPWR Tile_X1Y0_S1END[3] Tile_X1Y0_S_OBI_middle.Inst_S_OBI_middle_ConfigMem.Inst_frame0_bit3.Q
+ _0098_ Tile_X1Y0_S_OBI_middle.Inst_S_OBI_middle_ConfigMem.Inst_frame0_bit4.Q sg13g2_a21oi_1
XFILLER_6_1032 VPWR VGND sg13g2_fill_2
XFILLER_10_559 VPWR VGND sg13g2_fill_1
XFILLER_1_279 VPWR VGND sg13g2_fill_2
XFILLER_1_268 VPWR VGND sg13g2_decap_8
XFILLER_2_703 VPWR VGND sg13g2_decap_8
XFILLER_5_574 VPWR VGND sg13g2_fill_2
X_0312_ Tile_X1Y0_S2END[7] ADDR_top23 Tile_X1Y0_S_OBI_middle.Inst_S_OBI_middle_ConfigMem.Inst_frame2_bit26.Q
+ Tile_X1Y0_S_OBI_middle.Inst_S_OBI_middle_switch_matrix.N2BEGb0 VPWR VGND sg13g2_mux2_1
XFILLER_3_1216 VPWR VGND sg13g2_decap_8
XFILLER_11_28 VPWR VGND sg13g2_decap_8
XFILLER_2_555 VPWR VGND sg13g2_decap_8
XFILLER_2_1260 VPWR VGND sg13g2_decap_8
X_0930_ Tile_X0Y0_S_OBI_left.Inst_S_OBI_left_switch_matrix.N2BEG3 Tile_X0Y0_N2BEG[3]
+ VPWR VGND sg13g2_buf_1
XFILLER_9_154 VPWR VGND sg13g2_fill_1
X_0792_ Tile_X0Y0_FrameData[31] Tile_X2Y0_FrameStrobe[1] Tile_X2Y0_S_OBI_right.Inst_S_OBI_right_ConfigMem.Inst_frame1_bit31.Q
+ VPWR VGND sg13g2_dlhq_1
X_0861_ Tile_X0Y0_FrameData[0] Tile_X0Y0_FrameStrobe[0] Tile_X0Y0_S_OBI_left.Inst_S_OBI_left_ConfigMem.Inst_frame0_bit0.Q
+ VPWR VGND sg13g2_dlhq_1
XFILLER_5_393 VPWR VGND sg13g2_decap_8
XFILLER_3_84 VPWR VGND sg13g2_decap_8
XFILLER_6_135 VPWR VGND sg13g2_fill_1
XFILLER_2_352 VPWR VGND sg13g2_decap_8
XFILLER_3_853 VPWR VGND sg13g2_decap_8
X_1060_ Tile_X0Y0_FrameData[11] Tile_X2Y0_FrameData_O[11] VPWR VGND sg13g2_buf_1
X_0844_ Tile_X0Y0_FrameData[17] Tile_X0Y0_FrameStrobe[0] Tile_X0Y0_S_OBI_left.Inst_S_OBI_left_ConfigMem.Inst_frame0_bit17.Q
+ VPWR VGND sg13g2_dlhq_1
X_0775_ Tile_X0Y0_FrameData[16] Tile_X2Y0_FrameStrobe[0] Tile_X2Y0_S_OBI_right.Inst_S_OBI_right_ConfigMem.Inst_frame0_bit16.Q
+ VPWR VGND sg13g2_dlhq_1
X_0913_ Tile_X0Y0_FrameStrobe[10] Tile_X0Y0_FrameStrobe_O[10] VPWR VGND sg13g2_buf_1
XFILLER_9_1299 VPWR VGND sg13g2_decap_8
XFILLER_10_1327 VPWR VGND sg13g2_decap_4
XFILLER_0_823 VPWR VGND sg13g2_decap_8
XFILLER_3_105 VPWR VGND sg13g2_decap_8
XFILLER_11_451 VPWR VGND sg13g2_decap_8
XFILLER_7_422 VPWR VGND sg13g2_decap_8
XFILLER_7_499 VPWR VGND sg13g2_decap_8
X_0491_ VGND VPWR Tile_X2Y0_S4END[10] Tile_X2Y0_S_OBI_right.Inst_S_OBI_right_ConfigMem.Inst_frame0_bit15.Q
+ _0154_ Tile_X2Y0_S_OBI_right.Inst_S_OBI_right_ConfigMem.Inst_frame0_bit16.Q sg13g2_a21oi_1
X_0560_ Tile_X0Y0_S4END[15] WDATA_top9 Tile_X0Y0_S_OBI_left.Inst_S_OBI_left_ConfigMem.Inst_frame1_bit14.Q
+ Tile_X0Y0_S_OBI_left.Inst_S_OBI_left_switch_matrix.N4BEG0 VPWR VGND sg13g2_mux2_1
X_1043_ Tile_X1Y0_S_OBI_middle.Inst_S_OBI_middle_switch_matrix.NN4BEG11 Tile_X1Y0_NN4BEG[11]
+ VPWR VGND sg13g2_buf_1
XFILLER_0_1005 VPWR VGND sg13g2_decap_8
XFILLER_0_63 VPWR VGND sg13g2_decap_8
X_1112_ Tile_X2Y0_S_OBI_right.Inst_S_OBI_right_switch_matrix.N2BEG7 Tile_X2Y0_N2BEG[7]
+ VPWR VGND sg13g2_buf_1
X_0827_ Tile_X0Y0_FrameData[28] Tile_X2Y0_FrameStrobe[2] Tile_X2Y0_S_OBI_right.Inst_S_OBI_right_ConfigMem.Inst_frame2_bit28.Q
+ VPWR VGND sg13g2_dlhq_1
X_0758_ Tile_X0Y0_FrameData[11] Tile_X1Y0_FrameStrobe[2] Tile_X1Y0_S_OBI_middle.Inst_S_OBI_middle_ConfigMem.Inst_frame2_bit11.Q
+ VPWR VGND sg13g2_dlhq_1
X_0689_ Tile_X0Y0_FrameData[16] Tile_X1Y0_FrameStrobe[0] Tile_X1Y0_S_OBI_middle.Inst_S_OBI_middle_ConfigMem.Inst_frame0_bit16.Q
+ VPWR VGND sg13g2_dlhq_1
XFILLER_0_119 VPWR VGND sg13g2_decap_8
XFILLER_5_948 VPWR VGND sg13g2_decap_8
XFILLER_0_620 VPWR VGND sg13g2_decap_8
XFILLER_4_447 VPWR VGND sg13g2_decap_8
XFILLER_0_697 VPWR VGND sg13g2_decap_8
XFILLER_8_764 VPWR VGND sg13g2_fill_1
X_0612_ VGND VPWR Tile_X0Y0_S4END[9] Tile_X0Y0_S_OBI_left.Inst_S_OBI_left_ConfigMem.Inst_frame0_bit12.Q
+ _0226_ Tile_X0Y0_S_OBI_left.Inst_S_OBI_left_ConfigMem.Inst_frame0_bit13.Q sg13g2_a21oi_1
X_0543_ Tile_X0Y0_S1END[0] ADDR_top8 Tile_X0Y0_S_OBI_left.Inst_S_OBI_left_ConfigMem.Inst_frame2_bit29.Q
+ Tile_X0Y0_S_OBI_left.Inst_S_OBI_left_switch_matrix.N1BEG3 VPWR VGND sg13g2_mux2_1
X_0474_ Tile_X2Y0_S4END[2] Tile_X2Y0_S_OBI_right.Inst_S_OBI_right_ConfigMem.Inst_frame0_bit9.Q
+ _0139_ VPWR VGND sg13g2_nor2b_1
XFILLER_6_1203 VPWR VGND sg13g2_decap_4
X_1026_ Tile_X1Y0_S_OBI_middle.Inst_S_OBI_middle_switch_matrix.N4BEG10 Tile_X1Y0_N4BEG[10]
+ VPWR VGND sg13g2_buf_1
XFILLER_9_506 VPWR VGND sg13g2_fill_2
XFILLER_1_995 VPWR VGND sg13g2_decap_4
XFILLER_0_494 VPWR VGND sg13g2_decap_8
XFILLER_4_277 VPWR VGND sg13g2_fill_1
XFILLER_1_1166 VPWR VGND sg13g2_decap_8
XFILLER_8_550 VPWR VGND sg13g2_fill_1
X_0526_ _0185_ Tile_X2Y0_S1END[2] Tile_X2Y0_S_OBI_right.Inst_S_OBI_right_ConfigMem.Inst_frame0_bit27.Q
+ VPWR VGND sg13g2_nand2b_1
X_0388_ _0097_ Tile_X1Y0_S1END[1] Tile_X1Y0_S_OBI_middle.Inst_S_OBI_middle_ConfigMem.Inst_frame0_bit3.Q
+ VPWR VGND sg13g2_nand2b_1
X_0457_ Tile_X2Y0_S_OBI_right.Inst_S_OBI_right_ConfigMem.Inst_frame0_bit2.Q _0122_
+ _0123_ _0124_ VPWR VGND sg13g2_nor3_1
XFILLER_6_1088 VPWR VGND sg13g2_fill_1
X_1009_ Tile_X1Y0_S_OBI_middle.Inst_S_OBI_middle_switch_matrix.N2BEGb1 Tile_X1Y0_N2BEGb[1]
+ VPWR VGND sg13g2_buf_1
XFILLER_11_1296 VPWR VGND sg13g2_decap_8
XFILLER_1_203 VPWR VGND sg13g2_decap_8
XFILLER_1_247 VPWR VGND sg13g2_decap_8
XFILLER_2_759 VPWR VGND sg13g2_decap_8
X_0311_ _0072_ VPWR Tile_X1Y0_S_OBI_middle.Inst_S_OBI_middle_switch_matrix.N2BEG7
+ VGND _0028_ Tile_X1Y0_S_OBI_middle.Inst_S_OBI_middle_ConfigMem.Inst_frame2_bit25.Q
+ sg13g2_o21ai_1
XFILLER_7_1331 VPWR VGND sg13g2_fill_1
X_0509_ Tile_X2Y0_S2MID[6] Tile_X2Y0_S_OBI_right.Inst_S_OBI_right_ConfigMem.Inst_frame0_bit21.Q
+ Tile_X2Y0_S_OBI_right.Inst_S_OBI_right_ConfigMem.Inst_frame0_bit22.Q _0170_ VPWR
+ VGND sg13g2_nor3_1
XFILLER_2_534 VPWR VGND sg13g2_decap_8
XFILLER_9_188 VPWR VGND sg13g2_fill_2
X_0860_ Tile_X0Y0_FrameData[1] Tile_X0Y0_FrameStrobe[0] Tile_X0Y0_S_OBI_left.Inst_S_OBI_left_ConfigMem.Inst_frame0_bit1.Q
+ VPWR VGND sg13g2_dlhq_1
X_0791_ Tile_X0Y0_FrameData[0] Tile_X2Y0_FrameStrobe[0] Tile_X2Y0_S_OBI_right.Inst_S_OBI_right_ConfigMem.Inst_frame0_bit0.Q
+ VPWR VGND sg13g2_dlhq_1
XFILLER_6_840 VPWR VGND sg13g2_fill_2
XFILLER_3_63 VPWR VGND sg13g2_decap_8
XFILLER_5_372 VPWR VGND sg13g2_decap_8
XFILLER_6_895 VPWR VGND sg13g2_decap_8
X_0989_ Tile_X1Y0_FrameStrobe[13] Tile_X1Y0_FrameStrobe_O[13] VPWR VGND sg13g2_buf_1
XFILLER_3_309 VPWR VGND sg13g2_fill_2
XFILLER_11_699 VPWR VGND sg13g2_fill_1
XFILLER_2_331 VPWR VGND sg13g2_decap_8
XFILLER_3_832 VPWR VGND sg13g2_decap_8
XFILLER_5_0 VPWR VGND sg13g2_decap_8
XFILLER_4_1323 VPWR VGND sg13g2_decap_8
X_0912_ Tile_X0Y0_FrameStrobe[9] Tile_X0Y0_FrameStrobe_O[9] VPWR VGND sg13g2_buf_1
X_0843_ Tile_X0Y0_FrameData[18] Tile_X0Y0_FrameStrobe[0] Tile_X0Y0_S_OBI_left.Inst_S_OBI_left_ConfigMem.Inst_frame0_bit18.Q
+ VPWR VGND sg13g2_dlhq_1
X_0774_ Tile_X0Y0_FrameData[17] Tile_X2Y0_FrameStrobe[0] Tile_X2Y0_S_OBI_right.Inst_S_OBI_right_ConfigMem.Inst_frame0_bit17.Q
+ VPWR VGND sg13g2_dlhq_1
XFILLER_5_180 VPWR VGND sg13g2_fill_1
XFILLER_0_802 VPWR VGND sg13g2_decap_8
XFILLER_0_879 VPWR VGND sg13g2_decap_8
XFILLER_11_430 VPWR VGND sg13g2_decap_8
XFILLER_8_946 VPWR VGND sg13g2_decap_8
XFILLER_7_401 VPWR VGND sg13g2_decap_8
XFILLER_7_478 VPWR VGND sg13g2_decap_8
X_0490_ _0153_ Tile_X2Y0_S2END[4] Tile_X2Y0_S_OBI_right.Inst_S_OBI_right_ConfigMem.Inst_frame0_bit15.Q
+ VPWR VGND sg13g2_nand2b_1
XFILLER_2_161 VPWR VGND sg13g2_fill_2
XFILLER_2_183 VPWR VGND sg13g2_decap_8
X_1042_ Tile_X1Y0_S_OBI_middle.Inst_S_OBI_middle_switch_matrix.NN4BEG10 Tile_X1Y0_NN4BEG[10]
+ VPWR VGND sg13g2_buf_1
XFILLER_0_42 VPWR VGND sg13g2_decap_8
XFILLER_4_1120 VPWR VGND sg13g2_fill_2
X_1111_ Tile_X2Y0_S_OBI_right.Inst_S_OBI_right_switch_matrix.N2BEG6 Tile_X2Y0_N2BEG[6]
+ VPWR VGND sg13g2_buf_1
X_0826_ Tile_X0Y0_FrameData[29] Tile_X2Y0_FrameStrobe[2] Tile_X2Y0_S_OBI_right.Inst_S_OBI_right_ConfigMem.Inst_frame2_bit29.Q
+ VPWR VGND sg13g2_dlhq_1
X_0757_ Tile_X0Y0_FrameData[12] Tile_X1Y0_FrameStrobe[2] Tile_X1Y0_S_OBI_middle.Inst_S_OBI_middle_ConfigMem.Inst_frame2_bit12.Q
+ VPWR VGND sg13g2_dlhq_1
X_0688_ Tile_X0Y0_FrameData[17] Tile_X1Y0_FrameStrobe[0] Tile_X1Y0_S_OBI_middle.Inst_S_OBI_middle_ConfigMem.Inst_frame0_bit17.Q
+ VPWR VGND sg13g2_dlhq_1
XFILLER_4_426 VPWR VGND sg13g2_decap_8
XFILLER_5_927 VPWR VGND sg13g2_decap_8
XFILLER_0_676 VPWR VGND sg13g2_decap_8
XFILLER_11_271 VPWR VGND sg13g2_fill_2
X_0542_ Tile_X0Y0_S1END[1] ADDR_top9 Tile_X0Y0_S_OBI_left.Inst_S_OBI_left_ConfigMem.Inst_frame2_bit28.Q
+ Tile_X0Y0_S_OBI_left.Inst_S_OBI_left_switch_matrix.N1BEG2 VPWR VGND sg13g2_mux2_1
X_0611_ _0225_ Tile_X0Y0_S2END[3] Tile_X0Y0_S_OBI_left.Inst_S_OBI_left_ConfigMem.Inst_frame0_bit12.Q
+ VPWR VGND sg13g2_nand2b_1
XFILLER_4_993 VPWR VGND sg13g2_decap_8
XFILLER_3_492 VPWR VGND sg13g2_decap_8
X_0473_ Tile_X2Y0_S_OBI_right.Inst_S_OBI_right_ConfigMem.Inst_frame0_bit10.Q VPWR
+ _0138_ VGND Tile_X2Y0_S_OBI_right.Inst_S_OBI_right_ConfigMem.Inst_frame0_bit9.Q
+ _0040_ sg13g2_o21ai_1
X_1025_ Tile_X1Y0_S_OBI_middle.Inst_S_OBI_middle_switch_matrix.N4BEG9 Tile_X1Y0_N4BEG[9]
+ VPWR VGND sg13g2_buf_1
X_0809_ Tile_X0Y0_FrameData[14] Tile_X2Y0_FrameStrobe[1] Tile_X2Y0_S_OBI_right.Inst_S_OBI_right_ConfigMem.Inst_frame1_bit14.Q
+ VPWR VGND sg13g2_dlhq_1
XFILLER_9_518 VPWR VGND sg13g2_decap_8
XFILLER_5_713 VPWR VGND sg13g2_fill_1
XFILLER_5_724 VPWR VGND sg13g2_fill_2
XFILLER_1_952 VPWR VGND sg13g2_fill_1
XFILLER_1_941 VPWR VGND sg13g2_decap_8
XFILLER_0_473 VPWR VGND sg13g2_decap_8
XFILLER_1_1145 VPWR VGND sg13g2_decap_8
XANTENNA_1 VPWR VGND ADDR_top0 sg13g2_antennanp
X_0525_ Tile_X2Y0_S_OBI_right.Inst_S_OBI_right_ConfigMem.Inst_frame0_bit26.Q _0182_
+ _0183_ _0184_ VPWR VGND sg13g2_nor3_1
X_0456_ Tile_X2Y0_S4END[0] Tile_X2Y0_S_OBI_right.Inst_S_OBI_right_ConfigMem.Inst_frame0_bit3.Q
+ _0123_ VPWR VGND sg13g2_nor2b_1
XFILLER_6_63 VPWR VGND sg13g2_decap_8
X_0387_ _0095_ VPWR RDATA_top31 VGND Tile_X1Y0_S_OBI_middle.Inst_S_OBI_middle_ConfigMem.Inst_frame0_bit31.Q
+ _0096_ sg13g2_o21ai_1
X_1008_ Tile_X1Y0_S_OBI_middle.Inst_S_OBI_middle_switch_matrix.N2BEGb0 Tile_X1Y0_N2BEGb[0]
+ VPWR VGND sg13g2_buf_1
XFILLER_9_7 VPWR VGND sg13g2_decap_8
XFILLER_2_738 VPWR VGND sg13g2_decap_8
X_0310_ _0072_ BE_top3 Tile_X1Y0_S_OBI_middle.Inst_S_OBI_middle_ConfigMem.Inst_frame2_bit25.Q
+ VPWR VGND sg13g2_nand2_1
XFILLER_1_760 VPWR VGND sg13g2_fill_1
XFILLER_5_576 VPWR VGND sg13g2_fill_1
XFILLER_8_1107 VPWR VGND sg13g2_fill_2
X_0508_ Tile_X2Y0_S_OBI_right.Inst_S_OBI_right_ConfigMem.Inst_frame0_bit22.Q VPWR
+ _0169_ VGND _0034_ Tile_X2Y0_S_OBI_right.Inst_S_OBI_right_ConfigMem.Inst_frame0_bit21.Q
+ sg13g2_o21ai_1
X_0439_ Tile_X2Y0_SS4END[12] ADDR_top16 Tile_X2Y0_S_OBI_right.Inst_S_OBI_right_ConfigMem.Inst_frame1_bit27.Q
+ Tile_X2Y0_S_OBI_right.Inst_S_OBI_right_switch_matrix.NN4BEG3 VPWR VGND sg13g2_mux2_1
XFILLER_7_808 VPWR VGND sg13g2_decap_8
XFILLER_2_513 VPWR VGND sg13g2_decap_8
XFILLER_2_1295 VPWR VGND sg13g2_decap_8
X_0790_ Tile_X0Y0_FrameData[1] Tile_X2Y0_FrameStrobe[0] Tile_X2Y0_S_OBI_right.Inst_S_OBI_right_ConfigMem.Inst_frame0_bit1.Q
+ VPWR VGND sg13g2_dlhq_1
XFILLER_6_874 VPWR VGND sg13g2_decap_8
XFILLER_3_42 VPWR VGND sg13g2_decap_8
XFILLER_3_1037 VPWR VGND sg13g2_fill_1
X_0988_ Tile_X1Y0_FrameStrobe[12] Tile_X1Y0_FrameStrobe_O[12] VPWR VGND sg13g2_buf_1
XFILLER_11_656 VPWR VGND sg13g2_fill_2
XFILLER_3_811 VPWR VGND sg13g2_decap_8
XFILLER_6_159 VPWR VGND sg13g2_fill_1
XFILLER_2_387 VPWR VGND sg13g2_decap_8
XFILLER_3_888 VPWR VGND sg13g2_decap_8
X_0842_ Tile_X0Y0_FrameData[19] Tile_X0Y0_FrameStrobe[0] Tile_X0Y0_S_OBI_left.Inst_S_OBI_left_ConfigMem.Inst_frame0_bit19.Q
+ VPWR VGND sg13g2_dlhq_1
X_0911_ Tile_X0Y0_FrameStrobe[8] Tile_X0Y0_FrameStrobe_O[8] VPWR VGND sg13g2_buf_1
X_0773_ Tile_X0Y0_FrameData[18] Tile_X2Y0_FrameStrobe[0] Tile_X2Y0_S_OBI_right.Inst_S_OBI_right_ConfigMem.Inst_frame0_bit18.Q
+ VPWR VGND sg13g2_dlhq_1
XFILLER_4_619 VPWR VGND sg13g2_fill_1
XFILLER_0_858 VPWR VGND sg13g2_decap_8
XFILLER_8_925 VPWR VGND sg13g2_decap_8
XFILLER_11_486 VPWR VGND sg13g2_decap_8
XFILLER_2_140 VPWR VGND sg13g2_decap_8
XFILLER_7_457 VPWR VGND sg13g2_decap_8
X_1110_ Tile_X2Y0_S_OBI_right.Inst_S_OBI_right_switch_matrix.N2BEG5 Tile_X2Y0_N2BEG[5]
+ VPWR VGND sg13g2_buf_1
X_1041_ Tile_X1Y0_S_OBI_middle.Inst_S_OBI_middle_switch_matrix.NN4BEG9 Tile_X1Y0_NN4BEG[9]
+ VPWR VGND sg13g2_buf_1
XFILLER_0_21 VPWR VGND sg13g2_decap_8
XFILLER_0_98 VPWR VGND sg13g2_decap_8
X_0825_ Tile_X0Y0_FrameData[30] Tile_X2Y0_FrameStrobe[2] Tile_X2Y0_S_OBI_right.Inst_S_OBI_right_ConfigMem.Inst_frame2_bit30.Q
+ VPWR VGND sg13g2_dlhq_1
X_0687_ Tile_X0Y0_FrameData[18] Tile_X1Y0_FrameStrobe[0] Tile_X1Y0_S_OBI_middle.Inst_S_OBI_middle_ConfigMem.Inst_frame0_bit18.Q
+ VPWR VGND sg13g2_dlhq_1
X_0756_ Tile_X0Y0_FrameData[13] Tile_X1Y0_FrameStrobe[2] Tile_X1Y0_S_OBI_middle.Inst_S_OBI_middle_ConfigMem.Inst_frame2_bit13.Q
+ VPWR VGND sg13g2_dlhq_1
XFILLER_4_405 VPWR VGND sg13g2_decap_8
XFILLER_5_906 VPWR VGND sg13g2_decap_8
XFILLER_0_655 VPWR VGND sg13g2_decap_8
XFILLER_8_799 VPWR VGND sg13g2_fill_2
XFILLER_7_232 VPWR VGND sg13g2_decap_4
X_0541_ Tile_X0Y0_S1END[2] WDATA_top8 Tile_X0Y0_S_OBI_left.Inst_S_OBI_left_ConfigMem.Inst_frame2_bit27.Q
+ Tile_X0Y0_S_OBI_left.Inst_S_OBI_left_switch_matrix.N1BEG1 VPWR VGND sg13g2_mux2_1
X_0472_ Tile_X2Y0_S2MID[2] Tile_X2Y0_S_OBI_right.Inst_S_OBI_right_ConfigMem.Inst_frame0_bit9.Q
+ Tile_X2Y0_S_OBI_right.Inst_S_OBI_right_ConfigMem.Inst_frame0_bit10.Q _0137_ VPWR
+ VGND sg13g2_nor3_1
XFILLER_3_471 VPWR VGND sg13g2_decap_8
XFILLER_4_972 VPWR VGND sg13g2_decap_8
X_0610_ _0220_ _0217_ _0224_ RDATA_top2 VPWR VGND sg13g2_a21o_1
X_1024_ Tile_X1Y0_S_OBI_middle.Inst_S_OBI_middle_switch_matrix.N4BEG8 Tile_X1Y0_N4BEG[8]
+ VPWR VGND sg13g2_buf_1
X_0808_ Tile_X0Y0_FrameData[15] Tile_X2Y0_FrameStrobe[1] Tile_X2Y0_S_OBI_right.Inst_S_OBI_right_ConfigMem.Inst_frame1_bit15.Q
+ VPWR VGND sg13g2_dlhq_1
X_0739_ Tile_X0Y0_FrameData[30] Tile_X1Y0_FrameStrobe[2] Tile_X1Y0_S_OBI_middle.Inst_S_OBI_middle_ConfigMem.Inst_frame2_bit30.Q
+ VPWR VGND sg13g2_dlhq_1
XFILLER_1_931 VPWR VGND sg13g2_decap_4
XFILLER_1_964 VPWR VGND sg13g2_decap_4
XFILLER_0_452 VPWR VGND sg13g2_decap_8
XFILLER_8_596 VPWR VGND sg13g2_decap_8
XFILLER_8_563 VPWR VGND sg13g2_decap_8
XANTENNA_2 VPWR VGND ADDR_top0 sg13g2_antennanp
XFILLER_6_42 VPWR VGND sg13g2_decap_8
X_0524_ Tile_X2Y0_S4END[8] Tile_X2Y0_S_OBI_right.Inst_S_OBI_right_ConfigMem.Inst_frame0_bit27.Q
+ _0183_ VPWR VGND sg13g2_nor2b_1
X_0455_ Tile_X2Y0_S2MID[0] Tile_X2Y0_S_OBI_right.Inst_S_OBI_right_ConfigMem.Inst_frame0_bit3.Q
+ Tile_X2Y0_S_OBI_right.Inst_S_OBI_right_ConfigMem.Inst_frame0_bit4.Q _0122_ VPWR
+ VGND sg13g2_nor3_1
X_1007_ Tile_X1Y0_S_OBI_middle.Inst_S_OBI_middle_switch_matrix.N2BEG7 Tile_X1Y0_N2BEG[7]
+ VPWR VGND sg13g2_buf_1
X_0386_ _0096_ Tile_X1Y0_S4END[11] Tile_X1Y0_S_OBI_middle.Inst_S_OBI_middle_ConfigMem.Inst_frame0_bit30.Q
+ VPWR VGND sg13g2_nand2b_1
XFILLER_2_717 VPWR VGND sg13g2_decap_8
XFILLER_9_338 VPWR VGND sg13g2_fill_1
XFILLER_7_1322 VPWR VGND sg13g2_decap_8
XFILLER_0_282 VPWR VGND sg13g2_decap_8
X_0438_ Tile_X2Y0_SS4END[13] ADDR_top17 Tile_X2Y0_S_OBI_right.Inst_S_OBI_right_ConfigMem.Inst_frame1_bit26.Q
+ Tile_X2Y0_S_OBI_right.Inst_S_OBI_right_switch_matrix.NN4BEG2 VPWR VGND sg13g2_mux2_1
X_0369_ _0083_ VPWR RDATA_top25 VGND Tile_X1Y0_S_OBI_middle.Inst_S_OBI_middle_ConfigMem.Inst_frame0_bit19.Q
+ _0084_ sg13g2_o21ai_1
X_0507_ VPWR VGND Tile_X2Y0_S_OBI_right.Inst_S_OBI_right_ConfigMem.Inst_frame0_bit22.Q
+ _0047_ _0167_ _0165_ _0168_ _0166_ sg13g2_a221oi_1
XFILLER_6_319 VPWR VGND sg13g2_fill_1
XFILLER_2_569 VPWR VGND sg13g2_decap_8
XFILLER_2_1274 VPWR VGND sg13g2_decap_8
XFILLER_10_871 VPWR VGND sg13g2_fill_1
XFILLER_5_341 VPWR VGND sg13g2_decap_8
XFILLER_6_842 VPWR VGND sg13g2_fill_1
XFILLER_1_580 VPWR VGND sg13g2_decap_4
XFILLER_3_21 VPWR VGND sg13g2_decap_8
XFILLER_3_98 VPWR VGND sg13g2_decap_8
X_0987_ Tile_X1Y0_FrameStrobe[11] Tile_X1Y0_FrameStrobe_O[11] VPWR VGND sg13g2_buf_1
XFILLER_10_101 VPWR VGND sg13g2_fill_1
XFILLER_2_366 VPWR VGND sg13g2_decap_8
XFILLER_3_867 VPWR VGND sg13g2_decap_8
X_0772_ Tile_X0Y0_FrameData[19] Tile_X2Y0_FrameStrobe[0] Tile_X2Y0_S_OBI_right.Inst_S_OBI_right_ConfigMem.Inst_frame0_bit19.Q
+ VPWR VGND sg13g2_dlhq_1
X_0910_ Tile_X0Y0_FrameStrobe[7] Tile_X0Y0_FrameStrobe_O[7] VPWR VGND sg13g2_buf_1
X_0841_ Tile_X0Y0_FrameData[20] Tile_X0Y0_FrameStrobe[0] Tile_X0Y0_S_OBI_left.Inst_S_OBI_left_ConfigMem.Inst_frame0_bit20.Q
+ VPWR VGND sg13g2_dlhq_1
XFILLER_6_661 VPWR VGND sg13g2_decap_8
XFILLER_10_1319 VPWR VGND sg13g2_fill_1
XFILLER_3_119 VPWR VGND sg13g2_decap_8
XFILLER_0_837 VPWR VGND sg13g2_decap_8
XFILLER_11_465 VPWR VGND sg13g2_decap_8
XFILLER_7_436 VPWR VGND sg13g2_decap_8
X_1040_ Tile_X1Y0_S_OBI_middle.Inst_S_OBI_middle_switch_matrix.NN4BEG8 Tile_X1Y0_NN4BEG[8]
+ VPWR VGND sg13g2_buf_1
XFILLER_9_42 VPWR VGND sg13g2_decap_4
XFILLER_0_1019 VPWR VGND sg13g2_decap_8
XFILLER_0_77 VPWR VGND sg13g2_decap_8
XFILLER_7_992 VPWR VGND sg13g2_fill_1
X_0755_ Tile_X0Y0_FrameData[14] Tile_X1Y0_FrameStrobe[2] Tile_X1Y0_S_OBI_middle.Inst_S_OBI_middle_ConfigMem.Inst_frame2_bit14.Q
+ VPWR VGND sg13g2_dlhq_1
X_0824_ Tile_X0Y0_FrameData[31] Tile_X2Y0_FrameStrobe[2] Tile_X2Y0_S_OBI_right.Inst_S_OBI_right_ConfigMem.Inst_frame2_bit31.Q
+ VPWR VGND sg13g2_dlhq_1
XFILLER_6_491 VPWR VGND sg13g2_decap_8
X_0686_ Tile_X0Y0_FrameData[19] Tile_X1Y0_FrameStrobe[0] Tile_X1Y0_S_OBI_middle.Inst_S_OBI_middle_ConfigMem.Inst_frame0_bit19.Q
+ VPWR VGND sg13g2_dlhq_1
XFILLER_0_634 VPWR VGND sg13g2_decap_8
XFILLER_7_211 VPWR VGND sg13g2_decap_4
XFILLER_7_288 VPWR VGND sg13g2_fill_2
X_0540_ Tile_X2Y0_S1END[3] WDATA_top19 Tile_X2Y0_S_OBI_right.Inst_S_OBI_right_ConfigMem.Inst_frame2_bit26.Q
+ Tile_X2Y0_S_OBI_right.Inst_S_OBI_right_switch_matrix.N1BEG0 VPWR VGND sg13g2_mux2_1
X_0471_ VPWR VGND Tile_X2Y0_S_OBI_right.Inst_S_OBI_right_ConfigMem.Inst_frame0_bit10.Q
+ _0039_ _0135_ _0133_ _0136_ _0134_ sg13g2_a221oi_1
XFILLER_3_450 VPWR VGND sg13g2_decap_8
XFILLER_4_951 VPWR VGND sg13g2_decap_8
X_1023_ Tile_X1Y0_S_OBI_middle.Inst_S_OBI_middle_switch_matrix.N4BEG7 Tile_X1Y0_N4BEG[7]
+ VPWR VGND sg13g2_buf_1
X_0738_ Tile_X0Y0_FrameData[31] Tile_X1Y0_FrameStrobe[2] Tile_X1Y0_S_OBI_middle.Inst_S_OBI_middle_ConfigMem.Inst_frame2_bit31.Q
+ VPWR VGND sg13g2_dlhq_1
X_0807_ Tile_X0Y0_FrameData[16] Tile_X2Y0_FrameStrobe[1] Tile_X2Y0_S_OBI_right.Inst_S_OBI_right_ConfigMem.Inst_frame1_bit16.Q
+ VPWR VGND sg13g2_dlhq_1
X_0669_ Tile_X0Y0_S_OBI_left.Inst_S_OBI_left_ConfigMem.Inst_frame0_bit31.Q VPWR _0023_
+ VGND _0051_ Tile_X0Y0_S_OBI_left.Inst_S_OBI_left_ConfigMem.Inst_frame0_bit30.Q sg13g2_o21ai_1
XFILLER_5_726 VPWR VGND sg13g2_fill_1
XFILLER_0_431 VPWR VGND sg13g2_decap_8
XFILLER_1_1103 VPWR VGND sg13g2_decap_4
XFILLER_5_1283 VPWR VGND sg13g2_decap_8
XANTENNA_3 VPWR VGND ADDR_top23 sg13g2_antennanp
XFILLER_6_21 VPWR VGND sg13g2_decap_8
X_0523_ Tile_X2Y0_S1END[0] Tile_X2Y0_S_OBI_right.Inst_S_OBI_right_ConfigMem.Inst_frame0_bit27.Q
+ Tile_X2Y0_S_OBI_right.Inst_S_OBI_right_ConfigMem.Inst_frame0_bit28.Q _0182_ VPWR
+ VGND sg13g2_nor3_1
X_0385_ Tile_X1Y0_S_OBI_middle.Inst_S_OBI_middle_ConfigMem.Inst_frame0_bit30.Q VPWR
+ _0095_ VGND Tile_X1Y0_SS4END[11] Tile_X1Y0_S_OBI_middle.Inst_S_OBI_middle_ConfigMem.Inst_frame0_bit31.Q
+ sg13g2_o21ai_1
XFILLER_4_792 VPWR VGND sg13g2_decap_8
X_0454_ Tile_X2Y0_S_OBI_right.Inst_S_OBI_right_ConfigMem.Inst_frame0_bit4.Q VPWR _0121_
+ VGND Tile_X2Y0_S_OBI_right.Inst_S_OBI_right_ConfigMem.Inst_frame0_bit3.Q _0036_
+ sg13g2_o21ai_1
X_1006_ Tile_X1Y0_S_OBI_middle.Inst_S_OBI_middle_switch_matrix.N2BEG6 Tile_X1Y0_N2BEG[6]
+ VPWR VGND sg13g2_buf_1
XFILLER_11_1211 VPWR VGND sg13g2_fill_1
XFILLER_5_512 VPWR VGND sg13g2_decap_8
XFILLER_5_567 VPWR VGND sg13g2_decap_8
XFILLER_0_261 VPWR VGND sg13g2_decap_8
XFILLER_3_1209 VPWR VGND sg13g2_decap_8
XFILLER_5_1091 VPWR VGND sg13g2_decap_4
XFILLER_8_383 VPWR VGND sg13g2_decap_4
X_0506_ Tile_X2Y0_SS4END[12] Tile_X2Y0_S_OBI_right.Inst_S_OBI_right_ConfigMem.Inst_frame0_bit21.Q
+ _0167_ VPWR VGND sg13g2_nor2_1
X_0437_ Tile_X2Y0_SS4END[14] ADDR_top18 Tile_X2Y0_S_OBI_right.Inst_S_OBI_right_ConfigMem.Inst_frame1_bit25.Q
+ Tile_X2Y0_S_OBI_right.Inst_S_OBI_right_switch_matrix.NN4BEG1 VPWR VGND sg13g2_mux2_1
X_0368_ _0084_ Tile_X1Y0_S4END[5] Tile_X1Y0_S_OBI_middle.Inst_S_OBI_middle_ConfigMem.Inst_frame0_bit18.Q
+ VPWR VGND sg13g2_nand2b_1
X_0299_ Tile_X1Y0_S_OBI_middle.Inst_S_OBI_middle_ConfigMem.Inst_frame2_bit12.Q Tile_X1Y0_S1END[2]
+ REQ_top WE_top BE_top2 Tile_X1Y0_S_OBI_middle.Inst_S_OBI_middle_ConfigMem.Inst_frame2_bit13.Q
+ Tile_X1Y0_S_OBI_middle.Inst_S_OBI_middle_switch_matrix.N1BEG1 VPWR VGND sg13g2_mux4_1
XFILLER_2_548 VPWR VGND sg13g2_decap_8
XFILLER_2_1253 VPWR VGND sg13g2_decap_8
XFILLER_6_821 VPWR VGND sg13g2_fill_2
XFILLER_10_894 VPWR VGND sg13g2_fill_2
XFILLER_5_386 VPWR VGND sg13g2_decap_8
XFILLER_3_77 VPWR VGND sg13g2_decap_8
X_0986_ Tile_X1Y0_FrameStrobe[10] Tile_X1Y0_FrameStrobe_O[10] VPWR VGND sg13g2_buf_1
XFILLER_2_301 VPWR VGND sg13g2_decap_8
XFILLER_2_312 VPWR VGND sg13g2_fill_1
XFILLER_2_345 VPWR VGND sg13g2_decap_8
XFILLER_3_846 VPWR VGND sg13g2_decap_8
XFILLER_2_1094 VPWR VGND sg13g2_fill_2
X_0840_ Tile_X0Y0_FrameData[21] Tile_X0Y0_FrameStrobe[0] Tile_X0Y0_S_OBI_left.Inst_S_OBI_left_ConfigMem.Inst_frame0_bit21.Q
+ VPWR VGND sg13g2_dlhq_1
X_0771_ Tile_X0Y0_FrameData[20] Tile_X2Y0_FrameStrobe[0] Tile_X2Y0_S_OBI_right.Inst_S_OBI_right_ConfigMem.Inst_frame0_bit20.Q
+ VPWR VGND sg13g2_dlhq_1
XFILLER_5_194 VPWR VGND sg13g2_fill_1
X_0969_ Tile_X0Y0_SS4END[5] Tile_X0Y0_NN4BEG[10] VPWR VGND sg13g2_buf_1
XFILLER_0_816 VPWR VGND sg13g2_decap_8
XFILLER_11_444 VPWR VGND sg13g2_decap_8
XFILLER_7_415 VPWR VGND sg13g2_decap_8
XFILLER_2_197 VPWR VGND sg13g2_decap_8
XFILLER_3_0 VPWR VGND sg13g2_decap_8
XFILLER_0_56 VPWR VGND sg13g2_decap_8
XFILLER_9_21 VPWR VGND sg13g2_decap_8
X_0823_ Tile_X0Y0_FrameData[0] Tile_X2Y0_FrameStrobe[1] Tile_X2Y0_S_OBI_right.Inst_S_OBI_right_ConfigMem.Inst_frame1_bit0.Q
+ VPWR VGND sg13g2_dlhq_1
XFILLER_7_971 VPWR VGND sg13g2_decap_8
X_0754_ Tile_X0Y0_FrameData[15] Tile_X1Y0_FrameStrobe[2] Tile_X1Y0_S_OBI_middle.Inst_S_OBI_middle_ConfigMem.Inst_frame2_bit15.Q
+ VPWR VGND sg13g2_dlhq_1
X_0685_ Tile_X0Y0_FrameData[20] Tile_X1Y0_FrameStrobe[0] Tile_X1Y0_S_OBI_middle.Inst_S_OBI_middle_ConfigMem.Inst_frame0_bit20.Q
+ VPWR VGND sg13g2_dlhq_1
XFILLER_6_470 VPWR VGND sg13g2_decap_8
XFILLER_9_1034 VPWR VGND sg13g2_fill_2
X_1099_ Tile_X2Y0_FrameStrobe[18] Tile_X2Y0_FrameStrobe_O[18] VPWR VGND sg13g2_buf_1
XFILLER_0_613 VPWR VGND sg13g2_decap_8
XFILLER_4_930 VPWR VGND sg13g2_decap_8
X_0470_ Tile_X2Y0_SS4END[8] Tile_X2Y0_S_OBI_right.Inst_S_OBI_right_ConfigMem.Inst_frame0_bit9.Q
+ _0135_ VPWR VGND sg13g2_nor2_1
X_1022_ Tile_X1Y0_S_OBI_middle.Inst_S_OBI_middle_switch_matrix.N4BEG6 Tile_X1Y0_N4BEG[6]
+ VPWR VGND sg13g2_buf_1
X_0737_ Tile_X0Y0_FrameData[0] Tile_X1Y0_FrameStrobe[1] Tile_X1Y0_S_OBI_middle.Inst_S_OBI_middle_ConfigMem.Inst_frame1_bit0.Q
+ VPWR VGND sg13g2_dlhq_1
X_0668_ VPWR VGND Tile_X0Y0_S_OBI_left.Inst_S_OBI_left_ConfigMem.Inst_frame0_bit31.Q
+ _0070_ _0021_ _0019_ _0022_ _0020_ sg13g2_a221oi_1
X_0806_ Tile_X0Y0_FrameData[17] Tile_X2Y0_FrameStrobe[1] Tile_X2Y0_S_OBI_right.Inst_S_OBI_right_ConfigMem.Inst_frame1_bit17.Q
+ VPWR VGND sg13g2_dlhq_1
X_0599_ Tile_X0Y0_S4END[1] Tile_X0Y0_S_OBI_left.Inst_S_OBI_left_ConfigMem.Inst_frame0_bit6.Q
+ _0215_ VPWR VGND sg13g2_nor2b_1
XFILLER_1_999 VPWR VGND sg13g2_fill_2
XFILLER_1_988 VPWR VGND sg13g2_decap_8
XFILLER_1_900 VPWR VGND sg13g2_decap_4
XFILLER_0_487 VPWR VGND sg13g2_decap_8
XFILLER_0_410 VPWR VGND sg13g2_decap_8
XFILLER_1_1159 VPWR VGND sg13g2_decap_8
XFILLER_5_1262 VPWR VGND sg13g2_decap_8
XFILLER_8_510 VPWR VGND sg13g2_fill_1
X_0522_ Tile_X2Y0_S_OBI_right.Inst_S_OBI_right_ConfigMem.Inst_frame0_bit28.Q VPWR
+ _0181_ VGND _0032_ Tile_X2Y0_S_OBI_right.Inst_S_OBI_right_ConfigMem.Inst_frame0_bit27.Q
+ sg13g2_o21ai_1
XANTENNA_4 VPWR VGND ADDR_top23 sg13g2_antennanp
XFILLER_6_77 VPWR VGND sg13g2_decap_8
X_0384_ _0093_ VPWR RDATA_top30 VGND Tile_X1Y0_S_OBI_middle.Inst_S_OBI_middle_ConfigMem.Inst_frame0_bit29.Q
+ _0094_ sg13g2_o21ai_1
X_0453_ VPWR VGND Tile_X2Y0_S_OBI_right.Inst_S_OBI_right_ConfigMem.Inst_frame0_bit4.Q
+ _0035_ _0119_ _0117_ _0120_ _0118_ sg13g2_a221oi_1
XFILLER_6_1059 VPWR VGND sg13g2_fill_2
X_1005_ Tile_X1Y0_S_OBI_middle.Inst_S_OBI_middle_switch_matrix.N2BEG5 Tile_X1Y0_N2BEG[5]
+ VPWR VGND sg13g2_buf_1
XFILLER_11_1289 VPWR VGND sg13g2_decap_8
XFILLER_1_796 VPWR VGND sg13g2_decap_8
XFILLER_1_741 VPWR VGND sg13g2_decap_4
XFILLER_0_240 VPWR VGND sg13g2_decap_8
X_0436_ Tile_X2Y0_SS4END[15] ADDR_top19 Tile_X2Y0_S_OBI_right.Inst_S_OBI_right_ConfigMem.Inst_frame1_bit24.Q
+ Tile_X2Y0_S_OBI_right.Inst_S_OBI_right_switch_matrix.NN4BEG0 VPWR VGND sg13g2_mux2_1
X_0505_ VGND VPWR Tile_X2Y0_S4END[12] Tile_X2Y0_S_OBI_right.Inst_S_OBI_right_ConfigMem.Inst_frame0_bit21.Q
+ _0166_ Tile_X2Y0_S_OBI_right.Inst_S_OBI_right_ConfigMem.Inst_frame0_bit22.Q sg13g2_a21oi_1
.ends
